* +++++++++++++++++++++++++++++++++++++++++++++++++++++
* CDL Netlist:
*
* Cell Name: sram_cell_default
* Netlisted: 2026-11-07 02:35:56
* Pegasus 25.14-s010
* +++++++++++++++++++++++++++++++++++++++++++++++++++++
*.LDD

* +++++++++++++++++++++++++++++++++++++++++++++++++++++
* Sub cell: sram_cell_default
* +++++++++++++++++++++++++++++++++++++++++++++++++++++
.subckt sram_cell_default GND Vdd WL Q Q_bar BL_bar BL
M6 BL_bar WL Q_bar GND g45n1svt L=4.5e-08 W=1.2e-07 AD=1.68e-14 AS=1.68e-14 PD=5.2e-07 PS=5.2e-07 fw=1.2e-07 sa=1.4e-07 sb=1.4e-07 sca=7.47782 scb=0.00487805 scc=6.4515e-05 $X=430 $Y=1460
M7 GND Q Q_bar GND g45n1svt L=4.5e-08 W=1.2e-07 AD=1.68e-14 AS=1.68e-14 PD=5.2e-07 PS=5.2e-07 fw=1.2e-07 sa=1.4e-07 sb=1.4e-07 sca=4.77669 scb=0.000688053 scc=5.40588e-07 $X=1600 $Y=920
M8 GND Q_bar Q GND g45n1svt L=4.5e-08 W=1.2e-07 AD=1.68e-14 AS=1.68e-14 PD=5.2e-07 PS=5.2e-07 fw=1.2e-07 sa=1.4e-07 sb=1.4e-07 sca=4.77669 scb=0.000688053 scc=5.40588e-07 $X=2630 $Y=920
M9 Q WL BL GND g45n1svt L=4.5e-08 W=1.2e-07 AD=1.68e-14 AS=1.68e-14 PD=5.2e-07 PS=5.2e-07 fw=1.2e-07 sa=1.4e-07 sb=1.4e-07 sca=3.69959 scb=0.00013007 scc=4.39142e-09 $X=3720 $Y=2130
M10 Vdd Q Q_bar Vdd g45p1svt L=4.5e-08 W=1.2e-07 AD=1.68e-14 AS=1.68e-14 PD=5.2e-07 PS=5.2e-07 fw=1.2e-07 sa=1.4e-07 sb=1.4e-07 sca=57.0437 scb=0.0528056 scc=0.00752443 $X=1600 $Y=2710
M11 Q Q_bar Vdd Vdd g45p1svt L=4.5e-08 W=1.2e-07 AD=1.68e-14 AS=1.68e-14 PD=5.2e-07 PS=5.2e-07 fw=1.2e-07 sa=1.4e-07 sb=1.4e-07 sca=73.81 scb=0.0749781 scc=0.0101674 $X=2630 $Y=2710
** N=7 EP=7 NDC=6 FDC=6 HDC=6
.ends sram_cell_default
