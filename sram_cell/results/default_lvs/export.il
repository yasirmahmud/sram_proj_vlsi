c=dbOpenCellViewByType("sram_cell" "sram_cell_default" "schematic" "" "r")
f=outfile("netlists/sram_cell_default.cdl")
fprintf(f "* Exported from native OA schematic sram_cell/sram_cell/schematic\n.SUBCKT sram_cell_default BL BL_bar WL Q Q_bar Vdd GND\n")
foreach(i c~>instances when(member(i~>cellName '("nmos1v" "pmos1v"))
 fprintf(f "M%s" i~>name)
 foreach(tn '("D" "G" "S" "B") it=car(setof(x i~>instTerms x~>name==tn)) fprintf(f " %s" it~>net~>name))
 fprintf(f " %s W=%s L=%s\n" if(i~>cellName=="nmos1v" then "g45n1svt" else "g45p1svt") cdfGetInstCDF(i)~>w~>value cdfGetInstCDF(i)~>l~>value)
))
fprintf(f ".ENDS sram_cell_default\n") close(f)
exit()
