** Layout Netlist, pegasus precompare
**

.subckt sram_cell_default GND Vdd WL Q Q_bar BL_bar BL
MM6 BL_bar WL Q_bar GND G45N1SVT L=4.5e-08 W=1.2e-07 AD=1.68e-14 AS=1.68e-14 PD=5.2e-07 PS=5.2e-07 m=1
MM7 GND Q Q_bar GND G45N1SVT L=4.5e-08 W=1.2e-07 AD=1.68e-14 AS=1.68e-14 PD=5.2e-07 PS=5.2e-07 m=1
MM8 GND Q_bar Q GND G45N1SVT L=4.5e-08 W=1.2e-07 AD=1.68e-14 AS=1.68e-14 PD=5.2e-07 PS=5.2e-07 m=1
MM9 Q WL BL GND G45N1SVT L=4.5e-08 W=1.2e-07 AD=1.68e-14 AS=1.68e-14 PD=5.2e-07 PS=5.2e-07 m=1
MM10 Vdd Q Q_bar Vdd G45P1SVT L=4.5e-08 W=1.2e-07 AD=1.68e-14 AS=1.68e-14 PD=5.2e-07 PS=5.2e-07 m=1
MM11 Q Q_bar Vdd Vdd G45P1SVT L=4.5e-08 W=1.2e-07 AD=1.68e-14 AS=1.68e-14 PD=5.2e-07 PS=5.2e-07 m=1
.ends
