simulator lang=spectre
include "/ecel/UFAD/ymahmud/vlsi_sram_project/Project files/gpdk045_mos.scs" section=ss
parameters vdd=1.1 voffset=0
simOptions options reltol=1e-5 vabstol=1e-7 iabstol=1e-14 temp=125 gmin=1e-14
Vdd (Vdd 0) vsource dc=vdd
subckt sram_cell (BL BL_bar WL Q Q_bar Vdd GND)
PM0 (Q_bar Q Vdd Vdd) g45p1svt w=(120n) l=45n nf=ceil(((120n) - 5p) / (10u))           as=(((120n) / (ceil(((120n) - 5p) / (10u)))) < 119.5n) ? ((((50n > (((60n) - 0) + 60n) ? 50n : (((60n) - 0) + 60n)) * 120n) + (((120n) / (ceil(((120n) - 5p) / (10u)))) * 50n)) + (floor(((ceil(((120n) - 5p) / (10u))) - 1) / 2.0) * (((((60n) - 0) + 60n) * 120n) + (((120n) / (ceil(((120n) - 5p) / (10u)))) * 100n))) + ((((ceil(((120n) - 5p) / (10u))) / 2) - floor((ceil(((120n) - 5p) / (10u))) / 2) == 0) ? (((50n > (((60n) - 0) + 60n) ? 50n : (((60n) - 0) + 60n)) * 120n) + (((120n) / (ceil(((120n) - 5p) / (10u)))) * 50n)) : 0)) / 1 : (((100n > (((60n) - 0) + 80n) ? 100n : (((60n) - 0) + 80n)) * ((120n) / (ceil(((120n) - 5p) / (10u))))) + (floor(((ceil(((120n) - 5p) / (10u))) - 1) / 2.0) * ((60n > (((60n) - 0) + 50n) ? 60n : (((60n) - 0) + 50n)) * ((120n) / (ceil(((120n) - 5p) / (10u)))))) + ((((ceil(((120n) - 5p) / (10u))) / 2) - floor((ceil(((120n) - 5p) / (10u))) / 2) == 0) ? ((100n > (((60n) - 0) + 80n) ? 100n : (((60n) - 0) + 80n)) * ((120n) / (ceil(((120n) - 5p) / (10u))))) : 0)) / 1           ad=(((120n) / (ceil(((120n) - 5p) / (10u)))) < 119.5n) ? ((floor((ceil(((120n) - 5p) / (10u))) / 2.0) * (((((60n) - 0) + 60n) * 120n) + (((120n) / (ceil(((120n) - 5p) / (10u)))) * 100n))) + ((((ceil(((120n) - 5p) / (10u))) / 2) - floor((ceil(((120n) - 5p) / (10u))) / 2) != 0) ? (((50n > (((60n) - 0) + 60n) ? 50n : (((60n) - 0) + 60n)) * 120n) + (((120n) / (ceil(((120n) - 5p) / (10u)))) * 50n)) : 0)) / 1 : ((floor((ceil(((120n) - 5p) / (10u))) / 2.0) * ((60n > (((60n) - 0) + 50n) ? 60n : (((60n) - 0) + 50n)) * ((120n) / (ceil(((120n) - 5p) / (10u)))))) + ((((ceil(((120n) - 5p) / (10u))) / 2) - floor((ceil(((120n) - 5p) / (10u))) / 2) != 0) ? ((100n > (((60n) - 0) + 80n) ? 100n : (((60n) - 0) + 80n)) * ((120n) / (ceil(((120n) - 5p) / (10u))))) : 0)) / 1           ps=(((120n) / (ceil(((120n) - 5p) / (10u)))) < 119.5n) ? (((2 * (50n > (((60n) - 0) + 60n) ? 50n : (((60n) - 0) + 60n))) + 340n) + (floor(((ceil(((120n) - 5p) / (10u))) - 1) / 2.0) * ((2 * (((60n) - 0) + 60n)) + 440n)) + ((((ceil(((120n) - 5p) / (10u))) / 2) - floor((ceil(((120n) - 5p) / (10u))) / 2) == 0) ? ((2 * (50n > (((60n) - 0) + 60n) ? 50n : (((60n) - 0) + 60n))) + 340n) : 0)) / 1 : (((2 * (100n > (((60n) - 0) + 80n) ? 100n : (((60n) - 0) + 80n))) + (2 * ((120n) / (ceil(((120n) - 5p) / (10u)))))) + (floor(((ceil(((120n) - 5p) / (10u))) - 1) / 2.0) * ((2 * (60n > (((60n) - 0) + 50n) ? 60n : (((60n) - 0) + 50n))) + (2 * ((120n) / (ceil(((120n) - 5p) / (10u))))))) + ((((ceil(((120n) - 5p) / (10u))) / 2) - floor((ceil(((120n) - 5p) / (10u))) / 2) == 0) ? ((2 * (100n > (((60n) - 0) + 80n) ? 100n : (((60n) - 0) + 80n))) + (2 * ((120n) / (ceil(((120n) - 5p) / (10u)))))) : 0)) / 1           pd=(((120n) / (ceil(((120n) - 5p) / (10u)))) < 119.5n) ? ((floor((ceil(((120n) - 5p) / (10u))) / 2.0) * ((2 * (((60n) - 0) + 60n)) + 440n)) + ((((ceil(((120n) - 5p) / (10u))) / 2) - floor((ceil(((120n) - 5p) / (10u))) / 2) != 0) ? ((2 * (50n > (((60n) - 0) + 60n) ? 50n : (((60n) - 0) + 60n))) + 340n) : 0)) / 1 : ((floor((ceil(((120n) - 5p) / (10u))) / 2.0) * ((2 * (60n > (((60n) - 0) + 50n) ? 60n : (((60n) - 0) + 50n))) + (2 * ((120n) / (ceil(((120n) - 5p) / (10u))))))) + ((((ceil(((120n) - 5p) / (10u))) / 2) - floor((ceil(((120n) - 5p) / (10u))) / 2) != 0) ? ((2 * (100n > (((60n) - 0) + 80n) ? 100n : (((60n) - 0) + 80n))) + (2 * ((120n) / (ceil(((120n) - 5p) / (10u)))))) : 0)) / 1           nrd=(((120n) / (ceil(((120n) - 5p) / (10u)))) < 119.5n) ? ((floor((ceil(((120n) - 5p) / (10u))) / 2.0) * (((((60n) - 0) + 60n) * 120n) + (((120n) / (ceil(((120n) - 5p) / (10u)))) * 100n))) + ((((ceil(((120n) - 5p) / (10u))) / 2) - floor((ceil(((120n) - 5p) / (10u))) / 2) != 0) ? (((50n > (((60n) - 0) + 60n) ? 50n : (((60n) - 0) + 60n)) * 120n) + (((120n) / (ceil(((120n) - 5p) / (10u)))) * 50n)) : 0)) / 1 : ((floor((ceil(((120n) - 5p) / (10u))) / 2.0) * ((60n > (((60n) - 0) + 50n) ? 60n : (((60n) - 0) + 50n)) * ((120n) / (ceil(((120n) - 5p) / (10u)))))) + ((((ceil(((120n) - 5p) / (10u))) / 2) - floor((ceil(((120n) - 5p) / (10u))) / 2) != 0) ? ((100n > (((60n) - 0) + 80n) ? 100n : (((60n) - 0) + 80n)) * ((120n) / (ceil(((120n) - 5p) / (10u))))) : 0)) / 1 / (((120n) / (ceil(((120n) - 5p) / (10u)))) * (ceil(((120n) - 5p) / (10u))) * ((120n) / (ceil(((120n) - 5p) / (10u)))) * (ceil(((120n) - 5p) / (10u))))           nrs=(((120n) / (ceil(((120n) - 5p) / (10u)))) < 119.5n) ? ((((50n > (((60n) - 0) + 60n) ? 50n : (((60n) - 0) + 60n)) * 120n) + (((120n) / (ceil(((120n) - 5p) / (10u)))) * 50n)) + (floor(((ceil(((120n) - 5p) / (10u))) - 1) / 2.0) * (((((60n) - 0) + 60n) * 120n) + (((120n) / (ceil(((120n) - 5p) / (10u)))) * 100n))) + ((((ceil(((120n) - 5p) / (10u))) / 2) - floor((ceil(((120n) - 5p) / (10u))) / 2) == 0) ? (((50n > (((60n) - 0) + 60n) ? 50n : (((60n) - 0) + 60n)) * 120n) + (((120n) / (ceil(((120n) - 5p) / (10u)))) * 50n)) : 0)) / 1 : (((100n > (((60n) - 0) + 80n) ? 100n : (((60n) - 0) + 80n)) * ((120n) / (ceil(((120n) - 5p) / (10u))))) + (floor(((ceil(((120n) - 5p) / (10u))) - 1) / 2.0) * ((60n > (((60n) - 0) + 50n) ? 60n : (((60n) - 0) + 50n)) * ((120n) / (ceil(((120n) - 5p) / (10u)))))) + ((((ceil(((120n) - 5p) / (10u))) / 2) - floor((ceil(((120n) - 5p) / (10u))) / 2) == 0) ? ((100n > (((60n) - 0) + 80n) ? 100n : (((60n) - 0) + 80n)) * ((120n) / (ceil(((120n) - 5p) / (10u))))) : 0)) / 1 / (((120n) / (ceil(((120n) - 5p) / (10u)))) * (ceil(((120n) - 5p) / (10u))) * ((120n) / (ceil(((120n) - 5p) / (10u)))) * (ceil(((120n) - 5p) / (10u))))           sa=(((120n) / (ceil(((120n) - 5p) / (10u)))) < 119.5n) ? (50n > (((60n) - 0) + 60n) ? 50n : (((60n) - 0) + 60n)) + 5e-08 : (100n > (((60n) - 0) + 80n) ? 100n : (((60n) - 0) + 80n))           sb=(((120n) / (ceil(((120n) - 5p) / (10u)))) < 119.5n) ? (50n > (((60n) - 0) + 60n) ? 50n : (((60n) - 0) + 60n)) + 5e-08 : (100n > (((60n) - 0) + 80n) ? 100n : (((60n) - 0) + 80n))           sd=(((120n) / (ceil(((120n) - 5p) / (10u)))) < 119.5n) ? (((60n) - 0) + 60n) + (2*5e-08) : (60n > (((60n) - 0) + 50n) ? 60n : (((60n) - 0) + 50n))           sca=(( ((120n) / (ceil(((120n) - 5p) / (10u)))) * ( (((1u) * (1u) / ((((120n) / (ceil(((120n) - 5p) / (10u)))) < 119.5n) ? (50n > (((60n) - 0) + 60n) ? 50n : (((60n) - 0) + 60n)) + 5e-08 : (100n > (((60n) - 0) + 80n) ? 100n : (((60n) - 0) + 80n))+60n)) - ((1u) * (1u) / (((((120n) / (ceil(((120n) - 5p) / (10u)))) < 119.5n) ? (50n > (((60n) - 0) + 60n) ? 50n : (((60n) - 0) + 60n)) + 5e-08 : (100n > (((60n) - 0) + 80n) ? 100n : (((60n) - 0) + 80n))+60n)+(45n)))) + ((1u) * (1u) / ((((120n) / (ceil(((120n) - 5p) / (10u)))) < 119.5n) ? (50n > (((60n) - 0) + 60n) ? 50n : (((60n) - 0) + 60n)) + 5e-08 : (100n > (((60n) - 0) + 80n) ? 100n : (((60n) - 0) + 80n))+60n)) - ((1u) * (1u)/ (((((120n) / (ceil(((120n) - 5p) / (10u)))) < 119.5n) ? (50n > (((60n) - 0) + 60n) ? 50n : (((60n) - 0) + 60n)) + 5e-08 : (100n > (((60n) - 0) + 80n) ? 100n : (((60n) - 0) + 80n))+60n)+(45n))))) + ( (45n) * ( (((1u) * (1u) / (60n)) - ((1u) * (1u) / ((60n)+((120n) / (ceil(((120n) - 5p) / (10u))))))) + ((1u) * (1u) / (60n)) - ((1u) * (1u)/ ((60n)+((120n) / (ceil(((120n) - 5p) / (10u))))))))) / (((120n) / (ceil(((120n) - 5p) / (10u)))) * (45n))           scb=((((120n) / (ceil(((120n) - 5p) / (10u)))) * ((((((120n) / (ceil(((120n) - 5p) / (10u)))) < 119.5n) ? (50n > (((60n) - 0) + 60n) ? 50n : (((60n) - 0) + 60n)) + 5e-08 : (100n > (((60n) - 0) + 80n) ? 100n : (((60n) - 0) + 80n))+60n)/10 + (1u)/100)*exp(-10 * ((((120n) / (ceil(((120n) - 5p) / (10u)))) < 119.5n) ? (50n > (((60n) - 0) + 60n) ? 50n : (((60n) - 0) + 60n)) + 5e-08 : (100n > (((60n) - 0) + 80n) ? 100n : (((60n) - 0) + 80n))+60n) / (1u)) - ((((((120n) / (ceil(((120n) - 5p) / (10u)))) < 119.5n) ? (50n > (((60n) - 0) + 60n) ? 50n : (((60n) - 0) + 60n)) + 5e-08 : (100n > (((60n) - 0) + 80n) ? 100n : (((60n) - 0) + 80n))+60n)+(45n))/10 + (1u)/100)*exp(-10 * (((((120n) / (ceil(((120n) - 5p) / (10u)))) < 119.5n) ? (50n > (((60n) - 0) + 60n) ? 50n : (((60n) - 0) + 60n)) + 5e-08 : (100n > (((60n) - 0) + 80n) ? 100n : (((60n) - 0) + 80n))+60n)+(45n)) / (1u)) + (((((120n) / (ceil(((120n) - 5p) / (10u)))) < 119.5n) ? (50n > (((60n) - 0) + 60n) ? 50n : (((60n) - 0) + 60n)) + 5e-08 : (100n > (((60n) - 0) + 80n) ? 100n : (((60n) - 0) + 80n))+60n)/10 + (1u)/100)*exp(-10 * ((((120n) / (ceil(((120n) - 5p) / (10u)))) < 119.5n) ? (50n > (((60n) - 0) + 60n) ? 50n : (((60n) - 0) + 60n)) + 5e-08 : (100n > (((60n) - 0) + 80n) ? 100n : (((60n) - 0) + 80n))+60n) / (1u)) - ((((((120n) / (ceil(((120n) - 5p) / (10u)))) < 119.5n) ? (50n > (((60n) - 0) + 60n) ? 50n : (((60n) - 0) + 60n)) + 5e-08 : (100n > (((60n) - 0) + 80n) ? 100n : (((60n) - 0) + 80n))+60n)+(45n))/10 + (1u)/100)*exp(-10 * (((((120n) / (ceil(((120n) - 5p) / (10u)))) < 119.5n) ? (50n > (((60n) - 0) + 60n) ? 50n : (((60n) - 0) + 60n)) + 5e-08 : (100n > (((60n) - 0) + 80n) ? 100n : (((60n) - 0) + 80n))+60n)+(45n)) / (1u)))) + ((45n) * (((60n)/10 + (1u)/100)*exp(-10 * (60n) / (1u)) - (((60n)+((120n) / (ceil(((120n) - 5p) / (10u)))))/10 + (1u)/100)*exp(-10 * ((60n)+((120n) / (ceil(((120n) - 5p) / (10u))))) / (1u)) + ((60n)/10 + (1u)/100)*exp(-10 * (60n) / (1u)) - (((60n)+((120n) / (ceil(((120n) - 5p) / (10u)))))/10 + (1u)/100)*exp(-10 * ((60n)+((120n) / (ceil(((120n) - 5p) / (10u))))) / (1u))))) / (((120n) / (ceil(((120n) - 5p) / (10u)))) * (45n))           scc=((((120n) / (ceil(((120n) - 5p) / (10u)))) * ((((((120n) / (ceil(((120n) - 5p) / (10u)))) < 119.5n) ? (50n > (((60n) - 0) + 60n) ? 50n : (((60n) - 0) + 60n)) + 5e-08 : (100n > (((60n) - 0) + 80n) ? 100n : (((60n) - 0) + 80n))+60n)/20 + (1u)/400)*exp(-20 * ((((120n) / (ceil(((120n) - 5p) / (10u)))) < 119.5n) ? (50n > (((60n) - 0) + 60n) ? 50n : (((60n) - 0) + 60n)) + 5e-08 : (100n > (((60n) - 0) + 80n) ? 100n : (((60n) - 0) + 80n))+60n) / (1u)) - ((((((120n) / (ceil(((120n) - 5p) / (10u)))) < 119.5n) ? (50n > (((60n) - 0) + 60n) ? 50n : (((60n) - 0) + 60n)) + 5e-08 : (100n > (((60n) - 0) + 80n) ? 100n : (((60n) - 0) + 80n))+60n)+(45n))/20 + (1u)/400)*exp(-20 * (((((120n) / (ceil(((120n) - 5p) / (10u)))) < 119.5n) ? (50n > (((60n) - 0) + 60n) ? 50n : (((60n) - 0) + 60n)) + 5e-08 : (100n > (((60n) - 0) + 80n) ? 100n : (((60n) - 0) + 80n))+60n)+(45n)) / (1u)) + (((((120n) / (ceil(((120n) - 5p) / (10u)))) < 119.5n) ? (50n > (((60n) - 0) + 60n) ? 50n : (((60n) - 0) + 60n)) + 5e-08 : (100n > (((60n) - 0) + 80n) ? 100n : (((60n) - 0) + 80n))+60n)/20 + (1u)/400)*exp(-20 * ((((120n) / (ceil(((120n) - 5p) / (10u)))) < 119.5n) ? (50n > (((60n) - 0) + 60n) ? 50n : (((60n) - 0) + 60n)) + 5e-08 : (100n > (((60n) - 0) + 80n) ? 100n : (((60n) - 0) + 80n))+60n) / (1u)) - ((((((120n) / (ceil(((120n) - 5p) / (10u)))) < 119.5n) ? (50n > (((60n) - 0) + 60n) ? 50n : (((60n) - 0) + 60n)) + 5e-08 : (100n > (((60n) - 0) + 80n) ? 100n : (((60n) - 0) + 80n))+60n)+(45n))/20 + (1u)/400)*exp(-20 * (((((120n) / (ceil(((120n) - 5p) / (10u)))) < 119.5n) ? (50n > (((60n) - 0) + 60n) ? 50n : (((60n) - 0) + 60n)) + 5e-08 : (100n > (((60n) - 0) + 80n) ? 100n : (((60n) - 0) + 80n))+60n)+(45n)) / (1u)))) + ((45n) * (((60n)/20 + (1u)/400)*exp(-20 * (60n) / (1u)) - (((60n)+((120n) / (ceil(((120n) - 5p) / (10u)))))/20 + (1u)/400)*exp(-20 * ((60n)+((120n) / (ceil(((120n) - 5p) / (10u))))) / (1u)) + ((60n)/20 + (1u)/400)*exp(-20 * (60n) / (1u)) - (((60n)+((120n) / (ceil(((120n) - 5p) / (10u)))))/20 + (1u)/400)*exp(-20 * ((60n)+((120n) / (ceil(((120n) - 5p) / (10u))))) / (1u))))) / (((120n) / (ceil(((120n) - 5p) / (10u)))) * (45n))           m=(1)
PM1 (Q Q_bar Vdd Vdd) g45p1svt w=(120n) l=45n nf=ceil(((120n) - 5p) / (10u))           as=(((120n) / (ceil(((120n) - 5p) / (10u)))) < 119.5n) ? ((((50n > (((60n) - 0) + 60n) ? 50n : (((60n) - 0) + 60n)) * 120n) + (((120n) / (ceil(((120n) - 5p) / (10u)))) * 50n)) + (floor(((ceil(((120n) - 5p) / (10u))) - 1) / 2.0) * (((((60n) - 0) + 60n) * 120n) + (((120n) / (ceil(((120n) - 5p) / (10u)))) * 100n))) + ((((ceil(((120n) - 5p) / (10u))) / 2) - floor((ceil(((120n) - 5p) / (10u))) / 2) == 0) ? (((50n > (((60n) - 0) + 60n) ? 50n : (((60n) - 0) + 60n)) * 120n) + (((120n) / (ceil(((120n) - 5p) / (10u)))) * 50n)) : 0)) / 1 : (((100n > (((60n) - 0) + 80n) ? 100n : (((60n) - 0) + 80n)) * ((120n) / (ceil(((120n) - 5p) / (10u))))) + (floor(((ceil(((120n) - 5p) / (10u))) - 1) / 2.0) * ((60n > (((60n) - 0) + 50n) ? 60n : (((60n) - 0) + 50n)) * ((120n) / (ceil(((120n) - 5p) / (10u)))))) + ((((ceil(((120n) - 5p) / (10u))) / 2) - floor((ceil(((120n) - 5p) / (10u))) / 2) == 0) ? ((100n > (((60n) - 0) + 80n) ? 100n : (((60n) - 0) + 80n)) * ((120n) / (ceil(((120n) - 5p) / (10u))))) : 0)) / 1           ad=(((120n) / (ceil(((120n) - 5p) / (10u)))) < 119.5n) ? ((floor((ceil(((120n) - 5p) / (10u))) / 2.0) * (((((60n) - 0) + 60n) * 120n) + (((120n) / (ceil(((120n) - 5p) / (10u)))) * 100n))) + ((((ceil(((120n) - 5p) / (10u))) / 2) - floor((ceil(((120n) - 5p) / (10u))) / 2) != 0) ? (((50n > (((60n) - 0) + 60n) ? 50n : (((60n) - 0) + 60n)) * 120n) + (((120n) / (ceil(((120n) - 5p) / (10u)))) * 50n)) : 0)) / 1 : ((floor((ceil(((120n) - 5p) / (10u))) / 2.0) * ((60n > (((60n) - 0) + 50n) ? 60n : (((60n) - 0) + 50n)) * ((120n) / (ceil(((120n) - 5p) / (10u)))))) + ((((ceil(((120n) - 5p) / (10u))) / 2) - floor((ceil(((120n) - 5p) / (10u))) / 2) != 0) ? ((100n > (((60n) - 0) + 80n) ? 100n : (((60n) - 0) + 80n)) * ((120n) / (ceil(((120n) - 5p) / (10u))))) : 0)) / 1           ps=(((120n) / (ceil(((120n) - 5p) / (10u)))) < 119.5n) ? (((2 * (50n > (((60n) - 0) + 60n) ? 50n : (((60n) - 0) + 60n))) + 340n) + (floor(((ceil(((120n) - 5p) / (10u))) - 1) / 2.0) * ((2 * (((60n) - 0) + 60n)) + 440n)) + ((((ceil(((120n) - 5p) / (10u))) / 2) - floor((ceil(((120n) - 5p) / (10u))) / 2) == 0) ? ((2 * (50n > (((60n) - 0) + 60n) ? 50n : (((60n) - 0) + 60n))) + 340n) : 0)) / 1 : (((2 * (100n > (((60n) - 0) + 80n) ? 100n : (((60n) - 0) + 80n))) + (2 * ((120n) / (ceil(((120n) - 5p) / (10u)))))) + (floor(((ceil(((120n) - 5p) / (10u))) - 1) / 2.0) * ((2 * (60n > (((60n) - 0) + 50n) ? 60n : (((60n) - 0) + 50n))) + (2 * ((120n) / (ceil(((120n) - 5p) / (10u))))))) + ((((ceil(((120n) - 5p) / (10u))) / 2) - floor((ceil(((120n) - 5p) / (10u))) / 2) == 0) ? ((2 * (100n > (((60n) - 0) + 80n) ? 100n : (((60n) - 0) + 80n))) + (2 * ((120n) / (ceil(((120n) - 5p) / (10u)))))) : 0)) / 1           pd=(((120n) / (ceil(((120n) - 5p) / (10u)))) < 119.5n) ? ((floor((ceil(((120n) - 5p) / (10u))) / 2.0) * ((2 * (((60n) - 0) + 60n)) + 440n)) + ((((ceil(((120n) - 5p) / (10u))) / 2) - floor((ceil(((120n) - 5p) / (10u))) / 2) != 0) ? ((2 * (50n > (((60n) - 0) + 60n) ? 50n : (((60n) - 0) + 60n))) + 340n) : 0)) / 1 : ((floor((ceil(((120n) - 5p) / (10u))) / 2.0) * ((2 * (60n > (((60n) - 0) + 50n) ? 60n : (((60n) - 0) + 50n))) + (2 * ((120n) / (ceil(((120n) - 5p) / (10u))))))) + ((((ceil(((120n) - 5p) / (10u))) / 2) - floor((ceil(((120n) - 5p) / (10u))) / 2) != 0) ? ((2 * (100n > (((60n) - 0) + 80n) ? 100n : (((60n) - 0) + 80n))) + (2 * ((120n) / (ceil(((120n) - 5p) / (10u)))))) : 0)) / 1           nrd=(((120n) / (ceil(((120n) - 5p) / (10u)))) < 119.5n) ? ((floor((ceil(((120n) - 5p) / (10u))) / 2.0) * (((((60n) - 0) + 60n) * 120n) + (((120n) / (ceil(((120n) - 5p) / (10u)))) * 100n))) + ((((ceil(((120n) - 5p) / (10u))) / 2) - floor((ceil(((120n) - 5p) / (10u))) / 2) != 0) ? (((50n > (((60n) - 0) + 60n) ? 50n : (((60n) - 0) + 60n)) * 120n) + (((120n) / (ceil(((120n) - 5p) / (10u)))) * 50n)) : 0)) / 1 : ((floor((ceil(((120n) - 5p) / (10u))) / 2.0) * ((60n > (((60n) - 0) + 50n) ? 60n : (((60n) - 0) + 50n)) * ((120n) / (ceil(((120n) - 5p) / (10u)))))) + ((((ceil(((120n) - 5p) / (10u))) / 2) - floor((ceil(((120n) - 5p) / (10u))) / 2) != 0) ? ((100n > (((60n) - 0) + 80n) ? 100n : (((60n) - 0) + 80n)) * ((120n) / (ceil(((120n) - 5p) / (10u))))) : 0)) / 1 / (((120n) / (ceil(((120n) - 5p) / (10u)))) * (ceil(((120n) - 5p) / (10u))) * ((120n) / (ceil(((120n) - 5p) / (10u)))) * (ceil(((120n) - 5p) / (10u))))           nrs=(((120n) / (ceil(((120n) - 5p) / (10u)))) < 119.5n) ? ((((50n > (((60n) - 0) + 60n) ? 50n : (((60n) - 0) + 60n)) * 120n) + (((120n) / (ceil(((120n) - 5p) / (10u)))) * 50n)) + (floor(((ceil(((120n) - 5p) / (10u))) - 1) / 2.0) * (((((60n) - 0) + 60n) * 120n) + (((120n) / (ceil(((120n) - 5p) / (10u)))) * 100n))) + ((((ceil(((120n) - 5p) / (10u))) / 2) - floor((ceil(((120n) - 5p) / (10u))) / 2) == 0) ? (((50n > (((60n) - 0) + 60n) ? 50n : (((60n) - 0) + 60n)) * 120n) + (((120n) / (ceil(((120n) - 5p) / (10u)))) * 50n)) : 0)) / 1 : (((100n > (((60n) - 0) + 80n) ? 100n : (((60n) - 0) + 80n)) * ((120n) / (ceil(((120n) - 5p) / (10u))))) + (floor(((ceil(((120n) - 5p) / (10u))) - 1) / 2.0) * ((60n > (((60n) - 0) + 50n) ? 60n : (((60n) - 0) + 50n)) * ((120n) / (ceil(((120n) - 5p) / (10u)))))) + ((((ceil(((120n) - 5p) / (10u))) / 2) - floor((ceil(((120n) - 5p) / (10u))) / 2) == 0) ? ((100n > (((60n) - 0) + 80n) ? 100n : (((60n) - 0) + 80n)) * ((120n) / (ceil(((120n) - 5p) / (10u))))) : 0)) / 1 / (((120n) / (ceil(((120n) - 5p) / (10u)))) * (ceil(((120n) - 5p) / (10u))) * ((120n) / (ceil(((120n) - 5p) / (10u)))) * (ceil(((120n) - 5p) / (10u))))           sa=(((120n) / (ceil(((120n) - 5p) / (10u)))) < 119.5n) ? (50n > (((60n) - 0) + 60n) ? 50n : (((60n) - 0) + 60n)) + 5e-08 : (100n > (((60n) - 0) + 80n) ? 100n : (((60n) - 0) + 80n))           sb=(((120n) / (ceil(((120n) - 5p) / (10u)))) < 119.5n) ? (50n > (((60n) - 0) + 60n) ? 50n : (((60n) - 0) + 60n)) + 5e-08 : (100n > (((60n) - 0) + 80n) ? 100n : (((60n) - 0) + 80n))           sd=(((120n) / (ceil(((120n) - 5p) / (10u)))) < 119.5n) ? (((60n) - 0) + 60n) + (2*5e-08) : (60n > (((60n) - 0) + 50n) ? 60n : (((60n) - 0) + 50n))           sca=(( ((120n) / (ceil(((120n) - 5p) / (10u)))) * ( (((1u) * (1u) / ((((120n) / (ceil(((120n) - 5p) / (10u)))) < 119.5n) ? (50n > (((60n) - 0) + 60n) ? 50n : (((60n) - 0) + 60n)) + 5e-08 : (100n > (((60n) - 0) + 80n) ? 100n : (((60n) - 0) + 80n))+60n)) - ((1u) * (1u) / (((((120n) / (ceil(((120n) - 5p) / (10u)))) < 119.5n) ? (50n > (((60n) - 0) + 60n) ? 50n : (((60n) - 0) + 60n)) + 5e-08 : (100n > (((60n) - 0) + 80n) ? 100n : (((60n) - 0) + 80n))+60n)+(45n)))) + ((1u) * (1u) / ((((120n) / (ceil(((120n) - 5p) / (10u)))) < 119.5n) ? (50n > (((60n) - 0) + 60n) ? 50n : (((60n) - 0) + 60n)) + 5e-08 : (100n > (((60n) - 0) + 80n) ? 100n : (((60n) - 0) + 80n))+60n)) - ((1u) * (1u)/ (((((120n) / (ceil(((120n) - 5p) / (10u)))) < 119.5n) ? (50n > (((60n) - 0) + 60n) ? 50n : (((60n) - 0) + 60n)) + 5e-08 : (100n > (((60n) - 0) + 80n) ? 100n : (((60n) - 0) + 80n))+60n)+(45n))))) + ( (45n) * ( (((1u) * (1u) / (60n)) - ((1u) * (1u) / ((60n)+((120n) / (ceil(((120n) - 5p) / (10u))))))) + ((1u) * (1u) / (60n)) - ((1u) * (1u)/ ((60n)+((120n) / (ceil(((120n) - 5p) / (10u))))))))) / (((120n) / (ceil(((120n) - 5p) / (10u)))) * (45n))           scb=((((120n) / (ceil(((120n) - 5p) / (10u)))) * ((((((120n) / (ceil(((120n) - 5p) / (10u)))) < 119.5n) ? (50n > (((60n) - 0) + 60n) ? 50n : (((60n) - 0) + 60n)) + 5e-08 : (100n > (((60n) - 0) + 80n) ? 100n : (((60n) - 0) + 80n))+60n)/10 + (1u)/100)*exp(-10 * ((((120n) / (ceil(((120n) - 5p) / (10u)))) < 119.5n) ? (50n > (((60n) - 0) + 60n) ? 50n : (((60n) - 0) + 60n)) + 5e-08 : (100n > (((60n) - 0) + 80n) ? 100n : (((60n) - 0) + 80n))+60n) / (1u)) - ((((((120n) / (ceil(((120n) - 5p) / (10u)))) < 119.5n) ? (50n > (((60n) - 0) + 60n) ? 50n : (((60n) - 0) + 60n)) + 5e-08 : (100n > (((60n) - 0) + 80n) ? 100n : (((60n) - 0) + 80n))+60n)+(45n))/10 + (1u)/100)*exp(-10 * (((((120n) / (ceil(((120n) - 5p) / (10u)))) < 119.5n) ? (50n > (((60n) - 0) + 60n) ? 50n : (((60n) - 0) + 60n)) + 5e-08 : (100n > (((60n) - 0) + 80n) ? 100n : (((60n) - 0) + 80n))+60n)+(45n)) / (1u)) + (((((120n) / (ceil(((120n) - 5p) / (10u)))) < 119.5n) ? (50n > (((60n) - 0) + 60n) ? 50n : (((60n) - 0) + 60n)) + 5e-08 : (100n > (((60n) - 0) + 80n) ? 100n : (((60n) - 0) + 80n))+60n)/10 + (1u)/100)*exp(-10 * ((((120n) / (ceil(((120n) - 5p) / (10u)))) < 119.5n) ? (50n > (((60n) - 0) + 60n) ? 50n : (((60n) - 0) + 60n)) + 5e-08 : (100n > (((60n) - 0) + 80n) ? 100n : (((60n) - 0) + 80n))+60n) / (1u)) - ((((((120n) / (ceil(((120n) - 5p) / (10u)))) < 119.5n) ? (50n > (((60n) - 0) + 60n) ? 50n : (((60n) - 0) + 60n)) + 5e-08 : (100n > (((60n) - 0) + 80n) ? 100n : (((60n) - 0) + 80n))+60n)+(45n))/10 + (1u)/100)*exp(-10 * (((((120n) / (ceil(((120n) - 5p) / (10u)))) < 119.5n) ? (50n > (((60n) - 0) + 60n) ? 50n : (((60n) - 0) + 60n)) + 5e-08 : (100n > (((60n) - 0) + 80n) ? 100n : (((60n) - 0) + 80n))+60n)+(45n)) / (1u)))) + ((45n) * (((60n)/10 + (1u)/100)*exp(-10 * (60n) / (1u)) - (((60n)+((120n) / (ceil(((120n) - 5p) / (10u)))))/10 + (1u)/100)*exp(-10 * ((60n)+((120n) / (ceil(((120n) - 5p) / (10u))))) / (1u)) + ((60n)/10 + (1u)/100)*exp(-10 * (60n) / (1u)) - (((60n)+((120n) / (ceil(((120n) - 5p) / (10u)))))/10 + (1u)/100)*exp(-10 * ((60n)+((120n) / (ceil(((120n) - 5p) / (10u))))) / (1u))))) / (((120n) / (ceil(((120n) - 5p) / (10u)))) * (45n))           scc=((((120n) / (ceil(((120n) - 5p) / (10u)))) * ((((((120n) / (ceil(((120n) - 5p) / (10u)))) < 119.5n) ? (50n > (((60n) - 0) + 60n) ? 50n : (((60n) - 0) + 60n)) + 5e-08 : (100n > (((60n) - 0) + 80n) ? 100n : (((60n) - 0) + 80n))+60n)/20 + (1u)/400)*exp(-20 * ((((120n) / (ceil(((120n) - 5p) / (10u)))) < 119.5n) ? (50n > (((60n) - 0) + 60n) ? 50n : (((60n) - 0) + 60n)) + 5e-08 : (100n > (((60n) - 0) + 80n) ? 100n : (((60n) - 0) + 80n))+60n) / (1u)) - ((((((120n) / (ceil(((120n) - 5p) / (10u)))) < 119.5n) ? (50n > (((60n) - 0) + 60n) ? 50n : (((60n) - 0) + 60n)) + 5e-08 : (100n > (((60n) - 0) + 80n) ? 100n : (((60n) - 0) + 80n))+60n)+(45n))/20 + (1u)/400)*exp(-20 * (((((120n) / (ceil(((120n) - 5p) / (10u)))) < 119.5n) ? (50n > (((60n) - 0) + 60n) ? 50n : (((60n) - 0) + 60n)) + 5e-08 : (100n > (((60n) - 0) + 80n) ? 100n : (((60n) - 0) + 80n))+60n)+(45n)) / (1u)) + (((((120n) / (ceil(((120n) - 5p) / (10u)))) < 119.5n) ? (50n > (((60n) - 0) + 60n) ? 50n : (((60n) - 0) + 60n)) + 5e-08 : (100n > (((60n) - 0) + 80n) ? 100n : (((60n) - 0) + 80n))+60n)/20 + (1u)/400)*exp(-20 * ((((120n) / (ceil(((120n) - 5p) / (10u)))) < 119.5n) ? (50n > (((60n) - 0) + 60n) ? 50n : (((60n) - 0) + 60n)) + 5e-08 : (100n > (((60n) - 0) + 80n) ? 100n : (((60n) - 0) + 80n))+60n) / (1u)) - ((((((120n) / (ceil(((120n) - 5p) / (10u)))) < 119.5n) ? (50n > (((60n) - 0) + 60n) ? 50n : (((60n) - 0) + 60n)) + 5e-08 : (100n > (((60n) - 0) + 80n) ? 100n : (((60n) - 0) + 80n))+60n)+(45n))/20 + (1u)/400)*exp(-20 * (((((120n) / (ceil(((120n) - 5p) / (10u)))) < 119.5n) ? (50n > (((60n) - 0) + 60n) ? 50n : (((60n) - 0) + 60n)) + 5e-08 : (100n > (((60n) - 0) + 80n) ? 100n : (((60n) - 0) + 80n))+60n)+(45n)) / (1u)))) + ((45n) * (((60n)/20 + (1u)/400)*exp(-20 * (60n) / (1u)) - (((60n)+((120n) / (ceil(((120n) - 5p) / (10u)))))/20 + (1u)/400)*exp(-20 * ((60n)+((120n) / (ceil(((120n) - 5p) / (10u))))) / (1u)) + ((60n)/20 + (1u)/400)*exp(-20 * (60n) / (1u)) - (((60n)+((120n) / (ceil(((120n) - 5p) / (10u)))))/20 + (1u)/400)*exp(-20 * ((60n)+((120n) / (ceil(((120n) - 5p) / (10u))))) / (1u))))) / (((120n) / (ceil(((120n) - 5p) / (10u)))) * (45n))           m=(1)
NM0 (Q_bar Q GND GND) g45n1svt w=(360n) l=45n nf=ceil(((360n) - 5p) / (10u))           as=(((360n) / (ceil(((360n) - 5p) / (10u)))) < 119.5n) ? ((((50n > (((60n) - 0) + 60n) ? 50n : (((60n) - 0) + 60n)) * 120n) + (((360n) / (ceil(((360n) - 5p) / (10u)))) * 50n)) + (floor(((ceil(((360n) - 5p) / (10u))) - 1) / 2.0) * (((((60n) - 0) + 60n) * 120n) + (((360n) / (ceil(((360n) - 5p) / (10u)))) * 100n))) + ((((ceil(((360n) - 5p) / (10u))) / 2) - floor((ceil(((360n) - 5p) / (10u))) / 2) == 0) ? (((50n > (((60n) - 0) + 60n) ? 50n : (((60n) - 0) + 60n)) * 120n) + (((360n) / (ceil(((360n) - 5p) / (10u)))) * 50n)) : 0)) / 1 : (((100n > (((60n) - 0) + 80n) ? 100n : (((60n) - 0) + 80n)) * ((360n) / (ceil(((360n) - 5p) / (10u))))) + (floor(((ceil(((360n) - 5p) / (10u))) - 1) / 2.0) * ((60n > (((60n) - 0) + 50n) ? 60n : (((60n) - 0) + 50n)) * ((360n) / (ceil(((360n) - 5p) / (10u)))))) + ((((ceil(((360n) - 5p) / (10u))) / 2) - floor((ceil(((360n) - 5p) / (10u))) / 2) == 0) ? ((100n > (((60n) - 0) + 80n) ? 100n : (((60n) - 0) + 80n)) * ((360n) / (ceil(((360n) - 5p) / (10u))))) : 0)) / 1           ad=(((360n) / (ceil(((360n) - 5p) / (10u)))) < 119.5n) ? ((floor((ceil(((360n) - 5p) / (10u))) / 2.0) * (((((60n) - 0) + 60n) * 120n) + (((360n) / (ceil(((360n) - 5p) / (10u)))) * 100n))) + ((((ceil(((360n) - 5p) / (10u))) / 2) - floor((ceil(((360n) - 5p) / (10u))) / 2) != 0) ? (((50n > (((60n) - 0) + 60n) ? 50n : (((60n) - 0) + 60n)) * 120n) + (((360n) / (ceil(((360n) - 5p) / (10u)))) * 50n)) : 0)) / 1 : ((floor((ceil(((360n) - 5p) / (10u))) / 2.0) * ((60n > (((60n) - 0) + 50n) ? 60n : (((60n) - 0) + 50n)) * ((360n) / (ceil(((360n) - 5p) / (10u)))))) + ((((ceil(((360n) - 5p) / (10u))) / 2) - floor((ceil(((360n) - 5p) / (10u))) / 2) != 0) ? ((100n > (((60n) - 0) + 80n) ? 100n : (((60n) - 0) + 80n)) * ((360n) / (ceil(((360n) - 5p) / (10u))))) : 0)) / 1           ps=(((360n) / (ceil(((360n) - 5p) / (10u)))) < 119.5n) ? (((2 * (50n > (((60n) - 0) + 60n) ? 50n : (((60n) - 0) + 60n))) + 340n) + (floor(((ceil(((360n) - 5p) / (10u))) - 1) / 2.0) * ((2 * (((60n) - 0) + 60n)) + 440n)) + ((((ceil(((360n) - 5p) / (10u))) / 2) - floor((ceil(((360n) - 5p) / (10u))) / 2) == 0) ? ((2 * (50n > (((60n) - 0) + 60n) ? 50n : (((60n) - 0) + 60n))) + 340n) : 0)) / 1 : (((2 * (100n > (((60n) - 0) + 80n) ? 100n : (((60n) - 0) + 80n))) + (2 * ((360n) / (ceil(((360n) - 5p) / (10u)))))) + (floor(((ceil(((360n) - 5p) / (10u))) - 1) / 2.0) * ((2 * (60n > (((60n) - 0) + 50n) ? 60n : (((60n) - 0) + 50n))) + (2 * ((360n) / (ceil(((360n) - 5p) / (10u))))))) + ((((ceil(((360n) - 5p) / (10u))) / 2) - floor((ceil(((360n) - 5p) / (10u))) / 2) == 0) ? ((2 * (100n > (((60n) - 0) + 80n) ? 100n : (((60n) - 0) + 80n))) + (2 * ((360n) / (ceil(((360n) - 5p) / (10u)))))) : 0)) / 1           pd=(((360n) / (ceil(((360n) - 5p) / (10u)))) < 119.5n) ? ((floor((ceil(((360n) - 5p) / (10u))) / 2.0) * ((2 * (((60n) - 0) + 60n)) + 440n)) + ((((ceil(((360n) - 5p) / (10u))) / 2) - floor((ceil(((360n) - 5p) / (10u))) / 2) != 0) ? ((2 * (50n > (((60n) - 0) + 60n) ? 50n : (((60n) - 0) + 60n))) + 340n) : 0)) / 1 : ((floor((ceil(((360n) - 5p) / (10u))) / 2.0) * ((2 * (60n > (((60n) - 0) + 50n) ? 60n : (((60n) - 0) + 50n))) + (2 * ((360n) / (ceil(((360n) - 5p) / (10u))))))) + ((((ceil(((360n) - 5p) / (10u))) / 2) - floor((ceil(((360n) - 5p) / (10u))) / 2) != 0) ? ((2 * (100n > (((60n) - 0) + 80n) ? 100n : (((60n) - 0) + 80n))) + (2 * ((360n) / (ceil(((360n) - 5p) / (10u)))))) : 0)) / 1           nrd=(((360n) / (ceil(((360n) - 5p) / (10u)))) < 119.5n) ? ((floor((ceil(((360n) - 5p) / (10u))) / 2.0) * (((((60n) - 0) + 60n) * 120n) + (((360n) / (ceil(((360n) - 5p) / (10u)))) * 100n))) + ((((ceil(((360n) - 5p) / (10u))) / 2) - floor((ceil(((360n) - 5p) / (10u))) / 2) != 0) ? (((50n > (((60n) - 0) + 60n) ? 50n : (((60n) - 0) + 60n)) * 120n) + (((360n) / (ceil(((360n) - 5p) / (10u)))) * 50n)) : 0)) / 1 : ((floor((ceil(((360n) - 5p) / (10u))) / 2.0) * ((60n > (((60n) - 0) + 50n) ? 60n : (((60n) - 0) + 50n)) * ((360n) / (ceil(((360n) - 5p) / (10u)))))) + ((((ceil(((360n) - 5p) / (10u))) / 2) - floor((ceil(((360n) - 5p) / (10u))) / 2) != 0) ? ((100n > (((60n) - 0) + 80n) ? 100n : (((60n) - 0) + 80n)) * ((360n) / (ceil(((360n) - 5p) / (10u))))) : 0)) / 1 / (((360n) / (ceil(((360n) - 5p) / (10u)))) * (ceil(((360n) - 5p) / (10u))) * ((360n) / (ceil(((360n) - 5p) / (10u)))) * (ceil(((360n) - 5p) / (10u))))           nrs=(((360n) / (ceil(((360n) - 5p) / (10u)))) < 119.5n) ? ((((50n > (((60n) - 0) + 60n) ? 50n : (((60n) - 0) + 60n)) * 120n) + (((360n) / (ceil(((360n) - 5p) / (10u)))) * 50n)) + (floor(((ceil(((360n) - 5p) / (10u))) - 1) / 2.0) * (((((60n) - 0) + 60n) * 120n) + (((360n) / (ceil(((360n) - 5p) / (10u)))) * 100n))) + ((((ceil(((360n) - 5p) / (10u))) / 2) - floor((ceil(((360n) - 5p) / (10u))) / 2) == 0) ? (((50n > (((60n) - 0) + 60n) ? 50n : (((60n) - 0) + 60n)) * 120n) + (((360n) / (ceil(((360n) - 5p) / (10u)))) * 50n)) : 0)) / 1 : (((100n > (((60n) - 0) + 80n) ? 100n : (((60n) - 0) + 80n)) * ((360n) / (ceil(((360n) - 5p) / (10u))))) + (floor(((ceil(((360n) - 5p) / (10u))) - 1) / 2.0) * ((60n > (((60n) - 0) + 50n) ? 60n : (((60n) - 0) + 50n)) * ((360n) / (ceil(((360n) - 5p) / (10u)))))) + ((((ceil(((360n) - 5p) / (10u))) / 2) - floor((ceil(((360n) - 5p) / (10u))) / 2) == 0) ? ((100n > (((60n) - 0) + 80n) ? 100n : (((60n) - 0) + 80n)) * ((360n) / (ceil(((360n) - 5p) / (10u))))) : 0)) / 1 / (((360n) / (ceil(((360n) - 5p) / (10u)))) * (ceil(((360n) - 5p) / (10u))) * ((360n) / (ceil(((360n) - 5p) / (10u)))) * (ceil(((360n) - 5p) / (10u))))           sa=(((360n) / (ceil(((360n) - 5p) / (10u)))) < 119.5n) ? (50n > (((60n) - 0) + 60n) ? 50n : (((60n) - 0) + 60n)) + 5e-08 : (100n > (((60n) - 0) + 80n) ? 100n : (((60n) - 0) + 80n))           sb=(((360n) / (ceil(((360n) - 5p) / (10u)))) < 119.5n) ? (50n > (((60n) - 0) + 60n) ? 50n : (((60n) - 0) + 60n)) + 5e-08 : (100n > (((60n) - 0) + 80n) ? 100n : (((60n) - 0) + 80n))           sd=(((360n) / (ceil(((360n) - 5p) / (10u)))) < 119.5n) ? (((60n) - 0) + 60n) + (2*5e-08) : (60n > (((60n) - 0) + 50n) ? 60n : (((60n) - 0) + 50n))           sca=(( ((360n) / (ceil(((360n) - 5p) / (10u)))) * ( (((1u) * (1u) / ((((360n) / (ceil(((360n) - 5p) / (10u)))) < 119.5n) ? (50n > (((60n) - 0) + 60n) ? 50n : (((60n) - 0) + 60n)) + 5e-08 : (100n > (((60n) - 0) + 80n) ? 100n : (((60n) - 0) + 80n))+60n)) - ((1u) * (1u) / (((((360n) / (ceil(((360n) - 5p) / (10u)))) < 119.5n) ? (50n > (((60n) - 0) + 60n) ? 50n : (((60n) - 0) + 60n)) + 5e-08 : (100n > (((60n) - 0) + 80n) ? 100n : (((60n) - 0) + 80n))+60n)+(45n)))) + ((1u) * (1u) / ((((360n) / (ceil(((360n) - 5p) / (10u)))) < 119.5n) ? (50n > (((60n) - 0) + 60n) ? 50n : (((60n) - 0) + 60n)) + 5e-08 : (100n > (((60n) - 0) + 80n) ? 100n : (((60n) - 0) + 80n))+60n)) - ((1u) * (1u)/ (((((360n) / (ceil(((360n) - 5p) / (10u)))) < 119.5n) ? (50n > (((60n) - 0) + 60n) ? 50n : (((60n) - 0) + 60n)) + 5e-08 : (100n > (((60n) - 0) + 80n) ? 100n : (((60n) - 0) + 80n))+60n)+(45n))))) + ( (45n) * ( (((1u) * (1u) / (60n)) - ((1u) * (1u) / ((60n)+((360n) / (ceil(((360n) - 5p) / (10u))))))) + ((1u) * (1u) / (60n)) - ((1u) * (1u)/ ((60n)+((360n) / (ceil(((360n) - 5p) / (10u))))))))) / (((360n) / (ceil(((360n) - 5p) / (10u)))) * (45n))           scb=((((360n) / (ceil(((360n) - 5p) / (10u)))) * ((((((360n) / (ceil(((360n) - 5p) / (10u)))) < 119.5n) ? (50n > (((60n) - 0) + 60n) ? 50n : (((60n) - 0) + 60n)) + 5e-08 : (100n > (((60n) - 0) + 80n) ? 100n : (((60n) - 0) + 80n))+60n)/10 + (1u)/100)*exp(-10 * ((((360n) / (ceil(((360n) - 5p) / (10u)))) < 119.5n) ? (50n > (((60n) - 0) + 60n) ? 50n : (((60n) - 0) + 60n)) + 5e-08 : (100n > (((60n) - 0) + 80n) ? 100n : (((60n) - 0) + 80n))+60n) / (1u)) - ((((((360n) / (ceil(((360n) - 5p) / (10u)))) < 119.5n) ? (50n > (((60n) - 0) + 60n) ? 50n : (((60n) - 0) + 60n)) + 5e-08 : (100n > (((60n) - 0) + 80n) ? 100n : (((60n) - 0) + 80n))+60n)+(45n))/10 + (1u)/100)*exp(-10 * (((((360n) / (ceil(((360n) - 5p) / (10u)))) < 119.5n) ? (50n > (((60n) - 0) + 60n) ? 50n : (((60n) - 0) + 60n)) + 5e-08 : (100n > (((60n) - 0) + 80n) ? 100n : (((60n) - 0) + 80n))+60n)+(45n)) / (1u)) + (((((360n) / (ceil(((360n) - 5p) / (10u)))) < 119.5n) ? (50n > (((60n) - 0) + 60n) ? 50n : (((60n) - 0) + 60n)) + 5e-08 : (100n > (((60n) - 0) + 80n) ? 100n : (((60n) - 0) + 80n))+60n)/10 + (1u)/100)*exp(-10 * ((((360n) / (ceil(((360n) - 5p) / (10u)))) < 119.5n) ? (50n > (((60n) - 0) + 60n) ? 50n : (((60n) - 0) + 60n)) + 5e-08 : (100n > (((60n) - 0) + 80n) ? 100n : (((60n) - 0) + 80n))+60n) / (1u)) - ((((((360n) / (ceil(((360n) - 5p) / (10u)))) < 119.5n) ? (50n > (((60n) - 0) + 60n) ? 50n : (((60n) - 0) + 60n)) + 5e-08 : (100n > (((60n) - 0) + 80n) ? 100n : (((60n) - 0) + 80n))+60n)+(45n))/10 + (1u)/100)*exp(-10 * (((((360n) / (ceil(((360n) - 5p) / (10u)))) < 119.5n) ? (50n > (((60n) - 0) + 60n) ? 50n : (((60n) - 0) + 60n)) + 5e-08 : (100n > (((60n) - 0) + 80n) ? 100n : (((60n) - 0) + 80n))+60n)+(45n)) / (1u)))) + ((45n) * (((60n)/10 + (1u)/100)*exp(-10 * (60n) / (1u)) - (((60n)+((360n) / (ceil(((360n) - 5p) / (10u)))))/10 + (1u)/100)*exp(-10 * ((60n)+((360n) / (ceil(((360n) - 5p) / (10u))))) / (1u)) + ((60n)/10 + (1u)/100)*exp(-10 * (60n) / (1u)) - (((60n)+((360n) / (ceil(((360n) - 5p) / (10u)))))/10 + (1u)/100)*exp(-10 * ((60n)+((360n) / (ceil(((360n) - 5p) / (10u))))) / (1u))))) / (((360n) / (ceil(((360n) - 5p) / (10u)))) * (45n))           scc=((((360n) / (ceil(((360n) - 5p) / (10u)))) * ((((((360n) / (ceil(((360n) - 5p) / (10u)))) < 119.5n) ? (50n > (((60n) - 0) + 60n) ? 50n : (((60n) - 0) + 60n)) + 5e-08 : (100n > (((60n) - 0) + 80n) ? 100n : (((60n) - 0) + 80n))+60n)/20 + (1u)/400)*exp(-20 * ((((360n) / (ceil(((360n) - 5p) / (10u)))) < 119.5n) ? (50n > (((60n) - 0) + 60n) ? 50n : (((60n) - 0) + 60n)) + 5e-08 : (100n > (((60n) - 0) + 80n) ? 100n : (((60n) - 0) + 80n))+60n) / (1u)) - ((((((360n) / (ceil(((360n) - 5p) / (10u)))) < 119.5n) ? (50n > (((60n) - 0) + 60n) ? 50n : (((60n) - 0) + 60n)) + 5e-08 : (100n > (((60n) - 0) + 80n) ? 100n : (((60n) - 0) + 80n))+60n)+(45n))/20 + (1u)/400)*exp(-20 * (((((360n) / (ceil(((360n) - 5p) / (10u)))) < 119.5n) ? (50n > (((60n) - 0) + 60n) ? 50n : (((60n) - 0) + 60n)) + 5e-08 : (100n > (((60n) - 0) + 80n) ? 100n : (((60n) - 0) + 80n))+60n)+(45n)) / (1u)) + (((((360n) / (ceil(((360n) - 5p) / (10u)))) < 119.5n) ? (50n > (((60n) - 0) + 60n) ? 50n : (((60n) - 0) + 60n)) + 5e-08 : (100n > (((60n) - 0) + 80n) ? 100n : (((60n) - 0) + 80n))+60n)/20 + (1u)/400)*exp(-20 * ((((360n) / (ceil(((360n) - 5p) / (10u)))) < 119.5n) ? (50n > (((60n) - 0) + 60n) ? 50n : (((60n) - 0) + 60n)) + 5e-08 : (100n > (((60n) - 0) + 80n) ? 100n : (((60n) - 0) + 80n))+60n) / (1u)) - ((((((360n) / (ceil(((360n) - 5p) / (10u)))) < 119.5n) ? (50n > (((60n) - 0) + 60n) ? 50n : (((60n) - 0) + 60n)) + 5e-08 : (100n > (((60n) - 0) + 80n) ? 100n : (((60n) - 0) + 80n))+60n)+(45n))/20 + (1u)/400)*exp(-20 * (((((360n) / (ceil(((360n) - 5p) / (10u)))) < 119.5n) ? (50n > (((60n) - 0) + 60n) ? 50n : (((60n) - 0) + 60n)) + 5e-08 : (100n > (((60n) - 0) + 80n) ? 100n : (((60n) - 0) + 80n))+60n)+(45n)) / (1u)))) + ((45n) * (((60n)/20 + (1u)/400)*exp(-20 * (60n) / (1u)) - (((60n)+((360n) / (ceil(((360n) - 5p) / (10u)))))/20 + (1u)/400)*exp(-20 * ((60n)+((360n) / (ceil(((360n) - 5p) / (10u))))) / (1u)) + ((60n)/20 + (1u)/400)*exp(-20 * (60n) / (1u)) - (((60n)+((360n) / (ceil(((360n) - 5p) / (10u)))))/20 + (1u)/400)*exp(-20 * ((60n)+((360n) / (ceil(((360n) - 5p) / (10u))))) / (1u))))) / (((360n) / (ceil(((360n) - 5p) / (10u)))) * (45n))           m=(1)
NM1 (Q Q_bar GND GND) g45n1svt w=(360n) l=45n nf=ceil(((360n) - 5p) / (10u))           as=(((360n) / (ceil(((360n) - 5p) / (10u)))) < 119.5n) ? ((((50n > (((60n) - 0) + 60n) ? 50n : (((60n) - 0) + 60n)) * 120n) + (((360n) / (ceil(((360n) - 5p) / (10u)))) * 50n)) + (floor(((ceil(((360n) - 5p) / (10u))) - 1) / 2.0) * (((((60n) - 0) + 60n) * 120n) + (((360n) / (ceil(((360n) - 5p) / (10u)))) * 100n))) + ((((ceil(((360n) - 5p) / (10u))) / 2) - floor((ceil(((360n) - 5p) / (10u))) / 2) == 0) ? (((50n > (((60n) - 0) + 60n) ? 50n : (((60n) - 0) + 60n)) * 120n) + (((360n) / (ceil(((360n) - 5p) / (10u)))) * 50n)) : 0)) / 1 : (((100n > (((60n) - 0) + 80n) ? 100n : (((60n) - 0) + 80n)) * ((360n) / (ceil(((360n) - 5p) / (10u))))) + (floor(((ceil(((360n) - 5p) / (10u))) - 1) / 2.0) * ((60n > (((60n) - 0) + 50n) ? 60n : (((60n) - 0) + 50n)) * ((360n) / (ceil(((360n) - 5p) / (10u)))))) + ((((ceil(((360n) - 5p) / (10u))) / 2) - floor((ceil(((360n) - 5p) / (10u))) / 2) == 0) ? ((100n > (((60n) - 0) + 80n) ? 100n : (((60n) - 0) + 80n)) * ((360n) / (ceil(((360n) - 5p) / (10u))))) : 0)) / 1           ad=(((360n) / (ceil(((360n) - 5p) / (10u)))) < 119.5n) ? ((floor((ceil(((360n) - 5p) / (10u))) / 2.0) * (((((60n) - 0) + 60n) * 120n) + (((360n) / (ceil(((360n) - 5p) / (10u)))) * 100n))) + ((((ceil(((360n) - 5p) / (10u))) / 2) - floor((ceil(((360n) - 5p) / (10u))) / 2) != 0) ? (((50n > (((60n) - 0) + 60n) ? 50n : (((60n) - 0) + 60n)) * 120n) + (((360n) / (ceil(((360n) - 5p) / (10u)))) * 50n)) : 0)) / 1 : ((floor((ceil(((360n) - 5p) / (10u))) / 2.0) * ((60n > (((60n) - 0) + 50n) ? 60n : (((60n) - 0) + 50n)) * ((360n) / (ceil(((360n) - 5p) / (10u)))))) + ((((ceil(((360n) - 5p) / (10u))) / 2) - floor((ceil(((360n) - 5p) / (10u))) / 2) != 0) ? ((100n > (((60n) - 0) + 80n) ? 100n : (((60n) - 0) + 80n)) * ((360n) / (ceil(((360n) - 5p) / (10u))))) : 0)) / 1           ps=(((360n) / (ceil(((360n) - 5p) / (10u)))) < 119.5n) ? (((2 * (50n > (((60n) - 0) + 60n) ? 50n : (((60n) - 0) + 60n))) + 340n) + (floor(((ceil(((360n) - 5p) / (10u))) - 1) / 2.0) * ((2 * (((60n) - 0) + 60n)) + 440n)) + ((((ceil(((360n) - 5p) / (10u))) / 2) - floor((ceil(((360n) - 5p) / (10u))) / 2) == 0) ? ((2 * (50n > (((60n) - 0) + 60n) ? 50n : (((60n) - 0) + 60n))) + 340n) : 0)) / 1 : (((2 * (100n > (((60n) - 0) + 80n) ? 100n : (((60n) - 0) + 80n))) + (2 * ((360n) / (ceil(((360n) - 5p) / (10u)))))) + (floor(((ceil(((360n) - 5p) / (10u))) - 1) / 2.0) * ((2 * (60n > (((60n) - 0) + 50n) ? 60n : (((60n) - 0) + 50n))) + (2 * ((360n) / (ceil(((360n) - 5p) / (10u))))))) + ((((ceil(((360n) - 5p) / (10u))) / 2) - floor((ceil(((360n) - 5p) / (10u))) / 2) == 0) ? ((2 * (100n > (((60n) - 0) + 80n) ? 100n : (((60n) - 0) + 80n))) + (2 * ((360n) / (ceil(((360n) - 5p) / (10u)))))) : 0)) / 1           pd=(((360n) / (ceil(((360n) - 5p) / (10u)))) < 119.5n) ? ((floor((ceil(((360n) - 5p) / (10u))) / 2.0) * ((2 * (((60n) - 0) + 60n)) + 440n)) + ((((ceil(((360n) - 5p) / (10u))) / 2) - floor((ceil(((360n) - 5p) / (10u))) / 2) != 0) ? ((2 * (50n > (((60n) - 0) + 60n) ? 50n : (((60n) - 0) + 60n))) + 340n) : 0)) / 1 : ((floor((ceil(((360n) - 5p) / (10u))) / 2.0) * ((2 * (60n > (((60n) - 0) + 50n) ? 60n : (((60n) - 0) + 50n))) + (2 * ((360n) / (ceil(((360n) - 5p) / (10u))))))) + ((((ceil(((360n) - 5p) / (10u))) / 2) - floor((ceil(((360n) - 5p) / (10u))) / 2) != 0) ? ((2 * (100n > (((60n) - 0) + 80n) ? 100n : (((60n) - 0) + 80n))) + (2 * ((360n) / (ceil(((360n) - 5p) / (10u)))))) : 0)) / 1           nrd=(((360n) / (ceil(((360n) - 5p) / (10u)))) < 119.5n) ? ((floor((ceil(((360n) - 5p) / (10u))) / 2.0) * (((((60n) - 0) + 60n) * 120n) + (((360n) / (ceil(((360n) - 5p) / (10u)))) * 100n))) + ((((ceil(((360n) - 5p) / (10u))) / 2) - floor((ceil(((360n) - 5p) / (10u))) / 2) != 0) ? (((50n > (((60n) - 0) + 60n) ? 50n : (((60n) - 0) + 60n)) * 120n) + (((360n) / (ceil(((360n) - 5p) / (10u)))) * 50n)) : 0)) / 1 : ((floor((ceil(((360n) - 5p) / (10u))) / 2.0) * ((60n > (((60n) - 0) + 50n) ? 60n : (((60n) - 0) + 50n)) * ((360n) / (ceil(((360n) - 5p) / (10u)))))) + ((((ceil(((360n) - 5p) / (10u))) / 2) - floor((ceil(((360n) - 5p) / (10u))) / 2) != 0) ? ((100n > (((60n) - 0) + 80n) ? 100n : (((60n) - 0) + 80n)) * ((360n) / (ceil(((360n) - 5p) / (10u))))) : 0)) / 1 / (((360n) / (ceil(((360n) - 5p) / (10u)))) * (ceil(((360n) - 5p) / (10u))) * ((360n) / (ceil(((360n) - 5p) / (10u)))) * (ceil(((360n) - 5p) / (10u))))           nrs=(((360n) / (ceil(((360n) - 5p) / (10u)))) < 119.5n) ? ((((50n > (((60n) - 0) + 60n) ? 50n : (((60n) - 0) + 60n)) * 120n) + (((360n) / (ceil(((360n) - 5p) / (10u)))) * 50n)) + (floor(((ceil(((360n) - 5p) / (10u))) - 1) / 2.0) * (((((60n) - 0) + 60n) * 120n) + (((360n) / (ceil(((360n) - 5p) / (10u)))) * 100n))) + ((((ceil(((360n) - 5p) / (10u))) / 2) - floor((ceil(((360n) - 5p) / (10u))) / 2) == 0) ? (((50n > (((60n) - 0) + 60n) ? 50n : (((60n) - 0) + 60n)) * 120n) + (((360n) / (ceil(((360n) - 5p) / (10u)))) * 50n)) : 0)) / 1 : (((100n > (((60n) - 0) + 80n) ? 100n : (((60n) - 0) + 80n)) * ((360n) / (ceil(((360n) - 5p) / (10u))))) + (floor(((ceil(((360n) - 5p) / (10u))) - 1) / 2.0) * ((60n > (((60n) - 0) + 50n) ? 60n : (((60n) - 0) + 50n)) * ((360n) / (ceil(((360n) - 5p) / (10u)))))) + ((((ceil(((360n) - 5p) / (10u))) / 2) - floor((ceil(((360n) - 5p) / (10u))) / 2) == 0) ? ((100n > (((60n) - 0) + 80n) ? 100n : (((60n) - 0) + 80n)) * ((360n) / (ceil(((360n) - 5p) / (10u))))) : 0)) / 1 / (((360n) / (ceil(((360n) - 5p) / (10u)))) * (ceil(((360n) - 5p) / (10u))) * ((360n) / (ceil(((360n) - 5p) / (10u)))) * (ceil(((360n) - 5p) / (10u))))           sa=(((360n) / (ceil(((360n) - 5p) / (10u)))) < 119.5n) ? (50n > (((60n) - 0) + 60n) ? 50n : (((60n) - 0) + 60n)) + 5e-08 : (100n > (((60n) - 0) + 80n) ? 100n : (((60n) - 0) + 80n))           sb=(((360n) / (ceil(((360n) - 5p) / (10u)))) < 119.5n) ? (50n > (((60n) - 0) + 60n) ? 50n : (((60n) - 0) + 60n)) + 5e-08 : (100n > (((60n) - 0) + 80n) ? 100n : (((60n) - 0) + 80n))           sd=(((360n) / (ceil(((360n) - 5p) / (10u)))) < 119.5n) ? (((60n) - 0) + 60n) + (2*5e-08) : (60n > (((60n) - 0) + 50n) ? 60n : (((60n) - 0) + 50n))           sca=(( ((360n) / (ceil(((360n) - 5p) / (10u)))) * ( (((1u) * (1u) / ((((360n) / (ceil(((360n) - 5p) / (10u)))) < 119.5n) ? (50n > (((60n) - 0) + 60n) ? 50n : (((60n) - 0) + 60n)) + 5e-08 : (100n > (((60n) - 0) + 80n) ? 100n : (((60n) - 0) + 80n))+60n)) - ((1u) * (1u) / (((((360n) / (ceil(((360n) - 5p) / (10u)))) < 119.5n) ? (50n > (((60n) - 0) + 60n) ? 50n : (((60n) - 0) + 60n)) + 5e-08 : (100n > (((60n) - 0) + 80n) ? 100n : (((60n) - 0) + 80n))+60n)+(45n)))) + ((1u) * (1u) / ((((360n) / (ceil(((360n) - 5p) / (10u)))) < 119.5n) ? (50n > (((60n) - 0) + 60n) ? 50n : (((60n) - 0) + 60n)) + 5e-08 : (100n > (((60n) - 0) + 80n) ? 100n : (((60n) - 0) + 80n))+60n)) - ((1u) * (1u)/ (((((360n) / (ceil(((360n) - 5p) / (10u)))) < 119.5n) ? (50n > (((60n) - 0) + 60n) ? 50n : (((60n) - 0) + 60n)) + 5e-08 : (100n > (((60n) - 0) + 80n) ? 100n : (((60n) - 0) + 80n))+60n)+(45n))))) + ( (45n) * ( (((1u) * (1u) / (60n)) - ((1u) * (1u) / ((60n)+((360n) / (ceil(((360n) - 5p) / (10u))))))) + ((1u) * (1u) / (60n)) - ((1u) * (1u)/ ((60n)+((360n) / (ceil(((360n) - 5p) / (10u))))))))) / (((360n) / (ceil(((360n) - 5p) / (10u)))) * (45n))           scb=((((360n) / (ceil(((360n) - 5p) / (10u)))) * ((((((360n) / (ceil(((360n) - 5p) / (10u)))) < 119.5n) ? (50n > (((60n) - 0) + 60n) ? 50n : (((60n) - 0) + 60n)) + 5e-08 : (100n > (((60n) - 0) + 80n) ? 100n : (((60n) - 0) + 80n))+60n)/10 + (1u)/100)*exp(-10 * ((((360n) / (ceil(((360n) - 5p) / (10u)))) < 119.5n) ? (50n > (((60n) - 0) + 60n) ? 50n : (((60n) - 0) + 60n)) + 5e-08 : (100n > (((60n) - 0) + 80n) ? 100n : (((60n) - 0) + 80n))+60n) / (1u)) - ((((((360n) / (ceil(((360n) - 5p) / (10u)))) < 119.5n) ? (50n > (((60n) - 0) + 60n) ? 50n : (((60n) - 0) + 60n)) + 5e-08 : (100n > (((60n) - 0) + 80n) ? 100n : (((60n) - 0) + 80n))+60n)+(45n))/10 + (1u)/100)*exp(-10 * (((((360n) / (ceil(((360n) - 5p) / (10u)))) < 119.5n) ? (50n > (((60n) - 0) + 60n) ? 50n : (((60n) - 0) + 60n)) + 5e-08 : (100n > (((60n) - 0) + 80n) ? 100n : (((60n) - 0) + 80n))+60n)+(45n)) / (1u)) + (((((360n) / (ceil(((360n) - 5p) / (10u)))) < 119.5n) ? (50n > (((60n) - 0) + 60n) ? 50n : (((60n) - 0) + 60n)) + 5e-08 : (100n > (((60n) - 0) + 80n) ? 100n : (((60n) - 0) + 80n))+60n)/10 + (1u)/100)*exp(-10 * ((((360n) / (ceil(((360n) - 5p) / (10u)))) < 119.5n) ? (50n > (((60n) - 0) + 60n) ? 50n : (((60n) - 0) + 60n)) + 5e-08 : (100n > (((60n) - 0) + 80n) ? 100n : (((60n) - 0) + 80n))+60n) / (1u)) - ((((((360n) / (ceil(((360n) - 5p) / (10u)))) < 119.5n) ? (50n > (((60n) - 0) + 60n) ? 50n : (((60n) - 0) + 60n)) + 5e-08 : (100n > (((60n) - 0) + 80n) ? 100n : (((60n) - 0) + 80n))+60n)+(45n))/10 + (1u)/100)*exp(-10 * (((((360n) / (ceil(((360n) - 5p) / (10u)))) < 119.5n) ? (50n > (((60n) - 0) + 60n) ? 50n : (((60n) - 0) + 60n)) + 5e-08 : (100n > (((60n) - 0) + 80n) ? 100n : (((60n) - 0) + 80n))+60n)+(45n)) / (1u)))) + ((45n) * (((60n)/10 + (1u)/100)*exp(-10 * (60n) / (1u)) - (((60n)+((360n) / (ceil(((360n) - 5p) / (10u)))))/10 + (1u)/100)*exp(-10 * ((60n)+((360n) / (ceil(((360n) - 5p) / (10u))))) / (1u)) + ((60n)/10 + (1u)/100)*exp(-10 * (60n) / (1u)) - (((60n)+((360n) / (ceil(((360n) - 5p) / (10u)))))/10 + (1u)/100)*exp(-10 * ((60n)+((360n) / (ceil(((360n) - 5p) / (10u))))) / (1u))))) / (((360n) / (ceil(((360n) - 5p) / (10u)))) * (45n))           scc=((((360n) / (ceil(((360n) - 5p) / (10u)))) * ((((((360n) / (ceil(((360n) - 5p) / (10u)))) < 119.5n) ? (50n > (((60n) - 0) + 60n) ? 50n : (((60n) - 0) + 60n)) + 5e-08 : (100n > (((60n) - 0) + 80n) ? 100n : (((60n) - 0) + 80n))+60n)/20 + (1u)/400)*exp(-20 * ((((360n) / (ceil(((360n) - 5p) / (10u)))) < 119.5n) ? (50n > (((60n) - 0) + 60n) ? 50n : (((60n) - 0) + 60n)) + 5e-08 : (100n > (((60n) - 0) + 80n) ? 100n : (((60n) - 0) + 80n))+60n) / (1u)) - ((((((360n) / (ceil(((360n) - 5p) / (10u)))) < 119.5n) ? (50n > (((60n) - 0) + 60n) ? 50n : (((60n) - 0) + 60n)) + 5e-08 : (100n > (((60n) - 0) + 80n) ? 100n : (((60n) - 0) + 80n))+60n)+(45n))/20 + (1u)/400)*exp(-20 * (((((360n) / (ceil(((360n) - 5p) / (10u)))) < 119.5n) ? (50n > (((60n) - 0) + 60n) ? 50n : (((60n) - 0) + 60n)) + 5e-08 : (100n > (((60n) - 0) + 80n) ? 100n : (((60n) - 0) + 80n))+60n)+(45n)) / (1u)) + (((((360n) / (ceil(((360n) - 5p) / (10u)))) < 119.5n) ? (50n > (((60n) - 0) + 60n) ? 50n : (((60n) - 0) + 60n)) + 5e-08 : (100n > (((60n) - 0) + 80n) ? 100n : (((60n) - 0) + 80n))+60n)/20 + (1u)/400)*exp(-20 * ((((360n) / (ceil(((360n) - 5p) / (10u)))) < 119.5n) ? (50n > (((60n) - 0) + 60n) ? 50n : (((60n) - 0) + 60n)) + 5e-08 : (100n > (((60n) - 0) + 80n) ? 100n : (((60n) - 0) + 80n))+60n) / (1u)) - ((((((360n) / (ceil(((360n) - 5p) / (10u)))) < 119.5n) ? (50n > (((60n) - 0) + 60n) ? 50n : (((60n) - 0) + 60n)) + 5e-08 : (100n > (((60n) - 0) + 80n) ? 100n : (((60n) - 0) + 80n))+60n)+(45n))/20 + (1u)/400)*exp(-20 * (((((360n) / (ceil(((360n) - 5p) / (10u)))) < 119.5n) ? (50n > (((60n) - 0) + 60n) ? 50n : (((60n) - 0) + 60n)) + 5e-08 : (100n > (((60n) - 0) + 80n) ? 100n : (((60n) - 0) + 80n))+60n)+(45n)) / (1u)))) + ((45n) * (((60n)/20 + (1u)/400)*exp(-20 * (60n) / (1u)) - (((60n)+((360n) / (ceil(((360n) - 5p) / (10u)))))/20 + (1u)/400)*exp(-20 * ((60n)+((360n) / (ceil(((360n) - 5p) / (10u))))) / (1u)) + ((60n)/20 + (1u)/400)*exp(-20 * (60n) / (1u)) - (((60n)+((360n) / (ceil(((360n) - 5p) / (10u)))))/20 + (1u)/400)*exp(-20 * ((60n)+((360n) / (ceil(((360n) - 5p) / (10u))))) / (1u))))) / (((360n) / (ceil(((360n) - 5p) / (10u)))) * (45n))           m=(1)
NM2 (Q_bar WL BL_bar GND) g45n1svt w=(240n) l=45n nf=ceil(((240n) - 5p) / (10u))           as=(((240n) / (ceil(((240n) - 5p) / (10u)))) < 119.5n) ? ((((50n > (((60n) - 0) + 60n) ? 50n : (((60n) - 0) + 60n)) * 120n) + (((240n) / (ceil(((240n) - 5p) / (10u)))) * 50n)) + (floor(((ceil(((240n) - 5p) / (10u))) - 1) / 2.0) * (((((60n) - 0) + 60n) * 120n) + (((240n) / (ceil(((240n) - 5p) / (10u)))) * 100n))) + ((((ceil(((240n) - 5p) / (10u))) / 2) - floor((ceil(((240n) - 5p) / (10u))) / 2) == 0) ? (((50n > (((60n) - 0) + 60n) ? 50n : (((60n) - 0) + 60n)) * 120n) + (((240n) / (ceil(((240n) - 5p) / (10u)))) * 50n)) : 0)) / 1 : (((100n > (((60n) - 0) + 80n) ? 100n : (((60n) - 0) + 80n)) * ((240n) / (ceil(((240n) - 5p) / (10u))))) + (floor(((ceil(((240n) - 5p) / (10u))) - 1) / 2.0) * ((60n > (((60n) - 0) + 50n) ? 60n : (((60n) - 0) + 50n)) * ((240n) / (ceil(((240n) - 5p) / (10u)))))) + ((((ceil(((240n) - 5p) / (10u))) / 2) - floor((ceil(((240n) - 5p) / (10u))) / 2) == 0) ? ((100n > (((60n) - 0) + 80n) ? 100n : (((60n) - 0) + 80n)) * ((240n) / (ceil(((240n) - 5p) / (10u))))) : 0)) / 1           ad=(((240n) / (ceil(((240n) - 5p) / (10u)))) < 119.5n) ? ((floor((ceil(((240n) - 5p) / (10u))) / 2.0) * (((((60n) - 0) + 60n) * 120n) + (((240n) / (ceil(((240n) - 5p) / (10u)))) * 100n))) + ((((ceil(((240n) - 5p) / (10u))) / 2) - floor((ceil(((240n) - 5p) / (10u))) / 2) != 0) ? (((50n > (((60n) - 0) + 60n) ? 50n : (((60n) - 0) + 60n)) * 120n) + (((240n) / (ceil(((240n) - 5p) / (10u)))) * 50n)) : 0)) / 1 : ((floor((ceil(((240n) - 5p) / (10u))) / 2.0) * ((60n > (((60n) - 0) + 50n) ? 60n : (((60n) - 0) + 50n)) * ((240n) / (ceil(((240n) - 5p) / (10u)))))) + ((((ceil(((240n) - 5p) / (10u))) / 2) - floor((ceil(((240n) - 5p) / (10u))) / 2) != 0) ? ((100n > (((60n) - 0) + 80n) ? 100n : (((60n) - 0) + 80n)) * ((240n) / (ceil(((240n) - 5p) / (10u))))) : 0)) / 1           ps=(((240n) / (ceil(((240n) - 5p) / (10u)))) < 119.5n) ? (((2 * (50n > (((60n) - 0) + 60n) ? 50n : (((60n) - 0) + 60n))) + 340n) + (floor(((ceil(((240n) - 5p) / (10u))) - 1) / 2.0) * ((2 * (((60n) - 0) + 60n)) + 440n)) + ((((ceil(((240n) - 5p) / (10u))) / 2) - floor((ceil(((240n) - 5p) / (10u))) / 2) == 0) ? ((2 * (50n > (((60n) - 0) + 60n) ? 50n : (((60n) - 0) + 60n))) + 340n) : 0)) / 1 : (((2 * (100n > (((60n) - 0) + 80n) ? 100n : (((60n) - 0) + 80n))) + (2 * ((240n) / (ceil(((240n) - 5p) / (10u)))))) + (floor(((ceil(((240n) - 5p) / (10u))) - 1) / 2.0) * ((2 * (60n > (((60n) - 0) + 50n) ? 60n : (((60n) - 0) + 50n))) + (2 * ((240n) / (ceil(((240n) - 5p) / (10u))))))) + ((((ceil(((240n) - 5p) / (10u))) / 2) - floor((ceil(((240n) - 5p) / (10u))) / 2) == 0) ? ((2 * (100n > (((60n) - 0) + 80n) ? 100n : (((60n) - 0) + 80n))) + (2 * ((240n) / (ceil(((240n) - 5p) / (10u)))))) : 0)) / 1           pd=(((240n) / (ceil(((240n) - 5p) / (10u)))) < 119.5n) ? ((floor((ceil(((240n) - 5p) / (10u))) / 2.0) * ((2 * (((60n) - 0) + 60n)) + 440n)) + ((((ceil(((240n) - 5p) / (10u))) / 2) - floor((ceil(((240n) - 5p) / (10u))) / 2) != 0) ? ((2 * (50n > (((60n) - 0) + 60n) ? 50n : (((60n) - 0) + 60n))) + 340n) : 0)) / 1 : ((floor((ceil(((240n) - 5p) / (10u))) / 2.0) * ((2 * (60n > (((60n) - 0) + 50n) ? 60n : (((60n) - 0) + 50n))) + (2 * ((240n) / (ceil(((240n) - 5p) / (10u))))))) + ((((ceil(((240n) - 5p) / (10u))) / 2) - floor((ceil(((240n) - 5p) / (10u))) / 2) != 0) ? ((2 * (100n > (((60n) - 0) + 80n) ? 100n : (((60n) - 0) + 80n))) + (2 * ((240n) / (ceil(((240n) - 5p) / (10u)))))) : 0)) / 1           nrd=(((240n) / (ceil(((240n) - 5p) / (10u)))) < 119.5n) ? ((floor((ceil(((240n) - 5p) / (10u))) / 2.0) * (((((60n) - 0) + 60n) * 120n) + (((240n) / (ceil(((240n) - 5p) / (10u)))) * 100n))) + ((((ceil(((240n) - 5p) / (10u))) / 2) - floor((ceil(((240n) - 5p) / (10u))) / 2) != 0) ? (((50n > (((60n) - 0) + 60n) ? 50n : (((60n) - 0) + 60n)) * 120n) + (((240n) / (ceil(((240n) - 5p) / (10u)))) * 50n)) : 0)) / 1 : ((floor((ceil(((240n) - 5p) / (10u))) / 2.0) * ((60n > (((60n) - 0) + 50n) ? 60n : (((60n) - 0) + 50n)) * ((240n) / (ceil(((240n) - 5p) / (10u)))))) + ((((ceil(((240n) - 5p) / (10u))) / 2) - floor((ceil(((240n) - 5p) / (10u))) / 2) != 0) ? ((100n > (((60n) - 0) + 80n) ? 100n : (((60n) - 0) + 80n)) * ((240n) / (ceil(((240n) - 5p) / (10u))))) : 0)) / 1 / (((240n) / (ceil(((240n) - 5p) / (10u)))) * (ceil(((240n) - 5p) / (10u))) * ((240n) / (ceil(((240n) - 5p) / (10u)))) * (ceil(((240n) - 5p) / (10u))))           nrs=(((240n) / (ceil(((240n) - 5p) / (10u)))) < 119.5n) ? ((((50n > (((60n) - 0) + 60n) ? 50n : (((60n) - 0) + 60n)) * 120n) + (((240n) / (ceil(((240n) - 5p) / (10u)))) * 50n)) + (floor(((ceil(((240n) - 5p) / (10u))) - 1) / 2.0) * (((((60n) - 0) + 60n) * 120n) + (((240n) / (ceil(((240n) - 5p) / (10u)))) * 100n))) + ((((ceil(((240n) - 5p) / (10u))) / 2) - floor((ceil(((240n) - 5p) / (10u))) / 2) == 0) ? (((50n > (((60n) - 0) + 60n) ? 50n : (((60n) - 0) + 60n)) * 120n) + (((240n) / (ceil(((240n) - 5p) / (10u)))) * 50n)) : 0)) / 1 : (((100n > (((60n) - 0) + 80n) ? 100n : (((60n) - 0) + 80n)) * ((240n) / (ceil(((240n) - 5p) / (10u))))) + (floor(((ceil(((240n) - 5p) / (10u))) - 1) / 2.0) * ((60n > (((60n) - 0) + 50n) ? 60n : (((60n) - 0) + 50n)) * ((240n) / (ceil(((240n) - 5p) / (10u)))))) + ((((ceil(((240n) - 5p) / (10u))) / 2) - floor((ceil(((240n) - 5p) / (10u))) / 2) == 0) ? ((100n > (((60n) - 0) + 80n) ? 100n : (((60n) - 0) + 80n)) * ((240n) / (ceil(((240n) - 5p) / (10u))))) : 0)) / 1 / (((240n) / (ceil(((240n) - 5p) / (10u)))) * (ceil(((240n) - 5p) / (10u))) * ((240n) / (ceil(((240n) - 5p) / (10u)))) * (ceil(((240n) - 5p) / (10u))))           sa=(((240n) / (ceil(((240n) - 5p) / (10u)))) < 119.5n) ? (50n > (((60n) - 0) + 60n) ? 50n : (((60n) - 0) + 60n)) + 5e-08 : (100n > (((60n) - 0) + 80n) ? 100n : (((60n) - 0) + 80n))           sb=(((240n) / (ceil(((240n) - 5p) / (10u)))) < 119.5n) ? (50n > (((60n) - 0) + 60n) ? 50n : (((60n) - 0) + 60n)) + 5e-08 : (100n > (((60n) - 0) + 80n) ? 100n : (((60n) - 0) + 80n))           sd=(((240n) / (ceil(((240n) - 5p) / (10u)))) < 119.5n) ? (((60n) - 0) + 60n) + (2*5e-08) : (60n > (((60n) - 0) + 50n) ? 60n : (((60n) - 0) + 50n))           sca=(( ((240n) / (ceil(((240n) - 5p) / (10u)))) * ( (((1u) * (1u) / ((((240n) / (ceil(((240n) - 5p) / (10u)))) < 119.5n) ? (50n > (((60n) - 0) + 60n) ? 50n : (((60n) - 0) + 60n)) + 5e-08 : (100n > (((60n) - 0) + 80n) ? 100n : (((60n) - 0) + 80n))+60n)) - ((1u) * (1u) / (((((240n) / (ceil(((240n) - 5p) / (10u)))) < 119.5n) ? (50n > (((60n) - 0) + 60n) ? 50n : (((60n) - 0) + 60n)) + 5e-08 : (100n > (((60n) - 0) + 80n) ? 100n : (((60n) - 0) + 80n))+60n)+(45n)))) + ((1u) * (1u) / ((((240n) / (ceil(((240n) - 5p) / (10u)))) < 119.5n) ? (50n > (((60n) - 0) + 60n) ? 50n : (((60n) - 0) + 60n)) + 5e-08 : (100n > (((60n) - 0) + 80n) ? 100n : (((60n) - 0) + 80n))+60n)) - ((1u) * (1u)/ (((((240n) / (ceil(((240n) - 5p) / (10u)))) < 119.5n) ? (50n > (((60n) - 0) + 60n) ? 50n : (((60n) - 0) + 60n)) + 5e-08 : (100n > (((60n) - 0) + 80n) ? 100n : (((60n) - 0) + 80n))+60n)+(45n))))) + ( (45n) * ( (((1u) * (1u) / (60n)) - ((1u) * (1u) / ((60n)+((240n) / (ceil(((240n) - 5p) / (10u))))))) + ((1u) * (1u) / (60n)) - ((1u) * (1u)/ ((60n)+((240n) / (ceil(((240n) - 5p) / (10u))))))))) / (((240n) / (ceil(((240n) - 5p) / (10u)))) * (45n))           scb=((((240n) / (ceil(((240n) - 5p) / (10u)))) * ((((((240n) / (ceil(((240n) - 5p) / (10u)))) < 119.5n) ? (50n > (((60n) - 0) + 60n) ? 50n : (((60n) - 0) + 60n)) + 5e-08 : (100n > (((60n) - 0) + 80n) ? 100n : (((60n) - 0) + 80n))+60n)/10 + (1u)/100)*exp(-10 * ((((240n) / (ceil(((240n) - 5p) / (10u)))) < 119.5n) ? (50n > (((60n) - 0) + 60n) ? 50n : (((60n) - 0) + 60n)) + 5e-08 : (100n > (((60n) - 0) + 80n) ? 100n : (((60n) - 0) + 80n))+60n) / (1u)) - ((((((240n) / (ceil(((240n) - 5p) / (10u)))) < 119.5n) ? (50n > (((60n) - 0) + 60n) ? 50n : (((60n) - 0) + 60n)) + 5e-08 : (100n > (((60n) - 0) + 80n) ? 100n : (((60n) - 0) + 80n))+60n)+(45n))/10 + (1u)/100)*exp(-10 * (((((240n) / (ceil(((240n) - 5p) / (10u)))) < 119.5n) ? (50n > (((60n) - 0) + 60n) ? 50n : (((60n) - 0) + 60n)) + 5e-08 : (100n > (((60n) - 0) + 80n) ? 100n : (((60n) - 0) + 80n))+60n)+(45n)) / (1u)) + (((((240n) / (ceil(((240n) - 5p) / (10u)))) < 119.5n) ? (50n > (((60n) - 0) + 60n) ? 50n : (((60n) - 0) + 60n)) + 5e-08 : (100n > (((60n) - 0) + 80n) ? 100n : (((60n) - 0) + 80n))+60n)/10 + (1u)/100)*exp(-10 * ((((240n) / (ceil(((240n) - 5p) / (10u)))) < 119.5n) ? (50n > (((60n) - 0) + 60n) ? 50n : (((60n) - 0) + 60n)) + 5e-08 : (100n > (((60n) - 0) + 80n) ? 100n : (((60n) - 0) + 80n))+60n) / (1u)) - ((((((240n) / (ceil(((240n) - 5p) / (10u)))) < 119.5n) ? (50n > (((60n) - 0) + 60n) ? 50n : (((60n) - 0) + 60n)) + 5e-08 : (100n > (((60n) - 0) + 80n) ? 100n : (((60n) - 0) + 80n))+60n)+(45n))/10 + (1u)/100)*exp(-10 * (((((240n) / (ceil(((240n) - 5p) / (10u)))) < 119.5n) ? (50n > (((60n) - 0) + 60n) ? 50n : (((60n) - 0) + 60n)) + 5e-08 : (100n > (((60n) - 0) + 80n) ? 100n : (((60n) - 0) + 80n))+60n)+(45n)) / (1u)))) + ((45n) * (((60n)/10 + (1u)/100)*exp(-10 * (60n) / (1u)) - (((60n)+((240n) / (ceil(((240n) - 5p) / (10u)))))/10 + (1u)/100)*exp(-10 * ((60n)+((240n) / (ceil(((240n) - 5p) / (10u))))) / (1u)) + ((60n)/10 + (1u)/100)*exp(-10 * (60n) / (1u)) - (((60n)+((240n) / (ceil(((240n) - 5p) / (10u)))))/10 + (1u)/100)*exp(-10 * ((60n)+((240n) / (ceil(((240n) - 5p) / (10u))))) / (1u))))) / (((240n) / (ceil(((240n) - 5p) / (10u)))) * (45n))           scc=((((240n) / (ceil(((240n) - 5p) / (10u)))) * ((((((240n) / (ceil(((240n) - 5p) / (10u)))) < 119.5n) ? (50n > (((60n) - 0) + 60n) ? 50n : (((60n) - 0) + 60n)) + 5e-08 : (100n > (((60n) - 0) + 80n) ? 100n : (((60n) - 0) + 80n))+60n)/20 + (1u)/400)*exp(-20 * ((((240n) / (ceil(((240n) - 5p) / (10u)))) < 119.5n) ? (50n > (((60n) - 0) + 60n) ? 50n : (((60n) - 0) + 60n)) + 5e-08 : (100n > (((60n) - 0) + 80n) ? 100n : (((60n) - 0) + 80n))+60n) / (1u)) - ((((((240n) / (ceil(((240n) - 5p) / (10u)))) < 119.5n) ? (50n > (((60n) - 0) + 60n) ? 50n : (((60n) - 0) + 60n)) + 5e-08 : (100n > (((60n) - 0) + 80n) ? 100n : (((60n) - 0) + 80n))+60n)+(45n))/20 + (1u)/400)*exp(-20 * (((((240n) / (ceil(((240n) - 5p) / (10u)))) < 119.5n) ? (50n > (((60n) - 0) + 60n) ? 50n : (((60n) - 0) + 60n)) + 5e-08 : (100n > (((60n) - 0) + 80n) ? 100n : (((60n) - 0) + 80n))+60n)+(45n)) / (1u)) + (((((240n) / (ceil(((240n) - 5p) / (10u)))) < 119.5n) ? (50n > (((60n) - 0) + 60n) ? 50n : (((60n) - 0) + 60n)) + 5e-08 : (100n > (((60n) - 0) + 80n) ? 100n : (((60n) - 0) + 80n))+60n)/20 + (1u)/400)*exp(-20 * ((((240n) / (ceil(((240n) - 5p) / (10u)))) < 119.5n) ? (50n > (((60n) - 0) + 60n) ? 50n : (((60n) - 0) + 60n)) + 5e-08 : (100n > (((60n) - 0) + 80n) ? 100n : (((60n) - 0) + 80n))+60n) / (1u)) - ((((((240n) / (ceil(((240n) - 5p) / (10u)))) < 119.5n) ? (50n > (((60n) - 0) + 60n) ? 50n : (((60n) - 0) + 60n)) + 5e-08 : (100n > (((60n) - 0) + 80n) ? 100n : (((60n) - 0) + 80n))+60n)+(45n))/20 + (1u)/400)*exp(-20 * (((((240n) / (ceil(((240n) - 5p) / (10u)))) < 119.5n) ? (50n > (((60n) - 0) + 60n) ? 50n : (((60n) - 0) + 60n)) + 5e-08 : (100n > (((60n) - 0) + 80n) ? 100n : (((60n) - 0) + 80n))+60n)+(45n)) / (1u)))) + ((45n) * (((60n)/20 + (1u)/400)*exp(-20 * (60n) / (1u)) - (((60n)+((240n) / (ceil(((240n) - 5p) / (10u)))))/20 + (1u)/400)*exp(-20 * ((60n)+((240n) / (ceil(((240n) - 5p) / (10u))))) / (1u)) + ((60n)/20 + (1u)/400)*exp(-20 * (60n) / (1u)) - (((60n)+((240n) / (ceil(((240n) - 5p) / (10u)))))/20 + (1u)/400)*exp(-20 * ((60n)+((240n) / (ceil(((240n) - 5p) / (10u))))) / (1u))))) / (((240n) / (ceil(((240n) - 5p) / (10u)))) * (45n))           m=(1)
NM3 (BL WL Q GND) g45n1svt w=(240n) l=45n nf=ceil(((240n) - 5p) / (10u))           as=(((240n) / (ceil(((240n) - 5p) / (10u)))) < 119.5n) ? ((((50n > (((60n) - 0) + 60n) ? 50n : (((60n) - 0) + 60n)) * 120n) + (((240n) / (ceil(((240n) - 5p) / (10u)))) * 50n)) + (floor(((ceil(((240n) - 5p) / (10u))) - 1) / 2.0) * (((((60n) - 0) + 60n) * 120n) + (((240n) / (ceil(((240n) - 5p) / (10u)))) * 100n))) + ((((ceil(((240n) - 5p) / (10u))) / 2) - floor((ceil(((240n) - 5p) / (10u))) / 2) == 0) ? (((50n > (((60n) - 0) + 60n) ? 50n : (((60n) - 0) + 60n)) * 120n) + (((240n) / (ceil(((240n) - 5p) / (10u)))) * 50n)) : 0)) / 1 : (((100n > (((60n) - 0) + 80n) ? 100n : (((60n) - 0) + 80n)) * ((240n) / (ceil(((240n) - 5p) / (10u))))) + (floor(((ceil(((240n) - 5p) / (10u))) - 1) / 2.0) * ((60n > (((60n) - 0) + 50n) ? 60n : (((60n) - 0) + 50n)) * ((240n) / (ceil(((240n) - 5p) / (10u)))))) + ((((ceil(((240n) - 5p) / (10u))) / 2) - floor((ceil(((240n) - 5p) / (10u))) / 2) == 0) ? ((100n > (((60n) - 0) + 80n) ? 100n : (((60n) - 0) + 80n)) * ((240n) / (ceil(((240n) - 5p) / (10u))))) : 0)) / 1           ad=(((240n) / (ceil(((240n) - 5p) / (10u)))) < 119.5n) ? ((floor((ceil(((240n) - 5p) / (10u))) / 2.0) * (((((60n) - 0) + 60n) * 120n) + (((240n) / (ceil(((240n) - 5p) / (10u)))) * 100n))) + ((((ceil(((240n) - 5p) / (10u))) / 2) - floor((ceil(((240n) - 5p) / (10u))) / 2) != 0) ? (((50n > (((60n) - 0) + 60n) ? 50n : (((60n) - 0) + 60n)) * 120n) + (((240n) / (ceil(((240n) - 5p) / (10u)))) * 50n)) : 0)) / 1 : ((floor((ceil(((240n) - 5p) / (10u))) / 2.0) * ((60n > (((60n) - 0) + 50n) ? 60n : (((60n) - 0) + 50n)) * ((240n) / (ceil(((240n) - 5p) / (10u)))))) + ((((ceil(((240n) - 5p) / (10u))) / 2) - floor((ceil(((240n) - 5p) / (10u))) / 2) != 0) ? ((100n > (((60n) - 0) + 80n) ? 100n : (((60n) - 0) + 80n)) * ((240n) / (ceil(((240n) - 5p) / (10u))))) : 0)) / 1           ps=(((240n) / (ceil(((240n) - 5p) / (10u)))) < 119.5n) ? (((2 * (50n > (((60n) - 0) + 60n) ? 50n : (((60n) - 0) + 60n))) + 340n) + (floor(((ceil(((240n) - 5p) / (10u))) - 1) / 2.0) * ((2 * (((60n) - 0) + 60n)) + 440n)) + ((((ceil(((240n) - 5p) / (10u))) / 2) - floor((ceil(((240n) - 5p) / (10u))) / 2) == 0) ? ((2 * (50n > (((60n) - 0) + 60n) ? 50n : (((60n) - 0) + 60n))) + 340n) : 0)) / 1 : (((2 * (100n > (((60n) - 0) + 80n) ? 100n : (((60n) - 0) + 80n))) + (2 * ((240n) / (ceil(((240n) - 5p) / (10u)))))) + (floor(((ceil(((240n) - 5p) / (10u))) - 1) / 2.0) * ((2 * (60n > (((60n) - 0) + 50n) ? 60n : (((60n) - 0) + 50n))) + (2 * ((240n) / (ceil(((240n) - 5p) / (10u))))))) + ((((ceil(((240n) - 5p) / (10u))) / 2) - floor((ceil(((240n) - 5p) / (10u))) / 2) == 0) ? ((2 * (100n > (((60n) - 0) + 80n) ? 100n : (((60n) - 0) + 80n))) + (2 * ((240n) / (ceil(((240n) - 5p) / (10u)))))) : 0)) / 1           pd=(((240n) / (ceil(((240n) - 5p) / (10u)))) < 119.5n) ? ((floor((ceil(((240n) - 5p) / (10u))) / 2.0) * ((2 * (((60n) - 0) + 60n)) + 440n)) + ((((ceil(((240n) - 5p) / (10u))) / 2) - floor((ceil(((240n) - 5p) / (10u))) / 2) != 0) ? ((2 * (50n > (((60n) - 0) + 60n) ? 50n : (((60n) - 0) + 60n))) + 340n) : 0)) / 1 : ((floor((ceil(((240n) - 5p) / (10u))) / 2.0) * ((2 * (60n > (((60n) - 0) + 50n) ? 60n : (((60n) - 0) + 50n))) + (2 * ((240n) / (ceil(((240n) - 5p) / (10u))))))) + ((((ceil(((240n) - 5p) / (10u))) / 2) - floor((ceil(((240n) - 5p) / (10u))) / 2) != 0) ? ((2 * (100n > (((60n) - 0) + 80n) ? 100n : (((60n) - 0) + 80n))) + (2 * ((240n) / (ceil(((240n) - 5p) / (10u)))))) : 0)) / 1           nrd=(((240n) / (ceil(((240n) - 5p) / (10u)))) < 119.5n) ? ((floor((ceil(((240n) - 5p) / (10u))) / 2.0) * (((((60n) - 0) + 60n) * 120n) + (((240n) / (ceil(((240n) - 5p) / (10u)))) * 100n))) + ((((ceil(((240n) - 5p) / (10u))) / 2) - floor((ceil(((240n) - 5p) / (10u))) / 2) != 0) ? (((50n > (((60n) - 0) + 60n) ? 50n : (((60n) - 0) + 60n)) * 120n) + (((240n) / (ceil(((240n) - 5p) / (10u)))) * 50n)) : 0)) / 1 : ((floor((ceil(((240n) - 5p) / (10u))) / 2.0) * ((60n > (((60n) - 0) + 50n) ? 60n : (((60n) - 0) + 50n)) * ((240n) / (ceil(((240n) - 5p) / (10u)))))) + ((((ceil(((240n) - 5p) / (10u))) / 2) - floor((ceil(((240n) - 5p) / (10u))) / 2) != 0) ? ((100n > (((60n) - 0) + 80n) ? 100n : (((60n) - 0) + 80n)) * ((240n) / (ceil(((240n) - 5p) / (10u))))) : 0)) / 1 / (((240n) / (ceil(((240n) - 5p) / (10u)))) * (ceil(((240n) - 5p) / (10u))) * ((240n) / (ceil(((240n) - 5p) / (10u)))) * (ceil(((240n) - 5p) / (10u))))           nrs=(((240n) / (ceil(((240n) - 5p) / (10u)))) < 119.5n) ? ((((50n > (((60n) - 0) + 60n) ? 50n : (((60n) - 0) + 60n)) * 120n) + (((240n) / (ceil(((240n) - 5p) / (10u)))) * 50n)) + (floor(((ceil(((240n) - 5p) / (10u))) - 1) / 2.0) * (((((60n) - 0) + 60n) * 120n) + (((240n) / (ceil(((240n) - 5p) / (10u)))) * 100n))) + ((((ceil(((240n) - 5p) / (10u))) / 2) - floor((ceil(((240n) - 5p) / (10u))) / 2) == 0) ? (((50n > (((60n) - 0) + 60n) ? 50n : (((60n) - 0) + 60n)) * 120n) + (((240n) / (ceil(((240n) - 5p) / (10u)))) * 50n)) : 0)) / 1 : (((100n > (((60n) - 0) + 80n) ? 100n : (((60n) - 0) + 80n)) * ((240n) / (ceil(((240n) - 5p) / (10u))))) + (floor(((ceil(((240n) - 5p) / (10u))) - 1) / 2.0) * ((60n > (((60n) - 0) + 50n) ? 60n : (((60n) - 0) + 50n)) * ((240n) / (ceil(((240n) - 5p) / (10u)))))) + ((((ceil(((240n) - 5p) / (10u))) / 2) - floor((ceil(((240n) - 5p) / (10u))) / 2) == 0) ? ((100n > (((60n) - 0) + 80n) ? 100n : (((60n) - 0) + 80n)) * ((240n) / (ceil(((240n) - 5p) / (10u))))) : 0)) / 1 / (((240n) / (ceil(((240n) - 5p) / (10u)))) * (ceil(((240n) - 5p) / (10u))) * ((240n) / (ceil(((240n) - 5p) / (10u)))) * (ceil(((240n) - 5p) / (10u))))           sa=(((240n) / (ceil(((240n) - 5p) / (10u)))) < 119.5n) ? (50n > (((60n) - 0) + 60n) ? 50n : (((60n) - 0) + 60n)) + 5e-08 : (100n > (((60n) - 0) + 80n) ? 100n : (((60n) - 0) + 80n))           sb=(((240n) / (ceil(((240n) - 5p) / (10u)))) < 119.5n) ? (50n > (((60n) - 0) + 60n) ? 50n : (((60n) - 0) + 60n)) + 5e-08 : (100n > (((60n) - 0) + 80n) ? 100n : (((60n) - 0) + 80n))           sd=(((240n) / (ceil(((240n) - 5p) / (10u)))) < 119.5n) ? (((60n) - 0) + 60n) + (2*5e-08) : (60n > (((60n) - 0) + 50n) ? 60n : (((60n) - 0) + 50n))           sca=(( ((240n) / (ceil(((240n) - 5p) / (10u)))) * ( (((1u) * (1u) / ((((240n) / (ceil(((240n) - 5p) / (10u)))) < 119.5n) ? (50n > (((60n) - 0) + 60n) ? 50n : (((60n) - 0) + 60n)) + 5e-08 : (100n > (((60n) - 0) + 80n) ? 100n : (((60n) - 0) + 80n))+60n)) - ((1u) * (1u) / (((((240n) / (ceil(((240n) - 5p) / (10u)))) < 119.5n) ? (50n > (((60n) - 0) + 60n) ? 50n : (((60n) - 0) + 60n)) + 5e-08 : (100n > (((60n) - 0) + 80n) ? 100n : (((60n) - 0) + 80n))+60n)+(45n)))) + ((1u) * (1u) / ((((240n) / (ceil(((240n) - 5p) / (10u)))) < 119.5n) ? (50n > (((60n) - 0) + 60n) ? 50n : (((60n) - 0) + 60n)) + 5e-08 : (100n > (((60n) - 0) + 80n) ? 100n : (((60n) - 0) + 80n))+60n)) - ((1u) * (1u)/ (((((240n) / (ceil(((240n) - 5p) / (10u)))) < 119.5n) ? (50n > (((60n) - 0) + 60n) ? 50n : (((60n) - 0) + 60n)) + 5e-08 : (100n > (((60n) - 0) + 80n) ? 100n : (((60n) - 0) + 80n))+60n)+(45n))))) + ( (45n) * ( (((1u) * (1u) / (60n)) - ((1u) * (1u) / ((60n)+((240n) / (ceil(((240n) - 5p) / (10u))))))) + ((1u) * (1u) / (60n)) - ((1u) * (1u)/ ((60n)+((240n) / (ceil(((240n) - 5p) / (10u))))))))) / (((240n) / (ceil(((240n) - 5p) / (10u)))) * (45n))           scb=((((240n) / (ceil(((240n) - 5p) / (10u)))) * ((((((240n) / (ceil(((240n) - 5p) / (10u)))) < 119.5n) ? (50n > (((60n) - 0) + 60n) ? 50n : (((60n) - 0) + 60n)) + 5e-08 : (100n > (((60n) - 0) + 80n) ? 100n : (((60n) - 0) + 80n))+60n)/10 + (1u)/100)*exp(-10 * ((((240n) / (ceil(((240n) - 5p) / (10u)))) < 119.5n) ? (50n > (((60n) - 0) + 60n) ? 50n : (((60n) - 0) + 60n)) + 5e-08 : (100n > (((60n) - 0) + 80n) ? 100n : (((60n) - 0) + 80n))+60n) / (1u)) - ((((((240n) / (ceil(((240n) - 5p) / (10u)))) < 119.5n) ? (50n > (((60n) - 0) + 60n) ? 50n : (((60n) - 0) + 60n)) + 5e-08 : (100n > (((60n) - 0) + 80n) ? 100n : (((60n) - 0) + 80n))+60n)+(45n))/10 + (1u)/100)*exp(-10 * (((((240n) / (ceil(((240n) - 5p) / (10u)))) < 119.5n) ? (50n > (((60n) - 0) + 60n) ? 50n : (((60n) - 0) + 60n)) + 5e-08 : (100n > (((60n) - 0) + 80n) ? 100n : (((60n) - 0) + 80n))+60n)+(45n)) / (1u)) + (((((240n) / (ceil(((240n) - 5p) / (10u)))) < 119.5n) ? (50n > (((60n) - 0) + 60n) ? 50n : (((60n) - 0) + 60n)) + 5e-08 : (100n > (((60n) - 0) + 80n) ? 100n : (((60n) - 0) + 80n))+60n)/10 + (1u)/100)*exp(-10 * ((((240n) / (ceil(((240n) - 5p) / (10u)))) < 119.5n) ? (50n > (((60n) - 0) + 60n) ? 50n : (((60n) - 0) + 60n)) + 5e-08 : (100n > (((60n) - 0) + 80n) ? 100n : (((60n) - 0) + 80n))+60n) / (1u)) - ((((((240n) / (ceil(((240n) - 5p) / (10u)))) < 119.5n) ? (50n > (((60n) - 0) + 60n) ? 50n : (((60n) - 0) + 60n)) + 5e-08 : (100n > (((60n) - 0) + 80n) ? 100n : (((60n) - 0) + 80n))+60n)+(45n))/10 + (1u)/100)*exp(-10 * (((((240n) / (ceil(((240n) - 5p) / (10u)))) < 119.5n) ? (50n > (((60n) - 0) + 60n) ? 50n : (((60n) - 0) + 60n)) + 5e-08 : (100n > (((60n) - 0) + 80n) ? 100n : (((60n) - 0) + 80n))+60n)+(45n)) / (1u)))) + ((45n) * (((60n)/10 + (1u)/100)*exp(-10 * (60n) / (1u)) - (((60n)+((240n) / (ceil(((240n) - 5p) / (10u)))))/10 + (1u)/100)*exp(-10 * ((60n)+((240n) / (ceil(((240n) - 5p) / (10u))))) / (1u)) + ((60n)/10 + (1u)/100)*exp(-10 * (60n) / (1u)) - (((60n)+((240n) / (ceil(((240n) - 5p) / (10u)))))/10 + (1u)/100)*exp(-10 * ((60n)+((240n) / (ceil(((240n) - 5p) / (10u))))) / (1u))))) / (((240n) / (ceil(((240n) - 5p) / (10u)))) * (45n))           scc=((((240n) / (ceil(((240n) - 5p) / (10u)))) * ((((((240n) / (ceil(((240n) - 5p) / (10u)))) < 119.5n) ? (50n > (((60n) - 0) + 60n) ? 50n : (((60n) - 0) + 60n)) + 5e-08 : (100n > (((60n) - 0) + 80n) ? 100n : (((60n) - 0) + 80n))+60n)/20 + (1u)/400)*exp(-20 * ((((240n) / (ceil(((240n) - 5p) / (10u)))) < 119.5n) ? (50n > (((60n) - 0) + 60n) ? 50n : (((60n) - 0) + 60n)) + 5e-08 : (100n > (((60n) - 0) + 80n) ? 100n : (((60n) - 0) + 80n))+60n) / (1u)) - ((((((240n) / (ceil(((240n) - 5p) / (10u)))) < 119.5n) ? (50n > (((60n) - 0) + 60n) ? 50n : (((60n) - 0) + 60n)) + 5e-08 : (100n > (((60n) - 0) + 80n) ? 100n : (((60n) - 0) + 80n))+60n)+(45n))/20 + (1u)/400)*exp(-20 * (((((240n) / (ceil(((240n) - 5p) / (10u)))) < 119.5n) ? (50n > (((60n) - 0) + 60n) ? 50n : (((60n) - 0) + 60n)) + 5e-08 : (100n > (((60n) - 0) + 80n) ? 100n : (((60n) - 0) + 80n))+60n)+(45n)) / (1u)) + (((((240n) / (ceil(((240n) - 5p) / (10u)))) < 119.5n) ? (50n > (((60n) - 0) + 60n) ? 50n : (((60n) - 0) + 60n)) + 5e-08 : (100n > (((60n) - 0) + 80n) ? 100n : (((60n) - 0) + 80n))+60n)/20 + (1u)/400)*exp(-20 * ((((240n) / (ceil(((240n) - 5p) / (10u)))) < 119.5n) ? (50n > (((60n) - 0) + 60n) ? 50n : (((60n) - 0) + 60n)) + 5e-08 : (100n > (((60n) - 0) + 80n) ? 100n : (((60n) - 0) + 80n))+60n) / (1u)) - ((((((240n) / (ceil(((240n) - 5p) / (10u)))) < 119.5n) ? (50n > (((60n) - 0) + 60n) ? 50n : (((60n) - 0) + 60n)) + 5e-08 : (100n > (((60n) - 0) + 80n) ? 100n : (((60n) - 0) + 80n))+60n)+(45n))/20 + (1u)/400)*exp(-20 * (((((240n) / (ceil(((240n) - 5p) / (10u)))) < 119.5n) ? (50n > (((60n) - 0) + 60n) ? 50n : (((60n) - 0) + 60n)) + 5e-08 : (100n > (((60n) - 0) + 80n) ? 100n : (((60n) - 0) + 80n))+60n)+(45n)) / (1u)))) + ((45n) * (((60n)/20 + (1u)/400)*exp(-20 * (60n) / (1u)) - (((60n)+((240n) / (ceil(((240n) - 5p) / (10u)))))/20 + (1u)/400)*exp(-20 * ((60n)+((240n) / (ceil(((240n) - 5p) / (10u))))) / (1u)) + ((60n)/20 + (1u)/400)*exp(-20 * (60n) / (1u)) - (((60n)+((240n) / (ceil(((240n) - 5p) / (10u)))))/20 + (1u)/400)*exp(-20 * ((60n)+((240n) / (ceil(((240n) - 5p) / (10u))))) / (1u))))) / (((240n) / (ceil(((240n) - 5p) / (10u)))) * (45n))           m=(1)
ends sram_cell
Xcell (BL BL_bar WL Q Q_bar Vdd 0) sram_cell
VWL (WL 0) vsource type=pwl wave=[0n (0*vdd) 2n (0*vdd) 2.1n (1*vdd) 5n (1*vdd) 5.1n (0*vdd) 12n (0*vdd) 12.1n (1*vdd) 15n (1*vdd) 15.1n (0*vdd) 22n (0*vdd) 22.1n (1*vdd) 25n (1*vdd) 25.1n (0*vdd) 32n (0*vdd) 32.1n (1*vdd) 35n (1*vdd) 35.1n (0*vdd) 42n (0*vdd) 42.1n (1*vdd) 45n (1*vdd) 45.1n (0*vdd) 52n (0*vdd) 52.1n (1*vdd) 55n (1*vdd) 55.1n (0*vdd) 62n (0*vdd) 62.1n (1*vdd) 65n (1*vdd) 65.1n (0*vdd) 72n (0*vdd) 72.1n (1*vdd) 75n (1*vdd) 75.1n (0*vdd) 82n (0*vdd) 82.1n (1*vdd) 85n (1*vdd) 85.1n (0*vdd) 92n (0*vdd) 92.1n (1*vdd) 95n (1*vdd) 95.1n (0*vdd) 102n (0*vdd) 102.1n (1*vdd) 105n (1*vdd) 105.1n (0*vdd) 112n (0*vdd) 112.1n (1*vdd) 115n (1*vdd) 115.1n (0*vdd) 122n (0*vdd) 122.1n (1*vdd) 125n (1*vdd) 125.1n (0*vdd) 132n (0*vdd) 132.1n (1*vdd) 135n (1*vdd) 135.1n (0*vdd) 142n (0*vdd) 142.1n (1*vdd) 145n (1*vdd) 145.1n (0*vdd) 152n (0*vdd) 152.1n (1*vdd) 155n (1*vdd) 155.1n (0*vdd) 160n (0*vdd)]
VWEN (WEN 0) vsource type=pwl wave=[0n (0*vdd) 1n (0*vdd) 1.1n (1*vdd) 5n (1*vdd) 5.1n (0*vdd) 21n (0*vdd) 21.1n (1*vdd) 25n (1*vdd) 25.1n (0*vdd) 41n (0*vdd) 41.1n (1*vdd) 45n (1*vdd) 45.1n (0*vdd) 61n (0*vdd) 61.1n (1*vdd) 65n (1*vdd) 65.1n (0*vdd) 81n (0*vdd) 81.1n (1*vdd) 85n (1*vdd) 85.1n (0*vdd) 101n (0*vdd) 101.1n (1*vdd) 105n (1*vdd) 105.1n (0*vdd) 121n (0*vdd) 121.1n (1*vdd) 125n (1*vdd) 125.1n (0*vdd) 141n (0*vdd) 141.1n (1*vdd) 145n (1*vdd) 145.1n (0*vdd) 160n (0*vdd)]
VDIN (DIN 0) vsource type=pwl wave=[0n (0*vdd) 0.2n (0*vdd) 0.3n (1*vdd) 20.2n (1*vdd) 20.3n (0*vdd) 40.2n (0*vdd) 40.3n (1*vdd) 80.2n (1*vdd) 80.3n (0*vdd) 120.2n (0*vdd) 120.3n (1*vdd) 140.2n (1*vdd) 140.3n (0*vdd) 160n (0*vdd)]
VPREb (PREb 0) vsource type=pwl wave=[0n (0*vdd) 0.5n (0*vdd) 0.6n (1*vdd) 9n (1*vdd) 9.1n (0*vdd) 11n (0*vdd) 11.1n (1*vdd) 29n (1*vdd) 29.1n (0*vdd) 31n (0*vdd) 31.1n (1*vdd) 49n (1*vdd) 49.1n (0*vdd) 51n (0*vdd) 51.1n (1*vdd) 69n (1*vdd) 69.1n (0*vdd) 71n (0*vdd) 71.1n (1*vdd) 89n (1*vdd) 89.1n (0*vdd) 91n (0*vdd) 91.1n (1*vdd) 109n (1*vdd) 109.1n (0*vdd) 111n (0*vdd) 111.1n (1*vdd) 129n (1*vdd) 129.1n (0*vdd) 131n (0*vdd) 131.1n (1*vdd) 149n (1*vdd) 149.1n (0*vdd) 151n (0*vdd) 151.1n (1*vdd) 160n (1*vdd)]
Ewenb (WENb 0 Vdd WEN) vcvs gain=1
Edinb (DINb 0 Vdd DIN) vcvs gain=1
WnBL (BL WEN DIN 0) g45n1svt w=(1000n) l=45n nf=ceil(((1000n) - 5p) / (10u))           as=(((1000n) / (ceil(((1000n) - 5p) / (10u)))) < 119.5n) ? ((((50n > (((60n) - 0) + 60n) ? 50n : (((60n) - 0) + 60n)) * 120n) + (((1000n) / (ceil(((1000n) - 5p) / (10u)))) * 50n)) + (floor(((ceil(((1000n) - 5p) / (10u))) - 1) / 2.0) * (((((60n) - 0) + 60n) * 120n) + (((1000n) / (ceil(((1000n) - 5p) / (10u)))) * 100n))) + ((((ceil(((1000n) - 5p) / (10u))) / 2) - floor((ceil(((1000n) - 5p) / (10u))) / 2) == 0) ? (((50n > (((60n) - 0) + 60n) ? 50n : (((60n) - 0) + 60n)) * 120n) + (((1000n) / (ceil(((1000n) - 5p) / (10u)))) * 50n)) : 0)) / 1 : (((100n > (((60n) - 0) + 80n) ? 100n : (((60n) - 0) + 80n)) * ((1000n) / (ceil(((1000n) - 5p) / (10u))))) + (floor(((ceil(((1000n) - 5p) / (10u))) - 1) / 2.0) * ((60n > (((60n) - 0) + 50n) ? 60n : (((60n) - 0) + 50n)) * ((1000n) / (ceil(((1000n) - 5p) / (10u)))))) + ((((ceil(((1000n) - 5p) / (10u))) / 2) - floor((ceil(((1000n) - 5p) / (10u))) / 2) == 0) ? ((100n > (((60n) - 0) + 80n) ? 100n : (((60n) - 0) + 80n)) * ((1000n) / (ceil(((1000n) - 5p) / (10u))))) : 0)) / 1           ad=(((1000n) / (ceil(((1000n) - 5p) / (10u)))) < 119.5n) ? ((floor((ceil(((1000n) - 5p) / (10u))) / 2.0) * (((((60n) - 0) + 60n) * 120n) + (((1000n) / (ceil(((1000n) - 5p) / (10u)))) * 100n))) + ((((ceil(((1000n) - 5p) / (10u))) / 2) - floor((ceil(((1000n) - 5p) / (10u))) / 2) != 0) ? (((50n > (((60n) - 0) + 60n) ? 50n : (((60n) - 0) + 60n)) * 120n) + (((1000n) / (ceil(((1000n) - 5p) / (10u)))) * 50n)) : 0)) / 1 : ((floor((ceil(((1000n) - 5p) / (10u))) / 2.0) * ((60n > (((60n) - 0) + 50n) ? 60n : (((60n) - 0) + 50n)) * ((1000n) / (ceil(((1000n) - 5p) / (10u)))))) + ((((ceil(((1000n) - 5p) / (10u))) / 2) - floor((ceil(((1000n) - 5p) / (10u))) / 2) != 0) ? ((100n > (((60n) - 0) + 80n) ? 100n : (((60n) - 0) + 80n)) * ((1000n) / (ceil(((1000n) - 5p) / (10u))))) : 0)) / 1           ps=(((1000n) / (ceil(((1000n) - 5p) / (10u)))) < 119.5n) ? (((2 * (50n > (((60n) - 0) + 60n) ? 50n : (((60n) - 0) + 60n))) + 340n) + (floor(((ceil(((1000n) - 5p) / (10u))) - 1) / 2.0) * ((2 * (((60n) - 0) + 60n)) + 440n)) + ((((ceil(((1000n) - 5p) / (10u))) / 2) - floor((ceil(((1000n) - 5p) / (10u))) / 2) == 0) ? ((2 * (50n > (((60n) - 0) + 60n) ? 50n : (((60n) - 0) + 60n))) + 340n) : 0)) / 1 : (((2 * (100n > (((60n) - 0) + 80n) ? 100n : (((60n) - 0) + 80n))) + (2 * ((1000n) / (ceil(((1000n) - 5p) / (10u)))))) + (floor(((ceil(((1000n) - 5p) / (10u))) - 1) / 2.0) * ((2 * (60n > (((60n) - 0) + 50n) ? 60n : (((60n) - 0) + 50n))) + (2 * ((1000n) / (ceil(((1000n) - 5p) / (10u))))))) + ((((ceil(((1000n) - 5p) / (10u))) / 2) - floor((ceil(((1000n) - 5p) / (10u))) / 2) == 0) ? ((2 * (100n > (((60n) - 0) + 80n) ? 100n : (((60n) - 0) + 80n))) + (2 * ((1000n) / (ceil(((1000n) - 5p) / (10u)))))) : 0)) / 1           pd=(((1000n) / (ceil(((1000n) - 5p) / (10u)))) < 119.5n) ? ((floor((ceil(((1000n) - 5p) / (10u))) / 2.0) * ((2 * (((60n) - 0) + 60n)) + 440n)) + ((((ceil(((1000n) - 5p) / (10u))) / 2) - floor((ceil(((1000n) - 5p) / (10u))) / 2) != 0) ? ((2 * (50n > (((60n) - 0) + 60n) ? 50n : (((60n) - 0) + 60n))) + 340n) : 0)) / 1 : ((floor((ceil(((1000n) - 5p) / (10u))) / 2.0) * ((2 * (60n > (((60n) - 0) + 50n) ? 60n : (((60n) - 0) + 50n))) + (2 * ((1000n) / (ceil(((1000n) - 5p) / (10u))))))) + ((((ceil(((1000n) - 5p) / (10u))) / 2) - floor((ceil(((1000n) - 5p) / (10u))) / 2) != 0) ? ((2 * (100n > (((60n) - 0) + 80n) ? 100n : (((60n) - 0) + 80n))) + (2 * ((1000n) / (ceil(((1000n) - 5p) / (10u)))))) : 0)) / 1           nrd=(((1000n) / (ceil(((1000n) - 5p) / (10u)))) < 119.5n) ? ((floor((ceil(((1000n) - 5p) / (10u))) / 2.0) * (((((60n) - 0) + 60n) * 120n) + (((1000n) / (ceil(((1000n) - 5p) / (10u)))) * 100n))) + ((((ceil(((1000n) - 5p) / (10u))) / 2) - floor((ceil(((1000n) - 5p) / (10u))) / 2) != 0) ? (((50n > (((60n) - 0) + 60n) ? 50n : (((60n) - 0) + 60n)) * 120n) + (((1000n) / (ceil(((1000n) - 5p) / (10u)))) * 50n)) : 0)) / 1 : ((floor((ceil(((1000n) - 5p) / (10u))) / 2.0) * ((60n > (((60n) - 0) + 50n) ? 60n : (((60n) - 0) + 50n)) * ((1000n) / (ceil(((1000n) - 5p) / (10u)))))) + ((((ceil(((1000n) - 5p) / (10u))) / 2) - floor((ceil(((1000n) - 5p) / (10u))) / 2) != 0) ? ((100n > (((60n) - 0) + 80n) ? 100n : (((60n) - 0) + 80n)) * ((1000n) / (ceil(((1000n) - 5p) / (10u))))) : 0)) / 1 / (((1000n) / (ceil(((1000n) - 5p) / (10u)))) * (ceil(((1000n) - 5p) / (10u))) * ((1000n) / (ceil(((1000n) - 5p) / (10u)))) * (ceil(((1000n) - 5p) / (10u))))           nrs=(((1000n) / (ceil(((1000n) - 5p) / (10u)))) < 119.5n) ? ((((50n > (((60n) - 0) + 60n) ? 50n : (((60n) - 0) + 60n)) * 120n) + (((1000n) / (ceil(((1000n) - 5p) / (10u)))) * 50n)) + (floor(((ceil(((1000n) - 5p) / (10u))) - 1) / 2.0) * (((((60n) - 0) + 60n) * 120n) + (((1000n) / (ceil(((1000n) - 5p) / (10u)))) * 100n))) + ((((ceil(((1000n) - 5p) / (10u))) / 2) - floor((ceil(((1000n) - 5p) / (10u))) / 2) == 0) ? (((50n > (((60n) - 0) + 60n) ? 50n : (((60n) - 0) + 60n)) * 120n) + (((1000n) / (ceil(((1000n) - 5p) / (10u)))) * 50n)) : 0)) / 1 : (((100n > (((60n) - 0) + 80n) ? 100n : (((60n) - 0) + 80n)) * ((1000n) / (ceil(((1000n) - 5p) / (10u))))) + (floor(((ceil(((1000n) - 5p) / (10u))) - 1) / 2.0) * ((60n > (((60n) - 0) + 50n) ? 60n : (((60n) - 0) + 50n)) * ((1000n) / (ceil(((1000n) - 5p) / (10u)))))) + ((((ceil(((1000n) - 5p) / (10u))) / 2) - floor((ceil(((1000n) - 5p) / (10u))) / 2) == 0) ? ((100n > (((60n) - 0) + 80n) ? 100n : (((60n) - 0) + 80n)) * ((1000n) / (ceil(((1000n) - 5p) / (10u))))) : 0)) / 1 / (((1000n) / (ceil(((1000n) - 5p) / (10u)))) * (ceil(((1000n) - 5p) / (10u))) * ((1000n) / (ceil(((1000n) - 5p) / (10u)))) * (ceil(((1000n) - 5p) / (10u))))           sa=(((1000n) / (ceil(((1000n) - 5p) / (10u)))) < 119.5n) ? (50n > (((60n) - 0) + 60n) ? 50n : (((60n) - 0) + 60n)) + 5e-08 : (100n > (((60n) - 0) + 80n) ? 100n : (((60n) - 0) + 80n))           sb=(((1000n) / (ceil(((1000n) - 5p) / (10u)))) < 119.5n) ? (50n > (((60n) - 0) + 60n) ? 50n : (((60n) - 0) + 60n)) + 5e-08 : (100n > (((60n) - 0) + 80n) ? 100n : (((60n) - 0) + 80n))           sd=(((1000n) / (ceil(((1000n) - 5p) / (10u)))) < 119.5n) ? (((60n) - 0) + 60n) + (2*5e-08) : (60n > (((60n) - 0) + 50n) ? 60n : (((60n) - 0) + 50n))           sca=(( ((1000n) / (ceil(((1000n) - 5p) / (10u)))) * ( (((1u) * (1u) / ((((1000n) / (ceil(((1000n) - 5p) / (10u)))) < 119.5n) ? (50n > (((60n) - 0) + 60n) ? 50n : (((60n) - 0) + 60n)) + 5e-08 : (100n > (((60n) - 0) + 80n) ? 100n : (((60n) - 0) + 80n))+60n)) - ((1u) * (1u) / (((((1000n) / (ceil(((1000n) - 5p) / (10u)))) < 119.5n) ? (50n > (((60n) - 0) + 60n) ? 50n : (((60n) - 0) + 60n)) + 5e-08 : (100n > (((60n) - 0) + 80n) ? 100n : (((60n) - 0) + 80n))+60n)+(45n)))) + ((1u) * (1u) / ((((1000n) / (ceil(((1000n) - 5p) / (10u)))) < 119.5n) ? (50n > (((60n) - 0) + 60n) ? 50n : (((60n) - 0) + 60n)) + 5e-08 : (100n > (((60n) - 0) + 80n) ? 100n : (((60n) - 0) + 80n))+60n)) - ((1u) * (1u)/ (((((1000n) / (ceil(((1000n) - 5p) / (10u)))) < 119.5n) ? (50n > (((60n) - 0) + 60n) ? 50n : (((60n) - 0) + 60n)) + 5e-08 : (100n > (((60n) - 0) + 80n) ? 100n : (((60n) - 0) + 80n))+60n)+(45n))))) + ( (45n) * ( (((1u) * (1u) / (60n)) - ((1u) * (1u) / ((60n)+((1000n) / (ceil(((1000n) - 5p) / (10u))))))) + ((1u) * (1u) / (60n)) - ((1u) * (1u)/ ((60n)+((1000n) / (ceil(((1000n) - 5p) / (10u))))))))) / (((1000n) / (ceil(((1000n) - 5p) / (10u)))) * (45n))           scb=((((1000n) / (ceil(((1000n) - 5p) / (10u)))) * ((((((1000n) / (ceil(((1000n) - 5p) / (10u)))) < 119.5n) ? (50n > (((60n) - 0) + 60n) ? 50n : (((60n) - 0) + 60n)) + 5e-08 : (100n > (((60n) - 0) + 80n) ? 100n : (((60n) - 0) + 80n))+60n)/10 + (1u)/100)*exp(-10 * ((((1000n) / (ceil(((1000n) - 5p) / (10u)))) < 119.5n) ? (50n > (((60n) - 0) + 60n) ? 50n : (((60n) - 0) + 60n)) + 5e-08 : (100n > (((60n) - 0) + 80n) ? 100n : (((60n) - 0) + 80n))+60n) / (1u)) - ((((((1000n) / (ceil(((1000n) - 5p) / (10u)))) < 119.5n) ? (50n > (((60n) - 0) + 60n) ? 50n : (((60n) - 0) + 60n)) + 5e-08 : (100n > (((60n) - 0) + 80n) ? 100n : (((60n) - 0) + 80n))+60n)+(45n))/10 + (1u)/100)*exp(-10 * (((((1000n) / (ceil(((1000n) - 5p) / (10u)))) < 119.5n) ? (50n > (((60n) - 0) + 60n) ? 50n : (((60n) - 0) + 60n)) + 5e-08 : (100n > (((60n) - 0) + 80n) ? 100n : (((60n) - 0) + 80n))+60n)+(45n)) / (1u)) + (((((1000n) / (ceil(((1000n) - 5p) / (10u)))) < 119.5n) ? (50n > (((60n) - 0) + 60n) ? 50n : (((60n) - 0) + 60n)) + 5e-08 : (100n > (((60n) - 0) + 80n) ? 100n : (((60n) - 0) + 80n))+60n)/10 + (1u)/100)*exp(-10 * ((((1000n) / (ceil(((1000n) - 5p) / (10u)))) < 119.5n) ? (50n > (((60n) - 0) + 60n) ? 50n : (((60n) - 0) + 60n)) + 5e-08 : (100n > (((60n) - 0) + 80n) ? 100n : (((60n) - 0) + 80n))+60n) / (1u)) - ((((((1000n) / (ceil(((1000n) - 5p) / (10u)))) < 119.5n) ? (50n > (((60n) - 0) + 60n) ? 50n : (((60n) - 0) + 60n)) + 5e-08 : (100n > (((60n) - 0) + 80n) ? 100n : (((60n) - 0) + 80n))+60n)+(45n))/10 + (1u)/100)*exp(-10 * (((((1000n) / (ceil(((1000n) - 5p) / (10u)))) < 119.5n) ? (50n > (((60n) - 0) + 60n) ? 50n : (((60n) - 0) + 60n)) + 5e-08 : (100n > (((60n) - 0) + 80n) ? 100n : (((60n) - 0) + 80n))+60n)+(45n)) / (1u)))) + ((45n) * (((60n)/10 + (1u)/100)*exp(-10 * (60n) / (1u)) - (((60n)+((1000n) / (ceil(((1000n) - 5p) / (10u)))))/10 + (1u)/100)*exp(-10 * ((60n)+((1000n) / (ceil(((1000n) - 5p) / (10u))))) / (1u)) + ((60n)/10 + (1u)/100)*exp(-10 * (60n) / (1u)) - (((60n)+((1000n) / (ceil(((1000n) - 5p) / (10u)))))/10 + (1u)/100)*exp(-10 * ((60n)+((1000n) / (ceil(((1000n) - 5p) / (10u))))) / (1u))))) / (((1000n) / (ceil(((1000n) - 5p) / (10u)))) * (45n))           scc=((((1000n) / (ceil(((1000n) - 5p) / (10u)))) * ((((((1000n) / (ceil(((1000n) - 5p) / (10u)))) < 119.5n) ? (50n > (((60n) - 0) + 60n) ? 50n : (((60n) - 0) + 60n)) + 5e-08 : (100n > (((60n) - 0) + 80n) ? 100n : (((60n) - 0) + 80n))+60n)/20 + (1u)/400)*exp(-20 * ((((1000n) / (ceil(((1000n) - 5p) / (10u)))) < 119.5n) ? (50n > (((60n) - 0) + 60n) ? 50n : (((60n) - 0) + 60n)) + 5e-08 : (100n > (((60n) - 0) + 80n) ? 100n : (((60n) - 0) + 80n))+60n) / (1u)) - ((((((1000n) / (ceil(((1000n) - 5p) / (10u)))) < 119.5n) ? (50n > (((60n) - 0) + 60n) ? 50n : (((60n) - 0) + 60n)) + 5e-08 : (100n > (((60n) - 0) + 80n) ? 100n : (((60n) - 0) + 80n))+60n)+(45n))/20 + (1u)/400)*exp(-20 * (((((1000n) / (ceil(((1000n) - 5p) / (10u)))) < 119.5n) ? (50n > (((60n) - 0) + 60n) ? 50n : (((60n) - 0) + 60n)) + 5e-08 : (100n > (((60n) - 0) + 80n) ? 100n : (((60n) - 0) + 80n))+60n)+(45n)) / (1u)) + (((((1000n) / (ceil(((1000n) - 5p) / (10u)))) < 119.5n) ? (50n > (((60n) - 0) + 60n) ? 50n : (((60n) - 0) + 60n)) + 5e-08 : (100n > (((60n) - 0) + 80n) ? 100n : (((60n) - 0) + 80n))+60n)/20 + (1u)/400)*exp(-20 * ((((1000n) / (ceil(((1000n) - 5p) / (10u)))) < 119.5n) ? (50n > (((60n) - 0) + 60n) ? 50n : (((60n) - 0) + 60n)) + 5e-08 : (100n > (((60n) - 0) + 80n) ? 100n : (((60n) - 0) + 80n))+60n) / (1u)) - ((((((1000n) / (ceil(((1000n) - 5p) / (10u)))) < 119.5n) ? (50n > (((60n) - 0) + 60n) ? 50n : (((60n) - 0) + 60n)) + 5e-08 : (100n > (((60n) - 0) + 80n) ? 100n : (((60n) - 0) + 80n))+60n)+(45n))/20 + (1u)/400)*exp(-20 * (((((1000n) / (ceil(((1000n) - 5p) / (10u)))) < 119.5n) ? (50n > (((60n) - 0) + 60n) ? 50n : (((60n) - 0) + 60n)) + 5e-08 : (100n > (((60n) - 0) + 80n) ? 100n : (((60n) - 0) + 80n))+60n)+(45n)) / (1u)))) + ((45n) * (((60n)/20 + (1u)/400)*exp(-20 * (60n) / (1u)) - (((60n)+((1000n) / (ceil(((1000n) - 5p) / (10u)))))/20 + (1u)/400)*exp(-20 * ((60n)+((1000n) / (ceil(((1000n) - 5p) / (10u))))) / (1u)) + ((60n)/20 + (1u)/400)*exp(-20 * (60n) / (1u)) - (((60n)+((1000n) / (ceil(((1000n) - 5p) / (10u)))))/20 + (1u)/400)*exp(-20 * ((60n)+((1000n) / (ceil(((1000n) - 5p) / (10u))))) / (1u))))) / (((1000n) / (ceil(((1000n) - 5p) / (10u)))) * (45n))           m=(1)
WpBL (BL WENb DIN Vdd) g45p1svt w=(1000n) l=45n nf=ceil(((1000n) - 5p) / (10u))           as=(((1000n) / (ceil(((1000n) - 5p) / (10u)))) < 119.5n) ? ((((50n > (((60n) - 0) + 60n) ? 50n : (((60n) - 0) + 60n)) * 120n) + (((1000n) / (ceil(((1000n) - 5p) / (10u)))) * 50n)) + (floor(((ceil(((1000n) - 5p) / (10u))) - 1) / 2.0) * (((((60n) - 0) + 60n) * 120n) + (((1000n) / (ceil(((1000n) - 5p) / (10u)))) * 100n))) + ((((ceil(((1000n) - 5p) / (10u))) / 2) - floor((ceil(((1000n) - 5p) / (10u))) / 2) == 0) ? (((50n > (((60n) - 0) + 60n) ? 50n : (((60n) - 0) + 60n)) * 120n) + (((1000n) / (ceil(((1000n) - 5p) / (10u)))) * 50n)) : 0)) / 1 : (((100n > (((60n) - 0) + 80n) ? 100n : (((60n) - 0) + 80n)) * ((1000n) / (ceil(((1000n) - 5p) / (10u))))) + (floor(((ceil(((1000n) - 5p) / (10u))) - 1) / 2.0) * ((60n > (((60n) - 0) + 50n) ? 60n : (((60n) - 0) + 50n)) * ((1000n) / (ceil(((1000n) - 5p) / (10u)))))) + ((((ceil(((1000n) - 5p) / (10u))) / 2) - floor((ceil(((1000n) - 5p) / (10u))) / 2) == 0) ? ((100n > (((60n) - 0) + 80n) ? 100n : (((60n) - 0) + 80n)) * ((1000n) / (ceil(((1000n) - 5p) / (10u))))) : 0)) / 1           ad=(((1000n) / (ceil(((1000n) - 5p) / (10u)))) < 119.5n) ? ((floor((ceil(((1000n) - 5p) / (10u))) / 2.0) * (((((60n) - 0) + 60n) * 120n) + (((1000n) / (ceil(((1000n) - 5p) / (10u)))) * 100n))) + ((((ceil(((1000n) - 5p) / (10u))) / 2) - floor((ceil(((1000n) - 5p) / (10u))) / 2) != 0) ? (((50n > (((60n) - 0) + 60n) ? 50n : (((60n) - 0) + 60n)) * 120n) + (((1000n) / (ceil(((1000n) - 5p) / (10u)))) * 50n)) : 0)) / 1 : ((floor((ceil(((1000n) - 5p) / (10u))) / 2.0) * ((60n > (((60n) - 0) + 50n) ? 60n : (((60n) - 0) + 50n)) * ((1000n) / (ceil(((1000n) - 5p) / (10u)))))) + ((((ceil(((1000n) - 5p) / (10u))) / 2) - floor((ceil(((1000n) - 5p) / (10u))) / 2) != 0) ? ((100n > (((60n) - 0) + 80n) ? 100n : (((60n) - 0) + 80n)) * ((1000n) / (ceil(((1000n) - 5p) / (10u))))) : 0)) / 1           ps=(((1000n) / (ceil(((1000n) - 5p) / (10u)))) < 119.5n) ? (((2 * (50n > (((60n) - 0) + 60n) ? 50n : (((60n) - 0) + 60n))) + 340n) + (floor(((ceil(((1000n) - 5p) / (10u))) - 1) / 2.0) * ((2 * (((60n) - 0) + 60n)) + 440n)) + ((((ceil(((1000n) - 5p) / (10u))) / 2) - floor((ceil(((1000n) - 5p) / (10u))) / 2) == 0) ? ((2 * (50n > (((60n) - 0) + 60n) ? 50n : (((60n) - 0) + 60n))) + 340n) : 0)) / 1 : (((2 * (100n > (((60n) - 0) + 80n) ? 100n : (((60n) - 0) + 80n))) + (2 * ((1000n) / (ceil(((1000n) - 5p) / (10u)))))) + (floor(((ceil(((1000n) - 5p) / (10u))) - 1) / 2.0) * ((2 * (60n > (((60n) - 0) + 50n) ? 60n : (((60n) - 0) + 50n))) + (2 * ((1000n) / (ceil(((1000n) - 5p) / (10u))))))) + ((((ceil(((1000n) - 5p) / (10u))) / 2) - floor((ceil(((1000n) - 5p) / (10u))) / 2) == 0) ? ((2 * (100n > (((60n) - 0) + 80n) ? 100n : (((60n) - 0) + 80n))) + (2 * ((1000n) / (ceil(((1000n) - 5p) / (10u)))))) : 0)) / 1           pd=(((1000n) / (ceil(((1000n) - 5p) / (10u)))) < 119.5n) ? ((floor((ceil(((1000n) - 5p) / (10u))) / 2.0) * ((2 * (((60n) - 0) + 60n)) + 440n)) + ((((ceil(((1000n) - 5p) / (10u))) / 2) - floor((ceil(((1000n) - 5p) / (10u))) / 2) != 0) ? ((2 * (50n > (((60n) - 0) + 60n) ? 50n : (((60n) - 0) + 60n))) + 340n) : 0)) / 1 : ((floor((ceil(((1000n) - 5p) / (10u))) / 2.0) * ((2 * (60n > (((60n) - 0) + 50n) ? 60n : (((60n) - 0) + 50n))) + (2 * ((1000n) / (ceil(((1000n) - 5p) / (10u))))))) + ((((ceil(((1000n) - 5p) / (10u))) / 2) - floor((ceil(((1000n) - 5p) / (10u))) / 2) != 0) ? ((2 * (100n > (((60n) - 0) + 80n) ? 100n : (((60n) - 0) + 80n))) + (2 * ((1000n) / (ceil(((1000n) - 5p) / (10u)))))) : 0)) / 1           nrd=(((1000n) / (ceil(((1000n) - 5p) / (10u)))) < 119.5n) ? ((floor((ceil(((1000n) - 5p) / (10u))) / 2.0) * (((((60n) - 0) + 60n) * 120n) + (((1000n) / (ceil(((1000n) - 5p) / (10u)))) * 100n))) + ((((ceil(((1000n) - 5p) / (10u))) / 2) - floor((ceil(((1000n) - 5p) / (10u))) / 2) != 0) ? (((50n > (((60n) - 0) + 60n) ? 50n : (((60n) - 0) + 60n)) * 120n) + (((1000n) / (ceil(((1000n) - 5p) / (10u)))) * 50n)) : 0)) / 1 : ((floor((ceil(((1000n) - 5p) / (10u))) / 2.0) * ((60n > (((60n) - 0) + 50n) ? 60n : (((60n) - 0) + 50n)) * ((1000n) / (ceil(((1000n) - 5p) / (10u)))))) + ((((ceil(((1000n) - 5p) / (10u))) / 2) - floor((ceil(((1000n) - 5p) / (10u))) / 2) != 0) ? ((100n > (((60n) - 0) + 80n) ? 100n : (((60n) - 0) + 80n)) * ((1000n) / (ceil(((1000n) - 5p) / (10u))))) : 0)) / 1 / (((1000n) / (ceil(((1000n) - 5p) / (10u)))) * (ceil(((1000n) - 5p) / (10u))) * ((1000n) / (ceil(((1000n) - 5p) / (10u)))) * (ceil(((1000n) - 5p) / (10u))))           nrs=(((1000n) / (ceil(((1000n) - 5p) / (10u)))) < 119.5n) ? ((((50n > (((60n) - 0) + 60n) ? 50n : (((60n) - 0) + 60n)) * 120n) + (((1000n) / (ceil(((1000n) - 5p) / (10u)))) * 50n)) + (floor(((ceil(((1000n) - 5p) / (10u))) - 1) / 2.0) * (((((60n) - 0) + 60n) * 120n) + (((1000n) / (ceil(((1000n) - 5p) / (10u)))) * 100n))) + ((((ceil(((1000n) - 5p) / (10u))) / 2) - floor((ceil(((1000n) - 5p) / (10u))) / 2) == 0) ? (((50n > (((60n) - 0) + 60n) ? 50n : (((60n) - 0) + 60n)) * 120n) + (((1000n) / (ceil(((1000n) - 5p) / (10u)))) * 50n)) : 0)) / 1 : (((100n > (((60n) - 0) + 80n) ? 100n : (((60n) - 0) + 80n)) * ((1000n) / (ceil(((1000n) - 5p) / (10u))))) + (floor(((ceil(((1000n) - 5p) / (10u))) - 1) / 2.0) * ((60n > (((60n) - 0) + 50n) ? 60n : (((60n) - 0) + 50n)) * ((1000n) / (ceil(((1000n) - 5p) / (10u)))))) + ((((ceil(((1000n) - 5p) / (10u))) / 2) - floor((ceil(((1000n) - 5p) / (10u))) / 2) == 0) ? ((100n > (((60n) - 0) + 80n) ? 100n : (((60n) - 0) + 80n)) * ((1000n) / (ceil(((1000n) - 5p) / (10u))))) : 0)) / 1 / (((1000n) / (ceil(((1000n) - 5p) / (10u)))) * (ceil(((1000n) - 5p) / (10u))) * ((1000n) / (ceil(((1000n) - 5p) / (10u)))) * (ceil(((1000n) - 5p) / (10u))))           sa=(((1000n) / (ceil(((1000n) - 5p) / (10u)))) < 119.5n) ? (50n > (((60n) - 0) + 60n) ? 50n : (((60n) - 0) + 60n)) + 5e-08 : (100n > (((60n) - 0) + 80n) ? 100n : (((60n) - 0) + 80n))           sb=(((1000n) / (ceil(((1000n) - 5p) / (10u)))) < 119.5n) ? (50n > (((60n) - 0) + 60n) ? 50n : (((60n) - 0) + 60n)) + 5e-08 : (100n > (((60n) - 0) + 80n) ? 100n : (((60n) - 0) + 80n))           sd=(((1000n) / (ceil(((1000n) - 5p) / (10u)))) < 119.5n) ? (((60n) - 0) + 60n) + (2*5e-08) : (60n > (((60n) - 0) + 50n) ? 60n : (((60n) - 0) + 50n))           sca=(( ((1000n) / (ceil(((1000n) - 5p) / (10u)))) * ( (((1u) * (1u) / ((((1000n) / (ceil(((1000n) - 5p) / (10u)))) < 119.5n) ? (50n > (((60n) - 0) + 60n) ? 50n : (((60n) - 0) + 60n)) + 5e-08 : (100n > (((60n) - 0) + 80n) ? 100n : (((60n) - 0) + 80n))+60n)) - ((1u) * (1u) / (((((1000n) / (ceil(((1000n) - 5p) / (10u)))) < 119.5n) ? (50n > (((60n) - 0) + 60n) ? 50n : (((60n) - 0) + 60n)) + 5e-08 : (100n > (((60n) - 0) + 80n) ? 100n : (((60n) - 0) + 80n))+60n)+(45n)))) + ((1u) * (1u) / ((((1000n) / (ceil(((1000n) - 5p) / (10u)))) < 119.5n) ? (50n > (((60n) - 0) + 60n) ? 50n : (((60n) - 0) + 60n)) + 5e-08 : (100n > (((60n) - 0) + 80n) ? 100n : (((60n) - 0) + 80n))+60n)) - ((1u) * (1u)/ (((((1000n) / (ceil(((1000n) - 5p) / (10u)))) < 119.5n) ? (50n > (((60n) - 0) + 60n) ? 50n : (((60n) - 0) + 60n)) + 5e-08 : (100n > (((60n) - 0) + 80n) ? 100n : (((60n) - 0) + 80n))+60n)+(45n))))) + ( (45n) * ( (((1u) * (1u) / (60n)) - ((1u) * (1u) / ((60n)+((1000n) / (ceil(((1000n) - 5p) / (10u))))))) + ((1u) * (1u) / (60n)) - ((1u) * (1u)/ ((60n)+((1000n) / (ceil(((1000n) - 5p) / (10u))))))))) / (((1000n) / (ceil(((1000n) - 5p) / (10u)))) * (45n))           scb=((((1000n) / (ceil(((1000n) - 5p) / (10u)))) * ((((((1000n) / (ceil(((1000n) - 5p) / (10u)))) < 119.5n) ? (50n > (((60n) - 0) + 60n) ? 50n : (((60n) - 0) + 60n)) + 5e-08 : (100n > (((60n) - 0) + 80n) ? 100n : (((60n) - 0) + 80n))+60n)/10 + (1u)/100)*exp(-10 * ((((1000n) / (ceil(((1000n) - 5p) / (10u)))) < 119.5n) ? (50n > (((60n) - 0) + 60n) ? 50n : (((60n) - 0) + 60n)) + 5e-08 : (100n > (((60n) - 0) + 80n) ? 100n : (((60n) - 0) + 80n))+60n) / (1u)) - ((((((1000n) / (ceil(((1000n) - 5p) / (10u)))) < 119.5n) ? (50n > (((60n) - 0) + 60n) ? 50n : (((60n) - 0) + 60n)) + 5e-08 : (100n > (((60n) - 0) + 80n) ? 100n : (((60n) - 0) + 80n))+60n)+(45n))/10 + (1u)/100)*exp(-10 * (((((1000n) / (ceil(((1000n) - 5p) / (10u)))) < 119.5n) ? (50n > (((60n) - 0) + 60n) ? 50n : (((60n) - 0) + 60n)) + 5e-08 : (100n > (((60n) - 0) + 80n) ? 100n : (((60n) - 0) + 80n))+60n)+(45n)) / (1u)) + (((((1000n) / (ceil(((1000n) - 5p) / (10u)))) < 119.5n) ? (50n > (((60n) - 0) + 60n) ? 50n : (((60n) - 0) + 60n)) + 5e-08 : (100n > (((60n) - 0) + 80n) ? 100n : (((60n) - 0) + 80n))+60n)/10 + (1u)/100)*exp(-10 * ((((1000n) / (ceil(((1000n) - 5p) / (10u)))) < 119.5n) ? (50n > (((60n) - 0) + 60n) ? 50n : (((60n) - 0) + 60n)) + 5e-08 : (100n > (((60n) - 0) + 80n) ? 100n : (((60n) - 0) + 80n))+60n) / (1u)) - ((((((1000n) / (ceil(((1000n) - 5p) / (10u)))) < 119.5n) ? (50n > (((60n) - 0) + 60n) ? 50n : (((60n) - 0) + 60n)) + 5e-08 : (100n > (((60n) - 0) + 80n) ? 100n : (((60n) - 0) + 80n))+60n)+(45n))/10 + (1u)/100)*exp(-10 * (((((1000n) / (ceil(((1000n) - 5p) / (10u)))) < 119.5n) ? (50n > (((60n) - 0) + 60n) ? 50n : (((60n) - 0) + 60n)) + 5e-08 : (100n > (((60n) - 0) + 80n) ? 100n : (((60n) - 0) + 80n))+60n)+(45n)) / (1u)))) + ((45n) * (((60n)/10 + (1u)/100)*exp(-10 * (60n) / (1u)) - (((60n)+((1000n) / (ceil(((1000n) - 5p) / (10u)))))/10 + (1u)/100)*exp(-10 * ((60n)+((1000n) / (ceil(((1000n) - 5p) / (10u))))) / (1u)) + ((60n)/10 + (1u)/100)*exp(-10 * (60n) / (1u)) - (((60n)+((1000n) / (ceil(((1000n) - 5p) / (10u)))))/10 + (1u)/100)*exp(-10 * ((60n)+((1000n) / (ceil(((1000n) - 5p) / (10u))))) / (1u))))) / (((1000n) / (ceil(((1000n) - 5p) / (10u)))) * (45n))           scc=((((1000n) / (ceil(((1000n) - 5p) / (10u)))) * ((((((1000n) / (ceil(((1000n) - 5p) / (10u)))) < 119.5n) ? (50n > (((60n) - 0) + 60n) ? 50n : (((60n) - 0) + 60n)) + 5e-08 : (100n > (((60n) - 0) + 80n) ? 100n : (((60n) - 0) + 80n))+60n)/20 + (1u)/400)*exp(-20 * ((((1000n) / (ceil(((1000n) - 5p) / (10u)))) < 119.5n) ? (50n > (((60n) - 0) + 60n) ? 50n : (((60n) - 0) + 60n)) + 5e-08 : (100n > (((60n) - 0) + 80n) ? 100n : (((60n) - 0) + 80n))+60n) / (1u)) - ((((((1000n) / (ceil(((1000n) - 5p) / (10u)))) < 119.5n) ? (50n > (((60n) - 0) + 60n) ? 50n : (((60n) - 0) + 60n)) + 5e-08 : (100n > (((60n) - 0) + 80n) ? 100n : (((60n) - 0) + 80n))+60n)+(45n))/20 + (1u)/400)*exp(-20 * (((((1000n) / (ceil(((1000n) - 5p) / (10u)))) < 119.5n) ? (50n > (((60n) - 0) + 60n) ? 50n : (((60n) - 0) + 60n)) + 5e-08 : (100n > (((60n) - 0) + 80n) ? 100n : (((60n) - 0) + 80n))+60n)+(45n)) / (1u)) + (((((1000n) / (ceil(((1000n) - 5p) / (10u)))) < 119.5n) ? (50n > (((60n) - 0) + 60n) ? 50n : (((60n) - 0) + 60n)) + 5e-08 : (100n > (((60n) - 0) + 80n) ? 100n : (((60n) - 0) + 80n))+60n)/20 + (1u)/400)*exp(-20 * ((((1000n) / (ceil(((1000n) - 5p) / (10u)))) < 119.5n) ? (50n > (((60n) - 0) + 60n) ? 50n : (((60n) - 0) + 60n)) + 5e-08 : (100n > (((60n) - 0) + 80n) ? 100n : (((60n) - 0) + 80n))+60n) / (1u)) - ((((((1000n) / (ceil(((1000n) - 5p) / (10u)))) < 119.5n) ? (50n > (((60n) - 0) + 60n) ? 50n : (((60n) - 0) + 60n)) + 5e-08 : (100n > (((60n) - 0) + 80n) ? 100n : (((60n) - 0) + 80n))+60n)+(45n))/20 + (1u)/400)*exp(-20 * (((((1000n) / (ceil(((1000n) - 5p) / (10u)))) < 119.5n) ? (50n > (((60n) - 0) + 60n) ? 50n : (((60n) - 0) + 60n)) + 5e-08 : (100n > (((60n) - 0) + 80n) ? 100n : (((60n) - 0) + 80n))+60n)+(45n)) / (1u)))) + ((45n) * (((60n)/20 + (1u)/400)*exp(-20 * (60n) / (1u)) - (((60n)+((1000n) / (ceil(((1000n) - 5p) / (10u)))))/20 + (1u)/400)*exp(-20 * ((60n)+((1000n) / (ceil(((1000n) - 5p) / (10u))))) / (1u)) + ((60n)/20 + (1u)/400)*exp(-20 * (60n) / (1u)) - (((60n)+((1000n) / (ceil(((1000n) - 5p) / (10u)))))/20 + (1u)/400)*exp(-20 * ((60n)+((1000n) / (ceil(((1000n) - 5p) / (10u))))) / (1u))))) / (((1000n) / (ceil(((1000n) - 5p) / (10u)))) * (45n))           m=(1)
PreBL (BL PREb Vdd Vdd) g45p1svt w=(1000n) l=45n nf=ceil(((1000n) - 5p) / (10u))           as=(((1000n) / (ceil(((1000n) - 5p) / (10u)))) < 119.5n) ? ((((50n > (((60n) - 0) + 60n) ? 50n : (((60n) - 0) + 60n)) * 120n) + (((1000n) / (ceil(((1000n) - 5p) / (10u)))) * 50n)) + (floor(((ceil(((1000n) - 5p) / (10u))) - 1) / 2.0) * (((((60n) - 0) + 60n) * 120n) + (((1000n) / (ceil(((1000n) - 5p) / (10u)))) * 100n))) + ((((ceil(((1000n) - 5p) / (10u))) / 2) - floor((ceil(((1000n) - 5p) / (10u))) / 2) == 0) ? (((50n > (((60n) - 0) + 60n) ? 50n : (((60n) - 0) + 60n)) * 120n) + (((1000n) / (ceil(((1000n) - 5p) / (10u)))) * 50n)) : 0)) / 1 : (((100n > (((60n) - 0) + 80n) ? 100n : (((60n) - 0) + 80n)) * ((1000n) / (ceil(((1000n) - 5p) / (10u))))) + (floor(((ceil(((1000n) - 5p) / (10u))) - 1) / 2.0) * ((60n > (((60n) - 0) + 50n) ? 60n : (((60n) - 0) + 50n)) * ((1000n) / (ceil(((1000n) - 5p) / (10u)))))) + ((((ceil(((1000n) - 5p) / (10u))) / 2) - floor((ceil(((1000n) - 5p) / (10u))) / 2) == 0) ? ((100n > (((60n) - 0) + 80n) ? 100n : (((60n) - 0) + 80n)) * ((1000n) / (ceil(((1000n) - 5p) / (10u))))) : 0)) / 1           ad=(((1000n) / (ceil(((1000n) - 5p) / (10u)))) < 119.5n) ? ((floor((ceil(((1000n) - 5p) / (10u))) / 2.0) * (((((60n) - 0) + 60n) * 120n) + (((1000n) / (ceil(((1000n) - 5p) / (10u)))) * 100n))) + ((((ceil(((1000n) - 5p) / (10u))) / 2) - floor((ceil(((1000n) - 5p) / (10u))) / 2) != 0) ? (((50n > (((60n) - 0) + 60n) ? 50n : (((60n) - 0) + 60n)) * 120n) + (((1000n) / (ceil(((1000n) - 5p) / (10u)))) * 50n)) : 0)) / 1 : ((floor((ceil(((1000n) - 5p) / (10u))) / 2.0) * ((60n > (((60n) - 0) + 50n) ? 60n : (((60n) - 0) + 50n)) * ((1000n) / (ceil(((1000n) - 5p) / (10u)))))) + ((((ceil(((1000n) - 5p) / (10u))) / 2) - floor((ceil(((1000n) - 5p) / (10u))) / 2) != 0) ? ((100n > (((60n) - 0) + 80n) ? 100n : (((60n) - 0) + 80n)) * ((1000n) / (ceil(((1000n) - 5p) / (10u))))) : 0)) / 1           ps=(((1000n) / (ceil(((1000n) - 5p) / (10u)))) < 119.5n) ? (((2 * (50n > (((60n) - 0) + 60n) ? 50n : (((60n) - 0) + 60n))) + 340n) + (floor(((ceil(((1000n) - 5p) / (10u))) - 1) / 2.0) * ((2 * (((60n) - 0) + 60n)) + 440n)) + ((((ceil(((1000n) - 5p) / (10u))) / 2) - floor((ceil(((1000n) - 5p) / (10u))) / 2) == 0) ? ((2 * (50n > (((60n) - 0) + 60n) ? 50n : (((60n) - 0) + 60n))) + 340n) : 0)) / 1 : (((2 * (100n > (((60n) - 0) + 80n) ? 100n : (((60n) - 0) + 80n))) + (2 * ((1000n) / (ceil(((1000n) - 5p) / (10u)))))) + (floor(((ceil(((1000n) - 5p) / (10u))) - 1) / 2.0) * ((2 * (60n > (((60n) - 0) + 50n) ? 60n : (((60n) - 0) + 50n))) + (2 * ((1000n) / (ceil(((1000n) - 5p) / (10u))))))) + ((((ceil(((1000n) - 5p) / (10u))) / 2) - floor((ceil(((1000n) - 5p) / (10u))) / 2) == 0) ? ((2 * (100n > (((60n) - 0) + 80n) ? 100n : (((60n) - 0) + 80n))) + (2 * ((1000n) / (ceil(((1000n) - 5p) / (10u)))))) : 0)) / 1           pd=(((1000n) / (ceil(((1000n) - 5p) / (10u)))) < 119.5n) ? ((floor((ceil(((1000n) - 5p) / (10u))) / 2.0) * ((2 * (((60n) - 0) + 60n)) + 440n)) + ((((ceil(((1000n) - 5p) / (10u))) / 2) - floor((ceil(((1000n) - 5p) / (10u))) / 2) != 0) ? ((2 * (50n > (((60n) - 0) + 60n) ? 50n : (((60n) - 0) + 60n))) + 340n) : 0)) / 1 : ((floor((ceil(((1000n) - 5p) / (10u))) / 2.0) * ((2 * (60n > (((60n) - 0) + 50n) ? 60n : (((60n) - 0) + 50n))) + (2 * ((1000n) / (ceil(((1000n) - 5p) / (10u))))))) + ((((ceil(((1000n) - 5p) / (10u))) / 2) - floor((ceil(((1000n) - 5p) / (10u))) / 2) != 0) ? ((2 * (100n > (((60n) - 0) + 80n) ? 100n : (((60n) - 0) + 80n))) + (2 * ((1000n) / (ceil(((1000n) - 5p) / (10u)))))) : 0)) / 1           nrd=(((1000n) / (ceil(((1000n) - 5p) / (10u)))) < 119.5n) ? ((floor((ceil(((1000n) - 5p) / (10u))) / 2.0) * (((((60n) - 0) + 60n) * 120n) + (((1000n) / (ceil(((1000n) - 5p) / (10u)))) * 100n))) + ((((ceil(((1000n) - 5p) / (10u))) / 2) - floor((ceil(((1000n) - 5p) / (10u))) / 2) != 0) ? (((50n > (((60n) - 0) + 60n) ? 50n : (((60n) - 0) + 60n)) * 120n) + (((1000n) / (ceil(((1000n) - 5p) / (10u)))) * 50n)) : 0)) / 1 : ((floor((ceil(((1000n) - 5p) / (10u))) / 2.0) * ((60n > (((60n) - 0) + 50n) ? 60n : (((60n) - 0) + 50n)) * ((1000n) / (ceil(((1000n) - 5p) / (10u)))))) + ((((ceil(((1000n) - 5p) / (10u))) / 2) - floor((ceil(((1000n) - 5p) / (10u))) / 2) != 0) ? ((100n > (((60n) - 0) + 80n) ? 100n : (((60n) - 0) + 80n)) * ((1000n) / (ceil(((1000n) - 5p) / (10u))))) : 0)) / 1 / (((1000n) / (ceil(((1000n) - 5p) / (10u)))) * (ceil(((1000n) - 5p) / (10u))) * ((1000n) / (ceil(((1000n) - 5p) / (10u)))) * (ceil(((1000n) - 5p) / (10u))))           nrs=(((1000n) / (ceil(((1000n) - 5p) / (10u)))) < 119.5n) ? ((((50n > (((60n) - 0) + 60n) ? 50n : (((60n) - 0) + 60n)) * 120n) + (((1000n) / (ceil(((1000n) - 5p) / (10u)))) * 50n)) + (floor(((ceil(((1000n) - 5p) / (10u))) - 1) / 2.0) * (((((60n) - 0) + 60n) * 120n) + (((1000n) / (ceil(((1000n) - 5p) / (10u)))) * 100n))) + ((((ceil(((1000n) - 5p) / (10u))) / 2) - floor((ceil(((1000n) - 5p) / (10u))) / 2) == 0) ? (((50n > (((60n) - 0) + 60n) ? 50n : (((60n) - 0) + 60n)) * 120n) + (((1000n) / (ceil(((1000n) - 5p) / (10u)))) * 50n)) : 0)) / 1 : (((100n > (((60n) - 0) + 80n) ? 100n : (((60n) - 0) + 80n)) * ((1000n) / (ceil(((1000n) - 5p) / (10u))))) + (floor(((ceil(((1000n) - 5p) / (10u))) - 1) / 2.0) * ((60n > (((60n) - 0) + 50n) ? 60n : (((60n) - 0) + 50n)) * ((1000n) / (ceil(((1000n) - 5p) / (10u)))))) + ((((ceil(((1000n) - 5p) / (10u))) / 2) - floor((ceil(((1000n) - 5p) / (10u))) / 2) == 0) ? ((100n > (((60n) - 0) + 80n) ? 100n : (((60n) - 0) + 80n)) * ((1000n) / (ceil(((1000n) - 5p) / (10u))))) : 0)) / 1 / (((1000n) / (ceil(((1000n) - 5p) / (10u)))) * (ceil(((1000n) - 5p) / (10u))) * ((1000n) / (ceil(((1000n) - 5p) / (10u)))) * (ceil(((1000n) - 5p) / (10u))))           sa=(((1000n) / (ceil(((1000n) - 5p) / (10u)))) < 119.5n) ? (50n > (((60n) - 0) + 60n) ? 50n : (((60n) - 0) + 60n)) + 5e-08 : (100n > (((60n) - 0) + 80n) ? 100n : (((60n) - 0) + 80n))           sb=(((1000n) / (ceil(((1000n) - 5p) / (10u)))) < 119.5n) ? (50n > (((60n) - 0) + 60n) ? 50n : (((60n) - 0) + 60n)) + 5e-08 : (100n > (((60n) - 0) + 80n) ? 100n : (((60n) - 0) + 80n))           sd=(((1000n) / (ceil(((1000n) - 5p) / (10u)))) < 119.5n) ? (((60n) - 0) + 60n) + (2*5e-08) : (60n > (((60n) - 0) + 50n) ? 60n : (((60n) - 0) + 50n))           sca=(( ((1000n) / (ceil(((1000n) - 5p) / (10u)))) * ( (((1u) * (1u) / ((((1000n) / (ceil(((1000n) - 5p) / (10u)))) < 119.5n) ? (50n > (((60n) - 0) + 60n) ? 50n : (((60n) - 0) + 60n)) + 5e-08 : (100n > (((60n) - 0) + 80n) ? 100n : (((60n) - 0) + 80n))+60n)) - ((1u) * (1u) / (((((1000n) / (ceil(((1000n) - 5p) / (10u)))) < 119.5n) ? (50n > (((60n) - 0) + 60n) ? 50n : (((60n) - 0) + 60n)) + 5e-08 : (100n > (((60n) - 0) + 80n) ? 100n : (((60n) - 0) + 80n))+60n)+(45n)))) + ((1u) * (1u) / ((((1000n) / (ceil(((1000n) - 5p) / (10u)))) < 119.5n) ? (50n > (((60n) - 0) + 60n) ? 50n : (((60n) - 0) + 60n)) + 5e-08 : (100n > (((60n) - 0) + 80n) ? 100n : (((60n) - 0) + 80n))+60n)) - ((1u) * (1u)/ (((((1000n) / (ceil(((1000n) - 5p) / (10u)))) < 119.5n) ? (50n > (((60n) - 0) + 60n) ? 50n : (((60n) - 0) + 60n)) + 5e-08 : (100n > (((60n) - 0) + 80n) ? 100n : (((60n) - 0) + 80n))+60n)+(45n))))) + ( (45n) * ( (((1u) * (1u) / (60n)) - ((1u) * (1u) / ((60n)+((1000n) / (ceil(((1000n) - 5p) / (10u))))))) + ((1u) * (1u) / (60n)) - ((1u) * (1u)/ ((60n)+((1000n) / (ceil(((1000n) - 5p) / (10u))))))))) / (((1000n) / (ceil(((1000n) - 5p) / (10u)))) * (45n))           scb=((((1000n) / (ceil(((1000n) - 5p) / (10u)))) * ((((((1000n) / (ceil(((1000n) - 5p) / (10u)))) < 119.5n) ? (50n > (((60n) - 0) + 60n) ? 50n : (((60n) - 0) + 60n)) + 5e-08 : (100n > (((60n) - 0) + 80n) ? 100n : (((60n) - 0) + 80n))+60n)/10 + (1u)/100)*exp(-10 * ((((1000n) / (ceil(((1000n) - 5p) / (10u)))) < 119.5n) ? (50n > (((60n) - 0) + 60n) ? 50n : (((60n) - 0) + 60n)) + 5e-08 : (100n > (((60n) - 0) + 80n) ? 100n : (((60n) - 0) + 80n))+60n) / (1u)) - ((((((1000n) / (ceil(((1000n) - 5p) / (10u)))) < 119.5n) ? (50n > (((60n) - 0) + 60n) ? 50n : (((60n) - 0) + 60n)) + 5e-08 : (100n > (((60n) - 0) + 80n) ? 100n : (((60n) - 0) + 80n))+60n)+(45n))/10 + (1u)/100)*exp(-10 * (((((1000n) / (ceil(((1000n) - 5p) / (10u)))) < 119.5n) ? (50n > (((60n) - 0) + 60n) ? 50n : (((60n) - 0) + 60n)) + 5e-08 : (100n > (((60n) - 0) + 80n) ? 100n : (((60n) - 0) + 80n))+60n)+(45n)) / (1u)) + (((((1000n) / (ceil(((1000n) - 5p) / (10u)))) < 119.5n) ? (50n > (((60n) - 0) + 60n) ? 50n : (((60n) - 0) + 60n)) + 5e-08 : (100n > (((60n) - 0) + 80n) ? 100n : (((60n) - 0) + 80n))+60n)/10 + (1u)/100)*exp(-10 * ((((1000n) / (ceil(((1000n) - 5p) / (10u)))) < 119.5n) ? (50n > (((60n) - 0) + 60n) ? 50n : (((60n) - 0) + 60n)) + 5e-08 : (100n > (((60n) - 0) + 80n) ? 100n : (((60n) - 0) + 80n))+60n) / (1u)) - ((((((1000n) / (ceil(((1000n) - 5p) / (10u)))) < 119.5n) ? (50n > (((60n) - 0) + 60n) ? 50n : (((60n) - 0) + 60n)) + 5e-08 : (100n > (((60n) - 0) + 80n) ? 100n : (((60n) - 0) + 80n))+60n)+(45n))/10 + (1u)/100)*exp(-10 * (((((1000n) / (ceil(((1000n) - 5p) / (10u)))) < 119.5n) ? (50n > (((60n) - 0) + 60n) ? 50n : (((60n) - 0) + 60n)) + 5e-08 : (100n > (((60n) - 0) + 80n) ? 100n : (((60n) - 0) + 80n))+60n)+(45n)) / (1u)))) + ((45n) * (((60n)/10 + (1u)/100)*exp(-10 * (60n) / (1u)) - (((60n)+((1000n) / (ceil(((1000n) - 5p) / (10u)))))/10 + (1u)/100)*exp(-10 * ((60n)+((1000n) / (ceil(((1000n) - 5p) / (10u))))) / (1u)) + ((60n)/10 + (1u)/100)*exp(-10 * (60n) / (1u)) - (((60n)+((1000n) / (ceil(((1000n) - 5p) / (10u)))))/10 + (1u)/100)*exp(-10 * ((60n)+((1000n) / (ceil(((1000n) - 5p) / (10u))))) / (1u))))) / (((1000n) / (ceil(((1000n) - 5p) / (10u)))) * (45n))           scc=((((1000n) / (ceil(((1000n) - 5p) / (10u)))) * ((((((1000n) / (ceil(((1000n) - 5p) / (10u)))) < 119.5n) ? (50n > (((60n) - 0) + 60n) ? 50n : (((60n) - 0) + 60n)) + 5e-08 : (100n > (((60n) - 0) + 80n) ? 100n : (((60n) - 0) + 80n))+60n)/20 + (1u)/400)*exp(-20 * ((((1000n) / (ceil(((1000n) - 5p) / (10u)))) < 119.5n) ? (50n > (((60n) - 0) + 60n) ? 50n : (((60n) - 0) + 60n)) + 5e-08 : (100n > (((60n) - 0) + 80n) ? 100n : (((60n) - 0) + 80n))+60n) / (1u)) - ((((((1000n) / (ceil(((1000n) - 5p) / (10u)))) < 119.5n) ? (50n > (((60n) - 0) + 60n) ? 50n : (((60n) - 0) + 60n)) + 5e-08 : (100n > (((60n) - 0) + 80n) ? 100n : (((60n) - 0) + 80n))+60n)+(45n))/20 + (1u)/400)*exp(-20 * (((((1000n) / (ceil(((1000n) - 5p) / (10u)))) < 119.5n) ? (50n > (((60n) - 0) + 60n) ? 50n : (((60n) - 0) + 60n)) + 5e-08 : (100n > (((60n) - 0) + 80n) ? 100n : (((60n) - 0) + 80n))+60n)+(45n)) / (1u)) + (((((1000n) / (ceil(((1000n) - 5p) / (10u)))) < 119.5n) ? (50n > (((60n) - 0) + 60n) ? 50n : (((60n) - 0) + 60n)) + 5e-08 : (100n > (((60n) - 0) + 80n) ? 100n : (((60n) - 0) + 80n))+60n)/20 + (1u)/400)*exp(-20 * ((((1000n) / (ceil(((1000n) - 5p) / (10u)))) < 119.5n) ? (50n > (((60n) - 0) + 60n) ? 50n : (((60n) - 0) + 60n)) + 5e-08 : (100n > (((60n) - 0) + 80n) ? 100n : (((60n) - 0) + 80n))+60n) / (1u)) - ((((((1000n) / (ceil(((1000n) - 5p) / (10u)))) < 119.5n) ? (50n > (((60n) - 0) + 60n) ? 50n : (((60n) - 0) + 60n)) + 5e-08 : (100n > (((60n) - 0) + 80n) ? 100n : (((60n) - 0) + 80n))+60n)+(45n))/20 + (1u)/400)*exp(-20 * (((((1000n) / (ceil(((1000n) - 5p) / (10u)))) < 119.5n) ? (50n > (((60n) - 0) + 60n) ? 50n : (((60n) - 0) + 60n)) + 5e-08 : (100n > (((60n) - 0) + 80n) ? 100n : (((60n) - 0) + 80n))+60n)+(45n)) / (1u)))) + ((45n) * (((60n)/20 + (1u)/400)*exp(-20 * (60n) / (1u)) - (((60n)+((1000n) / (ceil(((1000n) - 5p) / (10u)))))/20 + (1u)/400)*exp(-20 * ((60n)+((1000n) / (ceil(((1000n) - 5p) / (10u))))) / (1u)) + ((60n)/20 + (1u)/400)*exp(-20 * (60n) / (1u)) - (((60n)+((1000n) / (ceil(((1000n) - 5p) / (10u)))))/20 + (1u)/400)*exp(-20 * ((60n)+((1000n) / (ceil(((1000n) - 5p) / (10u))))) / (1u))))) / (((1000n) / (ceil(((1000n) - 5p) / (10u)))) * (45n))           m=(1)
CBL (BL 0) capacitor c=20f
WnBL_bar (BL_bar WEN DINb 0) g45n1svt w=(1000n) l=45n nf=ceil(((1000n) - 5p) / (10u))           as=(((1000n) / (ceil(((1000n) - 5p) / (10u)))) < 119.5n) ? ((((50n > (((60n) - 0) + 60n) ? 50n : (((60n) - 0) + 60n)) * 120n) + (((1000n) / (ceil(((1000n) - 5p) / (10u)))) * 50n)) + (floor(((ceil(((1000n) - 5p) / (10u))) - 1) / 2.0) * (((((60n) - 0) + 60n) * 120n) + (((1000n) / (ceil(((1000n) - 5p) / (10u)))) * 100n))) + ((((ceil(((1000n) - 5p) / (10u))) / 2) - floor((ceil(((1000n) - 5p) / (10u))) / 2) == 0) ? (((50n > (((60n) - 0) + 60n) ? 50n : (((60n) - 0) + 60n)) * 120n) + (((1000n) / (ceil(((1000n) - 5p) / (10u)))) * 50n)) : 0)) / 1 : (((100n > (((60n) - 0) + 80n) ? 100n : (((60n) - 0) + 80n)) * ((1000n) / (ceil(((1000n) - 5p) / (10u))))) + (floor(((ceil(((1000n) - 5p) / (10u))) - 1) / 2.0) * ((60n > (((60n) - 0) + 50n) ? 60n : (((60n) - 0) + 50n)) * ((1000n) / (ceil(((1000n) - 5p) / (10u)))))) + ((((ceil(((1000n) - 5p) / (10u))) / 2) - floor((ceil(((1000n) - 5p) / (10u))) / 2) == 0) ? ((100n > (((60n) - 0) + 80n) ? 100n : (((60n) - 0) + 80n)) * ((1000n) / (ceil(((1000n) - 5p) / (10u))))) : 0)) / 1           ad=(((1000n) / (ceil(((1000n) - 5p) / (10u)))) < 119.5n) ? ((floor((ceil(((1000n) - 5p) / (10u))) / 2.0) * (((((60n) - 0) + 60n) * 120n) + (((1000n) / (ceil(((1000n) - 5p) / (10u)))) * 100n))) + ((((ceil(((1000n) - 5p) / (10u))) / 2) - floor((ceil(((1000n) - 5p) / (10u))) / 2) != 0) ? (((50n > (((60n) - 0) + 60n) ? 50n : (((60n) - 0) + 60n)) * 120n) + (((1000n) / (ceil(((1000n) - 5p) / (10u)))) * 50n)) : 0)) / 1 : ((floor((ceil(((1000n) - 5p) / (10u))) / 2.0) * ((60n > (((60n) - 0) + 50n) ? 60n : (((60n) - 0) + 50n)) * ((1000n) / (ceil(((1000n) - 5p) / (10u)))))) + ((((ceil(((1000n) - 5p) / (10u))) / 2) - floor((ceil(((1000n) - 5p) / (10u))) / 2) != 0) ? ((100n > (((60n) - 0) + 80n) ? 100n : (((60n) - 0) + 80n)) * ((1000n) / (ceil(((1000n) - 5p) / (10u))))) : 0)) / 1           ps=(((1000n) / (ceil(((1000n) - 5p) / (10u)))) < 119.5n) ? (((2 * (50n > (((60n) - 0) + 60n) ? 50n : (((60n) - 0) + 60n))) + 340n) + (floor(((ceil(((1000n) - 5p) / (10u))) - 1) / 2.0) * ((2 * (((60n) - 0) + 60n)) + 440n)) + ((((ceil(((1000n) - 5p) / (10u))) / 2) - floor((ceil(((1000n) - 5p) / (10u))) / 2) == 0) ? ((2 * (50n > (((60n) - 0) + 60n) ? 50n : (((60n) - 0) + 60n))) + 340n) : 0)) / 1 : (((2 * (100n > (((60n) - 0) + 80n) ? 100n : (((60n) - 0) + 80n))) + (2 * ((1000n) / (ceil(((1000n) - 5p) / (10u)))))) + (floor(((ceil(((1000n) - 5p) / (10u))) - 1) / 2.0) * ((2 * (60n > (((60n) - 0) + 50n) ? 60n : (((60n) - 0) + 50n))) + (2 * ((1000n) / (ceil(((1000n) - 5p) / (10u))))))) + ((((ceil(((1000n) - 5p) / (10u))) / 2) - floor((ceil(((1000n) - 5p) / (10u))) / 2) == 0) ? ((2 * (100n > (((60n) - 0) + 80n) ? 100n : (((60n) - 0) + 80n))) + (2 * ((1000n) / (ceil(((1000n) - 5p) / (10u)))))) : 0)) / 1           pd=(((1000n) / (ceil(((1000n) - 5p) / (10u)))) < 119.5n) ? ((floor((ceil(((1000n) - 5p) / (10u))) / 2.0) * ((2 * (((60n) - 0) + 60n)) + 440n)) + ((((ceil(((1000n) - 5p) / (10u))) / 2) - floor((ceil(((1000n) - 5p) / (10u))) / 2) != 0) ? ((2 * (50n > (((60n) - 0) + 60n) ? 50n : (((60n) - 0) + 60n))) + 340n) : 0)) / 1 : ((floor((ceil(((1000n) - 5p) / (10u))) / 2.0) * ((2 * (60n > (((60n) - 0) + 50n) ? 60n : (((60n) - 0) + 50n))) + (2 * ((1000n) / (ceil(((1000n) - 5p) / (10u))))))) + ((((ceil(((1000n) - 5p) / (10u))) / 2) - floor((ceil(((1000n) - 5p) / (10u))) / 2) != 0) ? ((2 * (100n > (((60n) - 0) + 80n) ? 100n : (((60n) - 0) + 80n))) + (2 * ((1000n) / (ceil(((1000n) - 5p) / (10u)))))) : 0)) / 1           nrd=(((1000n) / (ceil(((1000n) - 5p) / (10u)))) < 119.5n) ? ((floor((ceil(((1000n) - 5p) / (10u))) / 2.0) * (((((60n) - 0) + 60n) * 120n) + (((1000n) / (ceil(((1000n) - 5p) / (10u)))) * 100n))) + ((((ceil(((1000n) - 5p) / (10u))) / 2) - floor((ceil(((1000n) - 5p) / (10u))) / 2) != 0) ? (((50n > (((60n) - 0) + 60n) ? 50n : (((60n) - 0) + 60n)) * 120n) + (((1000n) / (ceil(((1000n) - 5p) / (10u)))) * 50n)) : 0)) / 1 : ((floor((ceil(((1000n) - 5p) / (10u))) / 2.0) * ((60n > (((60n) - 0) + 50n) ? 60n : (((60n) - 0) + 50n)) * ((1000n) / (ceil(((1000n) - 5p) / (10u)))))) + ((((ceil(((1000n) - 5p) / (10u))) / 2) - floor((ceil(((1000n) - 5p) / (10u))) / 2) != 0) ? ((100n > (((60n) - 0) + 80n) ? 100n : (((60n) - 0) + 80n)) * ((1000n) / (ceil(((1000n) - 5p) / (10u))))) : 0)) / 1 / (((1000n) / (ceil(((1000n) - 5p) / (10u)))) * (ceil(((1000n) - 5p) / (10u))) * ((1000n) / (ceil(((1000n) - 5p) / (10u)))) * (ceil(((1000n) - 5p) / (10u))))           nrs=(((1000n) / (ceil(((1000n) - 5p) / (10u)))) < 119.5n) ? ((((50n > (((60n) - 0) + 60n) ? 50n : (((60n) - 0) + 60n)) * 120n) + (((1000n) / (ceil(((1000n) - 5p) / (10u)))) * 50n)) + (floor(((ceil(((1000n) - 5p) / (10u))) - 1) / 2.0) * (((((60n) - 0) + 60n) * 120n) + (((1000n) / (ceil(((1000n) - 5p) / (10u)))) * 100n))) + ((((ceil(((1000n) - 5p) / (10u))) / 2) - floor((ceil(((1000n) - 5p) / (10u))) / 2) == 0) ? (((50n > (((60n) - 0) + 60n) ? 50n : (((60n) - 0) + 60n)) * 120n) + (((1000n) / (ceil(((1000n) - 5p) / (10u)))) * 50n)) : 0)) / 1 : (((100n > (((60n) - 0) + 80n) ? 100n : (((60n) - 0) + 80n)) * ((1000n) / (ceil(((1000n) - 5p) / (10u))))) + (floor(((ceil(((1000n) - 5p) / (10u))) - 1) / 2.0) * ((60n > (((60n) - 0) + 50n) ? 60n : (((60n) - 0) + 50n)) * ((1000n) / (ceil(((1000n) - 5p) / (10u)))))) + ((((ceil(((1000n) - 5p) / (10u))) / 2) - floor((ceil(((1000n) - 5p) / (10u))) / 2) == 0) ? ((100n > (((60n) - 0) + 80n) ? 100n : (((60n) - 0) + 80n)) * ((1000n) / (ceil(((1000n) - 5p) / (10u))))) : 0)) / 1 / (((1000n) / (ceil(((1000n) - 5p) / (10u)))) * (ceil(((1000n) - 5p) / (10u))) * ((1000n) / (ceil(((1000n) - 5p) / (10u)))) * (ceil(((1000n) - 5p) / (10u))))           sa=(((1000n) / (ceil(((1000n) - 5p) / (10u)))) < 119.5n) ? (50n > (((60n) - 0) + 60n) ? 50n : (((60n) - 0) + 60n)) + 5e-08 : (100n > (((60n) - 0) + 80n) ? 100n : (((60n) - 0) + 80n))           sb=(((1000n) / (ceil(((1000n) - 5p) / (10u)))) < 119.5n) ? (50n > (((60n) - 0) + 60n) ? 50n : (((60n) - 0) + 60n)) + 5e-08 : (100n > (((60n) - 0) + 80n) ? 100n : (((60n) - 0) + 80n))           sd=(((1000n) / (ceil(((1000n) - 5p) / (10u)))) < 119.5n) ? (((60n) - 0) + 60n) + (2*5e-08) : (60n > (((60n) - 0) + 50n) ? 60n : (((60n) - 0) + 50n))           sca=(( ((1000n) / (ceil(((1000n) - 5p) / (10u)))) * ( (((1u) * (1u) / ((((1000n) / (ceil(((1000n) - 5p) / (10u)))) < 119.5n) ? (50n > (((60n) - 0) + 60n) ? 50n : (((60n) - 0) + 60n)) + 5e-08 : (100n > (((60n) - 0) + 80n) ? 100n : (((60n) - 0) + 80n))+60n)) - ((1u) * (1u) / (((((1000n) / (ceil(((1000n) - 5p) / (10u)))) < 119.5n) ? (50n > (((60n) - 0) + 60n) ? 50n : (((60n) - 0) + 60n)) + 5e-08 : (100n > (((60n) - 0) + 80n) ? 100n : (((60n) - 0) + 80n))+60n)+(45n)))) + ((1u) * (1u) / ((((1000n) / (ceil(((1000n) - 5p) / (10u)))) < 119.5n) ? (50n > (((60n) - 0) + 60n) ? 50n : (((60n) - 0) + 60n)) + 5e-08 : (100n > (((60n) - 0) + 80n) ? 100n : (((60n) - 0) + 80n))+60n)) - ((1u) * (1u)/ (((((1000n) / (ceil(((1000n) - 5p) / (10u)))) < 119.5n) ? (50n > (((60n) - 0) + 60n) ? 50n : (((60n) - 0) + 60n)) + 5e-08 : (100n > (((60n) - 0) + 80n) ? 100n : (((60n) - 0) + 80n))+60n)+(45n))))) + ( (45n) * ( (((1u) * (1u) / (60n)) - ((1u) * (1u) / ((60n)+((1000n) / (ceil(((1000n) - 5p) / (10u))))))) + ((1u) * (1u) / (60n)) - ((1u) * (1u)/ ((60n)+((1000n) / (ceil(((1000n) - 5p) / (10u))))))))) / (((1000n) / (ceil(((1000n) - 5p) / (10u)))) * (45n))           scb=((((1000n) / (ceil(((1000n) - 5p) / (10u)))) * ((((((1000n) / (ceil(((1000n) - 5p) / (10u)))) < 119.5n) ? (50n > (((60n) - 0) + 60n) ? 50n : (((60n) - 0) + 60n)) + 5e-08 : (100n > (((60n) - 0) + 80n) ? 100n : (((60n) - 0) + 80n))+60n)/10 + (1u)/100)*exp(-10 * ((((1000n) / (ceil(((1000n) - 5p) / (10u)))) < 119.5n) ? (50n > (((60n) - 0) + 60n) ? 50n : (((60n) - 0) + 60n)) + 5e-08 : (100n > (((60n) - 0) + 80n) ? 100n : (((60n) - 0) + 80n))+60n) / (1u)) - ((((((1000n) / (ceil(((1000n) - 5p) / (10u)))) < 119.5n) ? (50n > (((60n) - 0) + 60n) ? 50n : (((60n) - 0) + 60n)) + 5e-08 : (100n > (((60n) - 0) + 80n) ? 100n : (((60n) - 0) + 80n))+60n)+(45n))/10 + (1u)/100)*exp(-10 * (((((1000n) / (ceil(((1000n) - 5p) / (10u)))) < 119.5n) ? (50n > (((60n) - 0) + 60n) ? 50n : (((60n) - 0) + 60n)) + 5e-08 : (100n > (((60n) - 0) + 80n) ? 100n : (((60n) - 0) + 80n))+60n)+(45n)) / (1u)) + (((((1000n) / (ceil(((1000n) - 5p) / (10u)))) < 119.5n) ? (50n > (((60n) - 0) + 60n) ? 50n : (((60n) - 0) + 60n)) + 5e-08 : (100n > (((60n) - 0) + 80n) ? 100n : (((60n) - 0) + 80n))+60n)/10 + (1u)/100)*exp(-10 * ((((1000n) / (ceil(((1000n) - 5p) / (10u)))) < 119.5n) ? (50n > (((60n) - 0) + 60n) ? 50n : (((60n) - 0) + 60n)) + 5e-08 : (100n > (((60n) - 0) + 80n) ? 100n : (((60n) - 0) + 80n))+60n) / (1u)) - ((((((1000n) / (ceil(((1000n) - 5p) / (10u)))) < 119.5n) ? (50n > (((60n) - 0) + 60n) ? 50n : (((60n) - 0) + 60n)) + 5e-08 : (100n > (((60n) - 0) + 80n) ? 100n : (((60n) - 0) + 80n))+60n)+(45n))/10 + (1u)/100)*exp(-10 * (((((1000n) / (ceil(((1000n) - 5p) / (10u)))) < 119.5n) ? (50n > (((60n) - 0) + 60n) ? 50n : (((60n) - 0) + 60n)) + 5e-08 : (100n > (((60n) - 0) + 80n) ? 100n : (((60n) - 0) + 80n))+60n)+(45n)) / (1u)))) + ((45n) * (((60n)/10 + (1u)/100)*exp(-10 * (60n) / (1u)) - (((60n)+((1000n) / (ceil(((1000n) - 5p) / (10u)))))/10 + (1u)/100)*exp(-10 * ((60n)+((1000n) / (ceil(((1000n) - 5p) / (10u))))) / (1u)) + ((60n)/10 + (1u)/100)*exp(-10 * (60n) / (1u)) - (((60n)+((1000n) / (ceil(((1000n) - 5p) / (10u)))))/10 + (1u)/100)*exp(-10 * ((60n)+((1000n) / (ceil(((1000n) - 5p) / (10u))))) / (1u))))) / (((1000n) / (ceil(((1000n) - 5p) / (10u)))) * (45n))           scc=((((1000n) / (ceil(((1000n) - 5p) / (10u)))) * ((((((1000n) / (ceil(((1000n) - 5p) / (10u)))) < 119.5n) ? (50n > (((60n) - 0) + 60n) ? 50n : (((60n) - 0) + 60n)) + 5e-08 : (100n > (((60n) - 0) + 80n) ? 100n : (((60n) - 0) + 80n))+60n)/20 + (1u)/400)*exp(-20 * ((((1000n) / (ceil(((1000n) - 5p) / (10u)))) < 119.5n) ? (50n > (((60n) - 0) + 60n) ? 50n : (((60n) - 0) + 60n)) + 5e-08 : (100n > (((60n) - 0) + 80n) ? 100n : (((60n) - 0) + 80n))+60n) / (1u)) - ((((((1000n) / (ceil(((1000n) - 5p) / (10u)))) < 119.5n) ? (50n > (((60n) - 0) + 60n) ? 50n : (((60n) - 0) + 60n)) + 5e-08 : (100n > (((60n) - 0) + 80n) ? 100n : (((60n) - 0) + 80n))+60n)+(45n))/20 + (1u)/400)*exp(-20 * (((((1000n) / (ceil(((1000n) - 5p) / (10u)))) < 119.5n) ? (50n > (((60n) - 0) + 60n) ? 50n : (((60n) - 0) + 60n)) + 5e-08 : (100n > (((60n) - 0) + 80n) ? 100n : (((60n) - 0) + 80n))+60n)+(45n)) / (1u)) + (((((1000n) / (ceil(((1000n) - 5p) / (10u)))) < 119.5n) ? (50n > (((60n) - 0) + 60n) ? 50n : (((60n) - 0) + 60n)) + 5e-08 : (100n > (((60n) - 0) + 80n) ? 100n : (((60n) - 0) + 80n))+60n)/20 + (1u)/400)*exp(-20 * ((((1000n) / (ceil(((1000n) - 5p) / (10u)))) < 119.5n) ? (50n > (((60n) - 0) + 60n) ? 50n : (((60n) - 0) + 60n)) + 5e-08 : (100n > (((60n) - 0) + 80n) ? 100n : (((60n) - 0) + 80n))+60n) / (1u)) - ((((((1000n) / (ceil(((1000n) - 5p) / (10u)))) < 119.5n) ? (50n > (((60n) - 0) + 60n) ? 50n : (((60n) - 0) + 60n)) + 5e-08 : (100n > (((60n) - 0) + 80n) ? 100n : (((60n) - 0) + 80n))+60n)+(45n))/20 + (1u)/400)*exp(-20 * (((((1000n) / (ceil(((1000n) - 5p) / (10u)))) < 119.5n) ? (50n > (((60n) - 0) + 60n) ? 50n : (((60n) - 0) + 60n)) + 5e-08 : (100n > (((60n) - 0) + 80n) ? 100n : (((60n) - 0) + 80n))+60n)+(45n)) / (1u)))) + ((45n) * (((60n)/20 + (1u)/400)*exp(-20 * (60n) / (1u)) - (((60n)+((1000n) / (ceil(((1000n) - 5p) / (10u)))))/20 + (1u)/400)*exp(-20 * ((60n)+((1000n) / (ceil(((1000n) - 5p) / (10u))))) / (1u)) + ((60n)/20 + (1u)/400)*exp(-20 * (60n) / (1u)) - (((60n)+((1000n) / (ceil(((1000n) - 5p) / (10u)))))/20 + (1u)/400)*exp(-20 * ((60n)+((1000n) / (ceil(((1000n) - 5p) / (10u))))) / (1u))))) / (((1000n) / (ceil(((1000n) - 5p) / (10u)))) * (45n))           m=(1)
WpBL_bar (BL_bar WENb DINb Vdd) g45p1svt w=(1000n) l=45n nf=ceil(((1000n) - 5p) / (10u))           as=(((1000n) / (ceil(((1000n) - 5p) / (10u)))) < 119.5n) ? ((((50n > (((60n) - 0) + 60n) ? 50n : (((60n) - 0) + 60n)) * 120n) + (((1000n) / (ceil(((1000n) - 5p) / (10u)))) * 50n)) + (floor(((ceil(((1000n) - 5p) / (10u))) - 1) / 2.0) * (((((60n) - 0) + 60n) * 120n) + (((1000n) / (ceil(((1000n) - 5p) / (10u)))) * 100n))) + ((((ceil(((1000n) - 5p) / (10u))) / 2) - floor((ceil(((1000n) - 5p) / (10u))) / 2) == 0) ? (((50n > (((60n) - 0) + 60n) ? 50n : (((60n) - 0) + 60n)) * 120n) + (((1000n) / (ceil(((1000n) - 5p) / (10u)))) * 50n)) : 0)) / 1 : (((100n > (((60n) - 0) + 80n) ? 100n : (((60n) - 0) + 80n)) * ((1000n) / (ceil(((1000n) - 5p) / (10u))))) + (floor(((ceil(((1000n) - 5p) / (10u))) - 1) / 2.0) * ((60n > (((60n) - 0) + 50n) ? 60n : (((60n) - 0) + 50n)) * ((1000n) / (ceil(((1000n) - 5p) / (10u)))))) + ((((ceil(((1000n) - 5p) / (10u))) / 2) - floor((ceil(((1000n) - 5p) / (10u))) / 2) == 0) ? ((100n > (((60n) - 0) + 80n) ? 100n : (((60n) - 0) + 80n)) * ((1000n) / (ceil(((1000n) - 5p) / (10u))))) : 0)) / 1           ad=(((1000n) / (ceil(((1000n) - 5p) / (10u)))) < 119.5n) ? ((floor((ceil(((1000n) - 5p) / (10u))) / 2.0) * (((((60n) - 0) + 60n) * 120n) + (((1000n) / (ceil(((1000n) - 5p) / (10u)))) * 100n))) + ((((ceil(((1000n) - 5p) / (10u))) / 2) - floor((ceil(((1000n) - 5p) / (10u))) / 2) != 0) ? (((50n > (((60n) - 0) + 60n) ? 50n : (((60n) - 0) + 60n)) * 120n) + (((1000n) / (ceil(((1000n) - 5p) / (10u)))) * 50n)) : 0)) / 1 : ((floor((ceil(((1000n) - 5p) / (10u))) / 2.0) * ((60n > (((60n) - 0) + 50n) ? 60n : (((60n) - 0) + 50n)) * ((1000n) / (ceil(((1000n) - 5p) / (10u)))))) + ((((ceil(((1000n) - 5p) / (10u))) / 2) - floor((ceil(((1000n) - 5p) / (10u))) / 2) != 0) ? ((100n > (((60n) - 0) + 80n) ? 100n : (((60n) - 0) + 80n)) * ((1000n) / (ceil(((1000n) - 5p) / (10u))))) : 0)) / 1           ps=(((1000n) / (ceil(((1000n) - 5p) / (10u)))) < 119.5n) ? (((2 * (50n > (((60n) - 0) + 60n) ? 50n : (((60n) - 0) + 60n))) + 340n) + (floor(((ceil(((1000n) - 5p) / (10u))) - 1) / 2.0) * ((2 * (((60n) - 0) + 60n)) + 440n)) + ((((ceil(((1000n) - 5p) / (10u))) / 2) - floor((ceil(((1000n) - 5p) / (10u))) / 2) == 0) ? ((2 * (50n > (((60n) - 0) + 60n) ? 50n : (((60n) - 0) + 60n))) + 340n) : 0)) / 1 : (((2 * (100n > (((60n) - 0) + 80n) ? 100n : (((60n) - 0) + 80n))) + (2 * ((1000n) / (ceil(((1000n) - 5p) / (10u)))))) + (floor(((ceil(((1000n) - 5p) / (10u))) - 1) / 2.0) * ((2 * (60n > (((60n) - 0) + 50n) ? 60n : (((60n) - 0) + 50n))) + (2 * ((1000n) / (ceil(((1000n) - 5p) / (10u))))))) + ((((ceil(((1000n) - 5p) / (10u))) / 2) - floor((ceil(((1000n) - 5p) / (10u))) / 2) == 0) ? ((2 * (100n > (((60n) - 0) + 80n) ? 100n : (((60n) - 0) + 80n))) + (2 * ((1000n) / (ceil(((1000n) - 5p) / (10u)))))) : 0)) / 1           pd=(((1000n) / (ceil(((1000n) - 5p) / (10u)))) < 119.5n) ? ((floor((ceil(((1000n) - 5p) / (10u))) / 2.0) * ((2 * (((60n) - 0) + 60n)) + 440n)) + ((((ceil(((1000n) - 5p) / (10u))) / 2) - floor((ceil(((1000n) - 5p) / (10u))) / 2) != 0) ? ((2 * (50n > (((60n) - 0) + 60n) ? 50n : (((60n) - 0) + 60n))) + 340n) : 0)) / 1 : ((floor((ceil(((1000n) - 5p) / (10u))) / 2.0) * ((2 * (60n > (((60n) - 0) + 50n) ? 60n : (((60n) - 0) + 50n))) + (2 * ((1000n) / (ceil(((1000n) - 5p) / (10u))))))) + ((((ceil(((1000n) - 5p) / (10u))) / 2) - floor((ceil(((1000n) - 5p) / (10u))) / 2) != 0) ? ((2 * (100n > (((60n) - 0) + 80n) ? 100n : (((60n) - 0) + 80n))) + (2 * ((1000n) / (ceil(((1000n) - 5p) / (10u)))))) : 0)) / 1           nrd=(((1000n) / (ceil(((1000n) - 5p) / (10u)))) < 119.5n) ? ((floor((ceil(((1000n) - 5p) / (10u))) / 2.0) * (((((60n) - 0) + 60n) * 120n) + (((1000n) / (ceil(((1000n) - 5p) / (10u)))) * 100n))) + ((((ceil(((1000n) - 5p) / (10u))) / 2) - floor((ceil(((1000n) - 5p) / (10u))) / 2) != 0) ? (((50n > (((60n) - 0) + 60n) ? 50n : (((60n) - 0) + 60n)) * 120n) + (((1000n) / (ceil(((1000n) - 5p) / (10u)))) * 50n)) : 0)) / 1 : ((floor((ceil(((1000n) - 5p) / (10u))) / 2.0) * ((60n > (((60n) - 0) + 50n) ? 60n : (((60n) - 0) + 50n)) * ((1000n) / (ceil(((1000n) - 5p) / (10u)))))) + ((((ceil(((1000n) - 5p) / (10u))) / 2) - floor((ceil(((1000n) - 5p) / (10u))) / 2) != 0) ? ((100n > (((60n) - 0) + 80n) ? 100n : (((60n) - 0) + 80n)) * ((1000n) / (ceil(((1000n) - 5p) / (10u))))) : 0)) / 1 / (((1000n) / (ceil(((1000n) - 5p) / (10u)))) * (ceil(((1000n) - 5p) / (10u))) * ((1000n) / (ceil(((1000n) - 5p) / (10u)))) * (ceil(((1000n) - 5p) / (10u))))           nrs=(((1000n) / (ceil(((1000n) - 5p) / (10u)))) < 119.5n) ? ((((50n > (((60n) - 0) + 60n) ? 50n : (((60n) - 0) + 60n)) * 120n) + (((1000n) / (ceil(((1000n) - 5p) / (10u)))) * 50n)) + (floor(((ceil(((1000n) - 5p) / (10u))) - 1) / 2.0) * (((((60n) - 0) + 60n) * 120n) + (((1000n) / (ceil(((1000n) - 5p) / (10u)))) * 100n))) + ((((ceil(((1000n) - 5p) / (10u))) / 2) - floor((ceil(((1000n) - 5p) / (10u))) / 2) == 0) ? (((50n > (((60n) - 0) + 60n) ? 50n : (((60n) - 0) + 60n)) * 120n) + (((1000n) / (ceil(((1000n) - 5p) / (10u)))) * 50n)) : 0)) / 1 : (((100n > (((60n) - 0) + 80n) ? 100n : (((60n) - 0) + 80n)) * ((1000n) / (ceil(((1000n) - 5p) / (10u))))) + (floor(((ceil(((1000n) - 5p) / (10u))) - 1) / 2.0) * ((60n > (((60n) - 0) + 50n) ? 60n : (((60n) - 0) + 50n)) * ((1000n) / (ceil(((1000n) - 5p) / (10u)))))) + ((((ceil(((1000n) - 5p) / (10u))) / 2) - floor((ceil(((1000n) - 5p) / (10u))) / 2) == 0) ? ((100n > (((60n) - 0) + 80n) ? 100n : (((60n) - 0) + 80n)) * ((1000n) / (ceil(((1000n) - 5p) / (10u))))) : 0)) / 1 / (((1000n) / (ceil(((1000n) - 5p) / (10u)))) * (ceil(((1000n) - 5p) / (10u))) * ((1000n) / (ceil(((1000n) - 5p) / (10u)))) * (ceil(((1000n) - 5p) / (10u))))           sa=(((1000n) / (ceil(((1000n) - 5p) / (10u)))) < 119.5n) ? (50n > (((60n) - 0) + 60n) ? 50n : (((60n) - 0) + 60n)) + 5e-08 : (100n > (((60n) - 0) + 80n) ? 100n : (((60n) - 0) + 80n))           sb=(((1000n) / (ceil(((1000n) - 5p) / (10u)))) < 119.5n) ? (50n > (((60n) - 0) + 60n) ? 50n : (((60n) - 0) + 60n)) + 5e-08 : (100n > (((60n) - 0) + 80n) ? 100n : (((60n) - 0) + 80n))           sd=(((1000n) / (ceil(((1000n) - 5p) / (10u)))) < 119.5n) ? (((60n) - 0) + 60n) + (2*5e-08) : (60n > (((60n) - 0) + 50n) ? 60n : (((60n) - 0) + 50n))           sca=(( ((1000n) / (ceil(((1000n) - 5p) / (10u)))) * ( (((1u) * (1u) / ((((1000n) / (ceil(((1000n) - 5p) / (10u)))) < 119.5n) ? (50n > (((60n) - 0) + 60n) ? 50n : (((60n) - 0) + 60n)) + 5e-08 : (100n > (((60n) - 0) + 80n) ? 100n : (((60n) - 0) + 80n))+60n)) - ((1u) * (1u) / (((((1000n) / (ceil(((1000n) - 5p) / (10u)))) < 119.5n) ? (50n > (((60n) - 0) + 60n) ? 50n : (((60n) - 0) + 60n)) + 5e-08 : (100n > (((60n) - 0) + 80n) ? 100n : (((60n) - 0) + 80n))+60n)+(45n)))) + ((1u) * (1u) / ((((1000n) / (ceil(((1000n) - 5p) / (10u)))) < 119.5n) ? (50n > (((60n) - 0) + 60n) ? 50n : (((60n) - 0) + 60n)) + 5e-08 : (100n > (((60n) - 0) + 80n) ? 100n : (((60n) - 0) + 80n))+60n)) - ((1u) * (1u)/ (((((1000n) / (ceil(((1000n) - 5p) / (10u)))) < 119.5n) ? (50n > (((60n) - 0) + 60n) ? 50n : (((60n) - 0) + 60n)) + 5e-08 : (100n > (((60n) - 0) + 80n) ? 100n : (((60n) - 0) + 80n))+60n)+(45n))))) + ( (45n) * ( (((1u) * (1u) / (60n)) - ((1u) * (1u) / ((60n)+((1000n) / (ceil(((1000n) - 5p) / (10u))))))) + ((1u) * (1u) / (60n)) - ((1u) * (1u)/ ((60n)+((1000n) / (ceil(((1000n) - 5p) / (10u))))))))) / (((1000n) / (ceil(((1000n) - 5p) / (10u)))) * (45n))           scb=((((1000n) / (ceil(((1000n) - 5p) / (10u)))) * ((((((1000n) / (ceil(((1000n) - 5p) / (10u)))) < 119.5n) ? (50n > (((60n) - 0) + 60n) ? 50n : (((60n) - 0) + 60n)) + 5e-08 : (100n > (((60n) - 0) + 80n) ? 100n : (((60n) - 0) + 80n))+60n)/10 + (1u)/100)*exp(-10 * ((((1000n) / (ceil(((1000n) - 5p) / (10u)))) < 119.5n) ? (50n > (((60n) - 0) + 60n) ? 50n : (((60n) - 0) + 60n)) + 5e-08 : (100n > (((60n) - 0) + 80n) ? 100n : (((60n) - 0) + 80n))+60n) / (1u)) - ((((((1000n) / (ceil(((1000n) - 5p) / (10u)))) < 119.5n) ? (50n > (((60n) - 0) + 60n) ? 50n : (((60n) - 0) + 60n)) + 5e-08 : (100n > (((60n) - 0) + 80n) ? 100n : (((60n) - 0) + 80n))+60n)+(45n))/10 + (1u)/100)*exp(-10 * (((((1000n) / (ceil(((1000n) - 5p) / (10u)))) < 119.5n) ? (50n > (((60n) - 0) + 60n) ? 50n : (((60n) - 0) + 60n)) + 5e-08 : (100n > (((60n) - 0) + 80n) ? 100n : (((60n) - 0) + 80n))+60n)+(45n)) / (1u)) + (((((1000n) / (ceil(((1000n) - 5p) / (10u)))) < 119.5n) ? (50n > (((60n) - 0) + 60n) ? 50n : (((60n) - 0) + 60n)) + 5e-08 : (100n > (((60n) - 0) + 80n) ? 100n : (((60n) - 0) + 80n))+60n)/10 + (1u)/100)*exp(-10 * ((((1000n) / (ceil(((1000n) - 5p) / (10u)))) < 119.5n) ? (50n > (((60n) - 0) + 60n) ? 50n : (((60n) - 0) + 60n)) + 5e-08 : (100n > (((60n) - 0) + 80n) ? 100n : (((60n) - 0) + 80n))+60n) / (1u)) - ((((((1000n) / (ceil(((1000n) - 5p) / (10u)))) < 119.5n) ? (50n > (((60n) - 0) + 60n) ? 50n : (((60n) - 0) + 60n)) + 5e-08 : (100n > (((60n) - 0) + 80n) ? 100n : (((60n) - 0) + 80n))+60n)+(45n))/10 + (1u)/100)*exp(-10 * (((((1000n) / (ceil(((1000n) - 5p) / (10u)))) < 119.5n) ? (50n > (((60n) - 0) + 60n) ? 50n : (((60n) - 0) + 60n)) + 5e-08 : (100n > (((60n) - 0) + 80n) ? 100n : (((60n) - 0) + 80n))+60n)+(45n)) / (1u)))) + ((45n) * (((60n)/10 + (1u)/100)*exp(-10 * (60n) / (1u)) - (((60n)+((1000n) / (ceil(((1000n) - 5p) / (10u)))))/10 + (1u)/100)*exp(-10 * ((60n)+((1000n) / (ceil(((1000n) - 5p) / (10u))))) / (1u)) + ((60n)/10 + (1u)/100)*exp(-10 * (60n) / (1u)) - (((60n)+((1000n) / (ceil(((1000n) - 5p) / (10u)))))/10 + (1u)/100)*exp(-10 * ((60n)+((1000n) / (ceil(((1000n) - 5p) / (10u))))) / (1u))))) / (((1000n) / (ceil(((1000n) - 5p) / (10u)))) * (45n))           scc=((((1000n) / (ceil(((1000n) - 5p) / (10u)))) * ((((((1000n) / (ceil(((1000n) - 5p) / (10u)))) < 119.5n) ? (50n > (((60n) - 0) + 60n) ? 50n : (((60n) - 0) + 60n)) + 5e-08 : (100n > (((60n) - 0) + 80n) ? 100n : (((60n) - 0) + 80n))+60n)/20 + (1u)/400)*exp(-20 * ((((1000n) / (ceil(((1000n) - 5p) / (10u)))) < 119.5n) ? (50n > (((60n) - 0) + 60n) ? 50n : (((60n) - 0) + 60n)) + 5e-08 : (100n > (((60n) - 0) + 80n) ? 100n : (((60n) - 0) + 80n))+60n) / (1u)) - ((((((1000n) / (ceil(((1000n) - 5p) / (10u)))) < 119.5n) ? (50n > (((60n) - 0) + 60n) ? 50n : (((60n) - 0) + 60n)) + 5e-08 : (100n > (((60n) - 0) + 80n) ? 100n : (((60n) - 0) + 80n))+60n)+(45n))/20 + (1u)/400)*exp(-20 * (((((1000n) / (ceil(((1000n) - 5p) / (10u)))) < 119.5n) ? (50n > (((60n) - 0) + 60n) ? 50n : (((60n) - 0) + 60n)) + 5e-08 : (100n > (((60n) - 0) + 80n) ? 100n : (((60n) - 0) + 80n))+60n)+(45n)) / (1u)) + (((((1000n) / (ceil(((1000n) - 5p) / (10u)))) < 119.5n) ? (50n > (((60n) - 0) + 60n) ? 50n : (((60n) - 0) + 60n)) + 5e-08 : (100n > (((60n) - 0) + 80n) ? 100n : (((60n) - 0) + 80n))+60n)/20 + (1u)/400)*exp(-20 * ((((1000n) / (ceil(((1000n) - 5p) / (10u)))) < 119.5n) ? (50n > (((60n) - 0) + 60n) ? 50n : (((60n) - 0) + 60n)) + 5e-08 : (100n > (((60n) - 0) + 80n) ? 100n : (((60n) - 0) + 80n))+60n) / (1u)) - ((((((1000n) / (ceil(((1000n) - 5p) / (10u)))) < 119.5n) ? (50n > (((60n) - 0) + 60n) ? 50n : (((60n) - 0) + 60n)) + 5e-08 : (100n > (((60n) - 0) + 80n) ? 100n : (((60n) - 0) + 80n))+60n)+(45n))/20 + (1u)/400)*exp(-20 * (((((1000n) / (ceil(((1000n) - 5p) / (10u)))) < 119.5n) ? (50n > (((60n) - 0) + 60n) ? 50n : (((60n) - 0) + 60n)) + 5e-08 : (100n > (((60n) - 0) + 80n) ? 100n : (((60n) - 0) + 80n))+60n)+(45n)) / (1u)))) + ((45n) * (((60n)/20 + (1u)/400)*exp(-20 * (60n) / (1u)) - (((60n)+((1000n) / (ceil(((1000n) - 5p) / (10u)))))/20 + (1u)/400)*exp(-20 * ((60n)+((1000n) / (ceil(((1000n) - 5p) / (10u))))) / (1u)) + ((60n)/20 + (1u)/400)*exp(-20 * (60n) / (1u)) - (((60n)+((1000n) / (ceil(((1000n) - 5p) / (10u)))))/20 + (1u)/400)*exp(-20 * ((60n)+((1000n) / (ceil(((1000n) - 5p) / (10u))))) / (1u))))) / (((1000n) / (ceil(((1000n) - 5p) / (10u)))) * (45n))           m=(1)
PreBL_bar (BL_bar PREb Vdd Vdd) g45p1svt w=(1000n) l=45n nf=ceil(((1000n) - 5p) / (10u))           as=(((1000n) / (ceil(((1000n) - 5p) / (10u)))) < 119.5n) ? ((((50n > (((60n) - 0) + 60n) ? 50n : (((60n) - 0) + 60n)) * 120n) + (((1000n) / (ceil(((1000n) - 5p) / (10u)))) * 50n)) + (floor(((ceil(((1000n) - 5p) / (10u))) - 1) / 2.0) * (((((60n) - 0) + 60n) * 120n) + (((1000n) / (ceil(((1000n) - 5p) / (10u)))) * 100n))) + ((((ceil(((1000n) - 5p) / (10u))) / 2) - floor((ceil(((1000n) - 5p) / (10u))) / 2) == 0) ? (((50n > (((60n) - 0) + 60n) ? 50n : (((60n) - 0) + 60n)) * 120n) + (((1000n) / (ceil(((1000n) - 5p) / (10u)))) * 50n)) : 0)) / 1 : (((100n > (((60n) - 0) + 80n) ? 100n : (((60n) - 0) + 80n)) * ((1000n) / (ceil(((1000n) - 5p) / (10u))))) + (floor(((ceil(((1000n) - 5p) / (10u))) - 1) / 2.0) * ((60n > (((60n) - 0) + 50n) ? 60n : (((60n) - 0) + 50n)) * ((1000n) / (ceil(((1000n) - 5p) / (10u)))))) + ((((ceil(((1000n) - 5p) / (10u))) / 2) - floor((ceil(((1000n) - 5p) / (10u))) / 2) == 0) ? ((100n > (((60n) - 0) + 80n) ? 100n : (((60n) - 0) + 80n)) * ((1000n) / (ceil(((1000n) - 5p) / (10u))))) : 0)) / 1           ad=(((1000n) / (ceil(((1000n) - 5p) / (10u)))) < 119.5n) ? ((floor((ceil(((1000n) - 5p) / (10u))) / 2.0) * (((((60n) - 0) + 60n) * 120n) + (((1000n) / (ceil(((1000n) - 5p) / (10u)))) * 100n))) + ((((ceil(((1000n) - 5p) / (10u))) / 2) - floor((ceil(((1000n) - 5p) / (10u))) / 2) != 0) ? (((50n > (((60n) - 0) + 60n) ? 50n : (((60n) - 0) + 60n)) * 120n) + (((1000n) / (ceil(((1000n) - 5p) / (10u)))) * 50n)) : 0)) / 1 : ((floor((ceil(((1000n) - 5p) / (10u))) / 2.0) * ((60n > (((60n) - 0) + 50n) ? 60n : (((60n) - 0) + 50n)) * ((1000n) / (ceil(((1000n) - 5p) / (10u)))))) + ((((ceil(((1000n) - 5p) / (10u))) / 2) - floor((ceil(((1000n) - 5p) / (10u))) / 2) != 0) ? ((100n > (((60n) - 0) + 80n) ? 100n : (((60n) - 0) + 80n)) * ((1000n) / (ceil(((1000n) - 5p) / (10u))))) : 0)) / 1           ps=(((1000n) / (ceil(((1000n) - 5p) / (10u)))) < 119.5n) ? (((2 * (50n > (((60n) - 0) + 60n) ? 50n : (((60n) - 0) + 60n))) + 340n) + (floor(((ceil(((1000n) - 5p) / (10u))) - 1) / 2.0) * ((2 * (((60n) - 0) + 60n)) + 440n)) + ((((ceil(((1000n) - 5p) / (10u))) / 2) - floor((ceil(((1000n) - 5p) / (10u))) / 2) == 0) ? ((2 * (50n > (((60n) - 0) + 60n) ? 50n : (((60n) - 0) + 60n))) + 340n) : 0)) / 1 : (((2 * (100n > (((60n) - 0) + 80n) ? 100n : (((60n) - 0) + 80n))) + (2 * ((1000n) / (ceil(((1000n) - 5p) / (10u)))))) + (floor(((ceil(((1000n) - 5p) / (10u))) - 1) / 2.0) * ((2 * (60n > (((60n) - 0) + 50n) ? 60n : (((60n) - 0) + 50n))) + (2 * ((1000n) / (ceil(((1000n) - 5p) / (10u))))))) + ((((ceil(((1000n) - 5p) / (10u))) / 2) - floor((ceil(((1000n) - 5p) / (10u))) / 2) == 0) ? ((2 * (100n > (((60n) - 0) + 80n) ? 100n : (((60n) - 0) + 80n))) + (2 * ((1000n) / (ceil(((1000n) - 5p) / (10u)))))) : 0)) / 1           pd=(((1000n) / (ceil(((1000n) - 5p) / (10u)))) < 119.5n) ? ((floor((ceil(((1000n) - 5p) / (10u))) / 2.0) * ((2 * (((60n) - 0) + 60n)) + 440n)) + ((((ceil(((1000n) - 5p) / (10u))) / 2) - floor((ceil(((1000n) - 5p) / (10u))) / 2) != 0) ? ((2 * (50n > (((60n) - 0) + 60n) ? 50n : (((60n) - 0) + 60n))) + 340n) : 0)) / 1 : ((floor((ceil(((1000n) - 5p) / (10u))) / 2.0) * ((2 * (60n > (((60n) - 0) + 50n) ? 60n : (((60n) - 0) + 50n))) + (2 * ((1000n) / (ceil(((1000n) - 5p) / (10u))))))) + ((((ceil(((1000n) - 5p) / (10u))) / 2) - floor((ceil(((1000n) - 5p) / (10u))) / 2) != 0) ? ((2 * (100n > (((60n) - 0) + 80n) ? 100n : (((60n) - 0) + 80n))) + (2 * ((1000n) / (ceil(((1000n) - 5p) / (10u)))))) : 0)) / 1           nrd=(((1000n) / (ceil(((1000n) - 5p) / (10u)))) < 119.5n) ? ((floor((ceil(((1000n) - 5p) / (10u))) / 2.0) * (((((60n) - 0) + 60n) * 120n) + (((1000n) / (ceil(((1000n) - 5p) / (10u)))) * 100n))) + ((((ceil(((1000n) - 5p) / (10u))) / 2) - floor((ceil(((1000n) - 5p) / (10u))) / 2) != 0) ? (((50n > (((60n) - 0) + 60n) ? 50n : (((60n) - 0) + 60n)) * 120n) + (((1000n) / (ceil(((1000n) - 5p) / (10u)))) * 50n)) : 0)) / 1 : ((floor((ceil(((1000n) - 5p) / (10u))) / 2.0) * ((60n > (((60n) - 0) + 50n) ? 60n : (((60n) - 0) + 50n)) * ((1000n) / (ceil(((1000n) - 5p) / (10u)))))) + ((((ceil(((1000n) - 5p) / (10u))) / 2) - floor((ceil(((1000n) - 5p) / (10u))) / 2) != 0) ? ((100n > (((60n) - 0) + 80n) ? 100n : (((60n) - 0) + 80n)) * ((1000n) / (ceil(((1000n) - 5p) / (10u))))) : 0)) / 1 / (((1000n) / (ceil(((1000n) - 5p) / (10u)))) * (ceil(((1000n) - 5p) / (10u))) * ((1000n) / (ceil(((1000n) - 5p) / (10u)))) * (ceil(((1000n) - 5p) / (10u))))           nrs=(((1000n) / (ceil(((1000n) - 5p) / (10u)))) < 119.5n) ? ((((50n > (((60n) - 0) + 60n) ? 50n : (((60n) - 0) + 60n)) * 120n) + (((1000n) / (ceil(((1000n) - 5p) / (10u)))) * 50n)) + (floor(((ceil(((1000n) - 5p) / (10u))) - 1) / 2.0) * (((((60n) - 0) + 60n) * 120n) + (((1000n) / (ceil(((1000n) - 5p) / (10u)))) * 100n))) + ((((ceil(((1000n) - 5p) / (10u))) / 2) - floor((ceil(((1000n) - 5p) / (10u))) / 2) == 0) ? (((50n > (((60n) - 0) + 60n) ? 50n : (((60n) - 0) + 60n)) * 120n) + (((1000n) / (ceil(((1000n) - 5p) / (10u)))) * 50n)) : 0)) / 1 : (((100n > (((60n) - 0) + 80n) ? 100n : (((60n) - 0) + 80n)) * ((1000n) / (ceil(((1000n) - 5p) / (10u))))) + (floor(((ceil(((1000n) - 5p) / (10u))) - 1) / 2.0) * ((60n > (((60n) - 0) + 50n) ? 60n : (((60n) - 0) + 50n)) * ((1000n) / (ceil(((1000n) - 5p) / (10u)))))) + ((((ceil(((1000n) - 5p) / (10u))) / 2) - floor((ceil(((1000n) - 5p) / (10u))) / 2) == 0) ? ((100n > (((60n) - 0) + 80n) ? 100n : (((60n) - 0) + 80n)) * ((1000n) / (ceil(((1000n) - 5p) / (10u))))) : 0)) / 1 / (((1000n) / (ceil(((1000n) - 5p) / (10u)))) * (ceil(((1000n) - 5p) / (10u))) * ((1000n) / (ceil(((1000n) - 5p) / (10u)))) * (ceil(((1000n) - 5p) / (10u))))           sa=(((1000n) / (ceil(((1000n) - 5p) / (10u)))) < 119.5n) ? (50n > (((60n) - 0) + 60n) ? 50n : (((60n) - 0) + 60n)) + 5e-08 : (100n > (((60n) - 0) + 80n) ? 100n : (((60n) - 0) + 80n))           sb=(((1000n) / (ceil(((1000n) - 5p) / (10u)))) < 119.5n) ? (50n > (((60n) - 0) + 60n) ? 50n : (((60n) - 0) + 60n)) + 5e-08 : (100n > (((60n) - 0) + 80n) ? 100n : (((60n) - 0) + 80n))           sd=(((1000n) / (ceil(((1000n) - 5p) / (10u)))) < 119.5n) ? (((60n) - 0) + 60n) + (2*5e-08) : (60n > (((60n) - 0) + 50n) ? 60n : (((60n) - 0) + 50n))           sca=(( ((1000n) / (ceil(((1000n) - 5p) / (10u)))) * ( (((1u) * (1u) / ((((1000n) / (ceil(((1000n) - 5p) / (10u)))) < 119.5n) ? (50n > (((60n) - 0) + 60n) ? 50n : (((60n) - 0) + 60n)) + 5e-08 : (100n > (((60n) - 0) + 80n) ? 100n : (((60n) - 0) + 80n))+60n)) - ((1u) * (1u) / (((((1000n) / (ceil(((1000n) - 5p) / (10u)))) < 119.5n) ? (50n > (((60n) - 0) + 60n) ? 50n : (((60n) - 0) + 60n)) + 5e-08 : (100n > (((60n) - 0) + 80n) ? 100n : (((60n) - 0) + 80n))+60n)+(45n)))) + ((1u) * (1u) / ((((1000n) / (ceil(((1000n) - 5p) / (10u)))) < 119.5n) ? (50n > (((60n) - 0) + 60n) ? 50n : (((60n) - 0) + 60n)) + 5e-08 : (100n > (((60n) - 0) + 80n) ? 100n : (((60n) - 0) + 80n))+60n)) - ((1u) * (1u)/ (((((1000n) / (ceil(((1000n) - 5p) / (10u)))) < 119.5n) ? (50n > (((60n) - 0) + 60n) ? 50n : (((60n) - 0) + 60n)) + 5e-08 : (100n > (((60n) - 0) + 80n) ? 100n : (((60n) - 0) + 80n))+60n)+(45n))))) + ( (45n) * ( (((1u) * (1u) / (60n)) - ((1u) * (1u) / ((60n)+((1000n) / (ceil(((1000n) - 5p) / (10u))))))) + ((1u) * (1u) / (60n)) - ((1u) * (1u)/ ((60n)+((1000n) / (ceil(((1000n) - 5p) / (10u))))))))) / (((1000n) / (ceil(((1000n) - 5p) / (10u)))) * (45n))           scb=((((1000n) / (ceil(((1000n) - 5p) / (10u)))) * ((((((1000n) / (ceil(((1000n) - 5p) / (10u)))) < 119.5n) ? (50n > (((60n) - 0) + 60n) ? 50n : (((60n) - 0) + 60n)) + 5e-08 : (100n > (((60n) - 0) + 80n) ? 100n : (((60n) - 0) + 80n))+60n)/10 + (1u)/100)*exp(-10 * ((((1000n) / (ceil(((1000n) - 5p) / (10u)))) < 119.5n) ? (50n > (((60n) - 0) + 60n) ? 50n : (((60n) - 0) + 60n)) + 5e-08 : (100n > (((60n) - 0) + 80n) ? 100n : (((60n) - 0) + 80n))+60n) / (1u)) - ((((((1000n) / (ceil(((1000n) - 5p) / (10u)))) < 119.5n) ? (50n > (((60n) - 0) + 60n) ? 50n : (((60n) - 0) + 60n)) + 5e-08 : (100n > (((60n) - 0) + 80n) ? 100n : (((60n) - 0) + 80n))+60n)+(45n))/10 + (1u)/100)*exp(-10 * (((((1000n) / (ceil(((1000n) - 5p) / (10u)))) < 119.5n) ? (50n > (((60n) - 0) + 60n) ? 50n : (((60n) - 0) + 60n)) + 5e-08 : (100n > (((60n) - 0) + 80n) ? 100n : (((60n) - 0) + 80n))+60n)+(45n)) / (1u)) + (((((1000n) / (ceil(((1000n) - 5p) / (10u)))) < 119.5n) ? (50n > (((60n) - 0) + 60n) ? 50n : (((60n) - 0) + 60n)) + 5e-08 : (100n > (((60n) - 0) + 80n) ? 100n : (((60n) - 0) + 80n))+60n)/10 + (1u)/100)*exp(-10 * ((((1000n) / (ceil(((1000n) - 5p) / (10u)))) < 119.5n) ? (50n > (((60n) - 0) + 60n) ? 50n : (((60n) - 0) + 60n)) + 5e-08 : (100n > (((60n) - 0) + 80n) ? 100n : (((60n) - 0) + 80n))+60n) / (1u)) - ((((((1000n) / (ceil(((1000n) - 5p) / (10u)))) < 119.5n) ? (50n > (((60n) - 0) + 60n) ? 50n : (((60n) - 0) + 60n)) + 5e-08 : (100n > (((60n) - 0) + 80n) ? 100n : (((60n) - 0) + 80n))+60n)+(45n))/10 + (1u)/100)*exp(-10 * (((((1000n) / (ceil(((1000n) - 5p) / (10u)))) < 119.5n) ? (50n > (((60n) - 0) + 60n) ? 50n : (((60n) - 0) + 60n)) + 5e-08 : (100n > (((60n) - 0) + 80n) ? 100n : (((60n) - 0) + 80n))+60n)+(45n)) / (1u)))) + ((45n) * (((60n)/10 + (1u)/100)*exp(-10 * (60n) / (1u)) - (((60n)+((1000n) / (ceil(((1000n) - 5p) / (10u)))))/10 + (1u)/100)*exp(-10 * ((60n)+((1000n) / (ceil(((1000n) - 5p) / (10u))))) / (1u)) + ((60n)/10 + (1u)/100)*exp(-10 * (60n) / (1u)) - (((60n)+((1000n) / (ceil(((1000n) - 5p) / (10u)))))/10 + (1u)/100)*exp(-10 * ((60n)+((1000n) / (ceil(((1000n) - 5p) / (10u))))) / (1u))))) / (((1000n) / (ceil(((1000n) - 5p) / (10u)))) * (45n))           scc=((((1000n) / (ceil(((1000n) - 5p) / (10u)))) * ((((((1000n) / (ceil(((1000n) - 5p) / (10u)))) < 119.5n) ? (50n > (((60n) - 0) + 60n) ? 50n : (((60n) - 0) + 60n)) + 5e-08 : (100n > (((60n) - 0) + 80n) ? 100n : (((60n) - 0) + 80n))+60n)/20 + (1u)/400)*exp(-20 * ((((1000n) / (ceil(((1000n) - 5p) / (10u)))) < 119.5n) ? (50n > (((60n) - 0) + 60n) ? 50n : (((60n) - 0) + 60n)) + 5e-08 : (100n > (((60n) - 0) + 80n) ? 100n : (((60n) - 0) + 80n))+60n) / (1u)) - ((((((1000n) / (ceil(((1000n) - 5p) / (10u)))) < 119.5n) ? (50n > (((60n) - 0) + 60n) ? 50n : (((60n) - 0) + 60n)) + 5e-08 : (100n > (((60n) - 0) + 80n) ? 100n : (((60n) - 0) + 80n))+60n)+(45n))/20 + (1u)/400)*exp(-20 * (((((1000n) / (ceil(((1000n) - 5p) / (10u)))) < 119.5n) ? (50n > (((60n) - 0) + 60n) ? 50n : (((60n) - 0) + 60n)) + 5e-08 : (100n > (((60n) - 0) + 80n) ? 100n : (((60n) - 0) + 80n))+60n)+(45n)) / (1u)) + (((((1000n) / (ceil(((1000n) - 5p) / (10u)))) < 119.5n) ? (50n > (((60n) - 0) + 60n) ? 50n : (((60n) - 0) + 60n)) + 5e-08 : (100n > (((60n) - 0) + 80n) ? 100n : (((60n) - 0) + 80n))+60n)/20 + (1u)/400)*exp(-20 * ((((1000n) / (ceil(((1000n) - 5p) / (10u)))) < 119.5n) ? (50n > (((60n) - 0) + 60n) ? 50n : (((60n) - 0) + 60n)) + 5e-08 : (100n > (((60n) - 0) + 80n) ? 100n : (((60n) - 0) + 80n))+60n) / (1u)) - ((((((1000n) / (ceil(((1000n) - 5p) / (10u)))) < 119.5n) ? (50n > (((60n) - 0) + 60n) ? 50n : (((60n) - 0) + 60n)) + 5e-08 : (100n > (((60n) - 0) + 80n) ? 100n : (((60n) - 0) + 80n))+60n)+(45n))/20 + (1u)/400)*exp(-20 * (((((1000n) / (ceil(((1000n) - 5p) / (10u)))) < 119.5n) ? (50n > (((60n) - 0) + 60n) ? 50n : (((60n) - 0) + 60n)) + 5e-08 : (100n > (((60n) - 0) + 80n) ? 100n : (((60n) - 0) + 80n))+60n)+(45n)) / (1u)))) + ((45n) * (((60n)/20 + (1u)/400)*exp(-20 * (60n) / (1u)) - (((60n)+((1000n) / (ceil(((1000n) - 5p) / (10u)))))/20 + (1u)/400)*exp(-20 * ((60n)+((1000n) / (ceil(((1000n) - 5p) / (10u))))) / (1u)) + ((60n)/20 + (1u)/400)*exp(-20 * (60n) / (1u)) - (((60n)+((1000n) / (ceil(((1000n) - 5p) / (10u)))))/20 + (1u)/400)*exp(-20 * ((60n)+((1000n) / (ceil(((1000n) - 5p) / (10u))))) / (1u))))) / (((1000n) / (ceil(((1000n) - 5p) / (10u)))) * (45n))           m=(1)
CBL_bar (BL_bar 0) capacitor c=20f
Equalize (BL PREb BL_bar Vdd) g45p1svt w=(1000n) l=45n nf=ceil(((1000n) - 5p) / (10u))           as=(((1000n) / (ceil(((1000n) - 5p) / (10u)))) < 119.5n) ? ((((50n > (((60n) - 0) + 60n) ? 50n : (((60n) - 0) + 60n)) * 120n) + (((1000n) / (ceil(((1000n) - 5p) / (10u)))) * 50n)) + (floor(((ceil(((1000n) - 5p) / (10u))) - 1) / 2.0) * (((((60n) - 0) + 60n) * 120n) + (((1000n) / (ceil(((1000n) - 5p) / (10u)))) * 100n))) + ((((ceil(((1000n) - 5p) / (10u))) / 2) - floor((ceil(((1000n) - 5p) / (10u))) / 2) == 0) ? (((50n > (((60n) - 0) + 60n) ? 50n : (((60n) - 0) + 60n)) * 120n) + (((1000n) / (ceil(((1000n) - 5p) / (10u)))) * 50n)) : 0)) / 1 : (((100n > (((60n) - 0) + 80n) ? 100n : (((60n) - 0) + 80n)) * ((1000n) / (ceil(((1000n) - 5p) / (10u))))) + (floor(((ceil(((1000n) - 5p) / (10u))) - 1) / 2.0) * ((60n > (((60n) - 0) + 50n) ? 60n : (((60n) - 0) + 50n)) * ((1000n) / (ceil(((1000n) - 5p) / (10u)))))) + ((((ceil(((1000n) - 5p) / (10u))) / 2) - floor((ceil(((1000n) - 5p) / (10u))) / 2) == 0) ? ((100n > (((60n) - 0) + 80n) ? 100n : (((60n) - 0) + 80n)) * ((1000n) / (ceil(((1000n) - 5p) / (10u))))) : 0)) / 1           ad=(((1000n) / (ceil(((1000n) - 5p) / (10u)))) < 119.5n) ? ((floor((ceil(((1000n) - 5p) / (10u))) / 2.0) * (((((60n) - 0) + 60n) * 120n) + (((1000n) / (ceil(((1000n) - 5p) / (10u)))) * 100n))) + ((((ceil(((1000n) - 5p) / (10u))) / 2) - floor((ceil(((1000n) - 5p) / (10u))) / 2) != 0) ? (((50n > (((60n) - 0) + 60n) ? 50n : (((60n) - 0) + 60n)) * 120n) + (((1000n) / (ceil(((1000n) - 5p) / (10u)))) * 50n)) : 0)) / 1 : ((floor((ceil(((1000n) - 5p) / (10u))) / 2.0) * ((60n > (((60n) - 0) + 50n) ? 60n : (((60n) - 0) + 50n)) * ((1000n) / (ceil(((1000n) - 5p) / (10u)))))) + ((((ceil(((1000n) - 5p) / (10u))) / 2) - floor((ceil(((1000n) - 5p) / (10u))) / 2) != 0) ? ((100n > (((60n) - 0) + 80n) ? 100n : (((60n) - 0) + 80n)) * ((1000n) / (ceil(((1000n) - 5p) / (10u))))) : 0)) / 1           ps=(((1000n) / (ceil(((1000n) - 5p) / (10u)))) < 119.5n) ? (((2 * (50n > (((60n) - 0) + 60n) ? 50n : (((60n) - 0) + 60n))) + 340n) + (floor(((ceil(((1000n) - 5p) / (10u))) - 1) / 2.0) * ((2 * (((60n) - 0) + 60n)) + 440n)) + ((((ceil(((1000n) - 5p) / (10u))) / 2) - floor((ceil(((1000n) - 5p) / (10u))) / 2) == 0) ? ((2 * (50n > (((60n) - 0) + 60n) ? 50n : (((60n) - 0) + 60n))) + 340n) : 0)) / 1 : (((2 * (100n > (((60n) - 0) + 80n) ? 100n : (((60n) - 0) + 80n))) + (2 * ((1000n) / (ceil(((1000n) - 5p) / (10u)))))) + (floor(((ceil(((1000n) - 5p) / (10u))) - 1) / 2.0) * ((2 * (60n > (((60n) - 0) + 50n) ? 60n : (((60n) - 0) + 50n))) + (2 * ((1000n) / (ceil(((1000n) - 5p) / (10u))))))) + ((((ceil(((1000n) - 5p) / (10u))) / 2) - floor((ceil(((1000n) - 5p) / (10u))) / 2) == 0) ? ((2 * (100n > (((60n) - 0) + 80n) ? 100n : (((60n) - 0) + 80n))) + (2 * ((1000n) / (ceil(((1000n) - 5p) / (10u)))))) : 0)) / 1           pd=(((1000n) / (ceil(((1000n) - 5p) / (10u)))) < 119.5n) ? ((floor((ceil(((1000n) - 5p) / (10u))) / 2.0) * ((2 * (((60n) - 0) + 60n)) + 440n)) + ((((ceil(((1000n) - 5p) / (10u))) / 2) - floor((ceil(((1000n) - 5p) / (10u))) / 2) != 0) ? ((2 * (50n > (((60n) - 0) + 60n) ? 50n : (((60n) - 0) + 60n))) + 340n) : 0)) / 1 : ((floor((ceil(((1000n) - 5p) / (10u))) / 2.0) * ((2 * (60n > (((60n) - 0) + 50n) ? 60n : (((60n) - 0) + 50n))) + (2 * ((1000n) / (ceil(((1000n) - 5p) / (10u))))))) + ((((ceil(((1000n) - 5p) / (10u))) / 2) - floor((ceil(((1000n) - 5p) / (10u))) / 2) != 0) ? ((2 * (100n > (((60n) - 0) + 80n) ? 100n : (((60n) - 0) + 80n))) + (2 * ((1000n) / (ceil(((1000n) - 5p) / (10u)))))) : 0)) / 1           nrd=(((1000n) / (ceil(((1000n) - 5p) / (10u)))) < 119.5n) ? ((floor((ceil(((1000n) - 5p) / (10u))) / 2.0) * (((((60n) - 0) + 60n) * 120n) + (((1000n) / (ceil(((1000n) - 5p) / (10u)))) * 100n))) + ((((ceil(((1000n) - 5p) / (10u))) / 2) - floor((ceil(((1000n) - 5p) / (10u))) / 2) != 0) ? (((50n > (((60n) - 0) + 60n) ? 50n : (((60n) - 0) + 60n)) * 120n) + (((1000n) / (ceil(((1000n) - 5p) / (10u)))) * 50n)) : 0)) / 1 : ((floor((ceil(((1000n) - 5p) / (10u))) / 2.0) * ((60n > (((60n) - 0) + 50n) ? 60n : (((60n) - 0) + 50n)) * ((1000n) / (ceil(((1000n) - 5p) / (10u)))))) + ((((ceil(((1000n) - 5p) / (10u))) / 2) - floor((ceil(((1000n) - 5p) / (10u))) / 2) != 0) ? ((100n > (((60n) - 0) + 80n) ? 100n : (((60n) - 0) + 80n)) * ((1000n) / (ceil(((1000n) - 5p) / (10u))))) : 0)) / 1 / (((1000n) / (ceil(((1000n) - 5p) / (10u)))) * (ceil(((1000n) - 5p) / (10u))) * ((1000n) / (ceil(((1000n) - 5p) / (10u)))) * (ceil(((1000n) - 5p) / (10u))))           nrs=(((1000n) / (ceil(((1000n) - 5p) / (10u)))) < 119.5n) ? ((((50n > (((60n) - 0) + 60n) ? 50n : (((60n) - 0) + 60n)) * 120n) + (((1000n) / (ceil(((1000n) - 5p) / (10u)))) * 50n)) + (floor(((ceil(((1000n) - 5p) / (10u))) - 1) / 2.0) * (((((60n) - 0) + 60n) * 120n) + (((1000n) / (ceil(((1000n) - 5p) / (10u)))) * 100n))) + ((((ceil(((1000n) - 5p) / (10u))) / 2) - floor((ceil(((1000n) - 5p) / (10u))) / 2) == 0) ? (((50n > (((60n) - 0) + 60n) ? 50n : (((60n) - 0) + 60n)) * 120n) + (((1000n) / (ceil(((1000n) - 5p) / (10u)))) * 50n)) : 0)) / 1 : (((100n > (((60n) - 0) + 80n) ? 100n : (((60n) - 0) + 80n)) * ((1000n) / (ceil(((1000n) - 5p) / (10u))))) + (floor(((ceil(((1000n) - 5p) / (10u))) - 1) / 2.0) * ((60n > (((60n) - 0) + 50n) ? 60n : (((60n) - 0) + 50n)) * ((1000n) / (ceil(((1000n) - 5p) / (10u)))))) + ((((ceil(((1000n) - 5p) / (10u))) / 2) - floor((ceil(((1000n) - 5p) / (10u))) / 2) == 0) ? ((100n > (((60n) - 0) + 80n) ? 100n : (((60n) - 0) + 80n)) * ((1000n) / (ceil(((1000n) - 5p) / (10u))))) : 0)) / 1 / (((1000n) / (ceil(((1000n) - 5p) / (10u)))) * (ceil(((1000n) - 5p) / (10u))) * ((1000n) / (ceil(((1000n) - 5p) / (10u)))) * (ceil(((1000n) - 5p) / (10u))))           sa=(((1000n) / (ceil(((1000n) - 5p) / (10u)))) < 119.5n) ? (50n > (((60n) - 0) + 60n) ? 50n : (((60n) - 0) + 60n)) + 5e-08 : (100n > (((60n) - 0) + 80n) ? 100n : (((60n) - 0) + 80n))           sb=(((1000n) / (ceil(((1000n) - 5p) / (10u)))) < 119.5n) ? (50n > (((60n) - 0) + 60n) ? 50n : (((60n) - 0) + 60n)) + 5e-08 : (100n > (((60n) - 0) + 80n) ? 100n : (((60n) - 0) + 80n))           sd=(((1000n) / (ceil(((1000n) - 5p) / (10u)))) < 119.5n) ? (((60n) - 0) + 60n) + (2*5e-08) : (60n > (((60n) - 0) + 50n) ? 60n : (((60n) - 0) + 50n))           sca=(( ((1000n) / (ceil(((1000n) - 5p) / (10u)))) * ( (((1u) * (1u) / ((((1000n) / (ceil(((1000n) - 5p) / (10u)))) < 119.5n) ? (50n > (((60n) - 0) + 60n) ? 50n : (((60n) - 0) + 60n)) + 5e-08 : (100n > (((60n) - 0) + 80n) ? 100n : (((60n) - 0) + 80n))+60n)) - ((1u) * (1u) / (((((1000n) / (ceil(((1000n) - 5p) / (10u)))) < 119.5n) ? (50n > (((60n) - 0) + 60n) ? 50n : (((60n) - 0) + 60n)) + 5e-08 : (100n > (((60n) - 0) + 80n) ? 100n : (((60n) - 0) + 80n))+60n)+(45n)))) + ((1u) * (1u) / ((((1000n) / (ceil(((1000n) - 5p) / (10u)))) < 119.5n) ? (50n > (((60n) - 0) + 60n) ? 50n : (((60n) - 0) + 60n)) + 5e-08 : (100n > (((60n) - 0) + 80n) ? 100n : (((60n) - 0) + 80n))+60n)) - ((1u) * (1u)/ (((((1000n) / (ceil(((1000n) - 5p) / (10u)))) < 119.5n) ? (50n > (((60n) - 0) + 60n) ? 50n : (((60n) - 0) + 60n)) + 5e-08 : (100n > (((60n) - 0) + 80n) ? 100n : (((60n) - 0) + 80n))+60n)+(45n))))) + ( (45n) * ( (((1u) * (1u) / (60n)) - ((1u) * (1u) / ((60n)+((1000n) / (ceil(((1000n) - 5p) / (10u))))))) + ((1u) * (1u) / (60n)) - ((1u) * (1u)/ ((60n)+((1000n) / (ceil(((1000n) - 5p) / (10u))))))))) / (((1000n) / (ceil(((1000n) - 5p) / (10u)))) * (45n))           scb=((((1000n) / (ceil(((1000n) - 5p) / (10u)))) * ((((((1000n) / (ceil(((1000n) - 5p) / (10u)))) < 119.5n) ? (50n > (((60n) - 0) + 60n) ? 50n : (((60n) - 0) + 60n)) + 5e-08 : (100n > (((60n) - 0) + 80n) ? 100n : (((60n) - 0) + 80n))+60n)/10 + (1u)/100)*exp(-10 * ((((1000n) / (ceil(((1000n) - 5p) / (10u)))) < 119.5n) ? (50n > (((60n) - 0) + 60n) ? 50n : (((60n) - 0) + 60n)) + 5e-08 : (100n > (((60n) - 0) + 80n) ? 100n : (((60n) - 0) + 80n))+60n) / (1u)) - ((((((1000n) / (ceil(((1000n) - 5p) / (10u)))) < 119.5n) ? (50n > (((60n) - 0) + 60n) ? 50n : (((60n) - 0) + 60n)) + 5e-08 : (100n > (((60n) - 0) + 80n) ? 100n : (((60n) - 0) + 80n))+60n)+(45n))/10 + (1u)/100)*exp(-10 * (((((1000n) / (ceil(((1000n) - 5p) / (10u)))) < 119.5n) ? (50n > (((60n) - 0) + 60n) ? 50n : (((60n) - 0) + 60n)) + 5e-08 : (100n > (((60n) - 0) + 80n) ? 100n : (((60n) - 0) + 80n))+60n)+(45n)) / (1u)) + (((((1000n) / (ceil(((1000n) - 5p) / (10u)))) < 119.5n) ? (50n > (((60n) - 0) + 60n) ? 50n : (((60n) - 0) + 60n)) + 5e-08 : (100n > (((60n) - 0) + 80n) ? 100n : (((60n) - 0) + 80n))+60n)/10 + (1u)/100)*exp(-10 * ((((1000n) / (ceil(((1000n) - 5p) / (10u)))) < 119.5n) ? (50n > (((60n) - 0) + 60n) ? 50n : (((60n) - 0) + 60n)) + 5e-08 : (100n > (((60n) - 0) + 80n) ? 100n : (((60n) - 0) + 80n))+60n) / (1u)) - ((((((1000n) / (ceil(((1000n) - 5p) / (10u)))) < 119.5n) ? (50n > (((60n) - 0) + 60n) ? 50n : (((60n) - 0) + 60n)) + 5e-08 : (100n > (((60n) - 0) + 80n) ? 100n : (((60n) - 0) + 80n))+60n)+(45n))/10 + (1u)/100)*exp(-10 * (((((1000n) / (ceil(((1000n) - 5p) / (10u)))) < 119.5n) ? (50n > (((60n) - 0) + 60n) ? 50n : (((60n) - 0) + 60n)) + 5e-08 : (100n > (((60n) - 0) + 80n) ? 100n : (((60n) - 0) + 80n))+60n)+(45n)) / (1u)))) + ((45n) * (((60n)/10 + (1u)/100)*exp(-10 * (60n) / (1u)) - (((60n)+((1000n) / (ceil(((1000n) - 5p) / (10u)))))/10 + (1u)/100)*exp(-10 * ((60n)+((1000n) / (ceil(((1000n) - 5p) / (10u))))) / (1u)) + ((60n)/10 + (1u)/100)*exp(-10 * (60n) / (1u)) - (((60n)+((1000n) / (ceil(((1000n) - 5p) / (10u)))))/10 + (1u)/100)*exp(-10 * ((60n)+((1000n) / (ceil(((1000n) - 5p) / (10u))))) / (1u))))) / (((1000n) / (ceil(((1000n) - 5p) / (10u)))) * (45n))           scc=((((1000n) / (ceil(((1000n) - 5p) / (10u)))) * ((((((1000n) / (ceil(((1000n) - 5p) / (10u)))) < 119.5n) ? (50n > (((60n) - 0) + 60n) ? 50n : (((60n) - 0) + 60n)) + 5e-08 : (100n > (((60n) - 0) + 80n) ? 100n : (((60n) - 0) + 80n))+60n)/20 + (1u)/400)*exp(-20 * ((((1000n) / (ceil(((1000n) - 5p) / (10u)))) < 119.5n) ? (50n > (((60n) - 0) + 60n) ? 50n : (((60n) - 0) + 60n)) + 5e-08 : (100n > (((60n) - 0) + 80n) ? 100n : (((60n) - 0) + 80n))+60n) / (1u)) - ((((((1000n) / (ceil(((1000n) - 5p) / (10u)))) < 119.5n) ? (50n > (((60n) - 0) + 60n) ? 50n : (((60n) - 0) + 60n)) + 5e-08 : (100n > (((60n) - 0) + 80n) ? 100n : (((60n) - 0) + 80n))+60n)+(45n))/20 + (1u)/400)*exp(-20 * (((((1000n) / (ceil(((1000n) - 5p) / (10u)))) < 119.5n) ? (50n > (((60n) - 0) + 60n) ? 50n : (((60n) - 0) + 60n)) + 5e-08 : (100n > (((60n) - 0) + 80n) ? 100n : (((60n) - 0) + 80n))+60n)+(45n)) / (1u)) + (((((1000n) / (ceil(((1000n) - 5p) / (10u)))) < 119.5n) ? (50n > (((60n) - 0) + 60n) ? 50n : (((60n) - 0) + 60n)) + 5e-08 : (100n > (((60n) - 0) + 80n) ? 100n : (((60n) - 0) + 80n))+60n)/20 + (1u)/400)*exp(-20 * ((((1000n) / (ceil(((1000n) - 5p) / (10u)))) < 119.5n) ? (50n > (((60n) - 0) + 60n) ? 50n : (((60n) - 0) + 60n)) + 5e-08 : (100n > (((60n) - 0) + 80n) ? 100n : (((60n) - 0) + 80n))+60n) / (1u)) - ((((((1000n) / (ceil(((1000n) - 5p) / (10u)))) < 119.5n) ? (50n > (((60n) - 0) + 60n) ? 50n : (((60n) - 0) + 60n)) + 5e-08 : (100n > (((60n) - 0) + 80n) ? 100n : (((60n) - 0) + 80n))+60n)+(45n))/20 + (1u)/400)*exp(-20 * (((((1000n) / (ceil(((1000n) - 5p) / (10u)))) < 119.5n) ? (50n > (((60n) - 0) + 60n) ? 50n : (((60n) - 0) + 60n)) + 5e-08 : (100n > (((60n) - 0) + 80n) ? 100n : (((60n) - 0) + 80n))+60n)+(45n)) / (1u)))) + ((45n) * (((60n)/20 + (1u)/400)*exp(-20 * (60n) / (1u)) - (((60n)+((1000n) / (ceil(((1000n) - 5p) / (10u)))))/20 + (1u)/400)*exp(-20 * ((60n)+((1000n) / (ceil(((1000n) - 5p) / (10u))))) / (1u)) + ((60n)/20 + (1u)/400)*exp(-20 * (60n) / (1u)) - (((60n)+((1000n) / (ceil(((1000n) - 5p) / (10u)))))/20 + (1u)/400)*exp(-20 * ((60n)+((1000n) / (ceil(((1000n) - 5p) / (10u))))) / (1u))))) / (((1000n) / (ceil(((1000n) - 5p) / (10u)))) * (45n))           m=(1)
ic Q=0 Q_bar=vdd
tran tran stop=160n maxstep=100p errpreset=conservative
save WL WEN PREb DIN BL BL_bar Q Q_bar
