simulator lang=spectre
subckt sram_cell (BL BL_bar WL Q Q_bar Vdd GND)
PM0 (Q_bar Q Vdd Vdd) g45p1svt w=(120n) l=45n nf=ceil(((120n) - 5p) / (10u))           as=(((120n) / (ceil(((120n) - 5p) / (10u)))) < 119.5n) ? ((((50n > (((60n) - 0) + 60n) ? 50n : (((60n) - 0) + 60n)) * 120n) + (((120n) / (ceil(((120n) - 5p) / (10u)))) * 50n)) + (floor(((ceil(((120n) - 5p) / (10u))) - 1) / 2.0) * (((((60n) - 0) + 60n) * 120n) + (((120n) / (ceil(((120n) - 5p) / (10u)))) * 100n))) + ((((ceil(((120n) - 5p) / (10u))) / 2) - floor((ceil(((120n) - 5p) / (10u))) / 2) == 0) ? (((50n > (((60n) - 0) + 60n) ? 50n : (((60n) - 0) + 60n)) * 120n) + (((120n) / (ceil(((120n) - 5p) / (10u)))) * 50n)) : 0)) / 1 : (((100n > (((60n) - 0) + 80n) ? 100n : (((60n) - 0) + 80n)) * ((120n) / (ceil(((120n) - 5p) / (10u))))) + (floor(((ceil(((120n) - 5p) / (10u))) - 1) / 2.0) * ((60n > (((60n) - 0) + 50n) ? 60n : (((60n) - 0) + 50n)) * ((120n) / (ceil(((120n) - 5p) / (10u)))))) + ((((ceil(((120n) - 5p) / (10u))) / 2) - floor((ceil(((120n) - 5p) / (10u))) / 2) == 0) ? ((100n > (((60n) - 0) + 80n) ? 100n : (((60n) - 0) + 80n)) * ((120n) / (ceil(((120n) - 5p) / (10u))))) : 0)) / 1           ad=(((120n) / (ceil(((120n) - 5p) / (10u)))) < 119.5n) ? ((floor((ceil(((120n) - 5p) / (10u))) / 2.0) * (((((60n) - 0) + 60n) * 120n) + (((120n) / (ceil(((120n) - 5p) / (10u)))) * 100n))) + ((((ceil(((120n) - 5p) / (10u))) / 2) - floor((ceil(((120n) - 5p) / (10u))) / 2) != 0) ? (((50n > (((60n) - 0) + 60n) ? 50n : (((60n) - 0) + 60n)) * 120n) + (((120n) / (ceil(((120n) - 5p) / (10u)))) * 50n)) : 0)) / 1 : ((floor((ceil(((120n) - 5p) / (10u))) / 2.0) * ((60n > (((60n) - 0) + 50n) ? 60n : (((60n) - 0) + 50n)) * ((120n) / (ceil(((120n) - 5p) / (10u)))))) + ((((ceil(((120n) - 5p) / (10u))) / 2) - floor((ceil(((120n) - 5p) / (10u))) / 2) != 0) ? ((100n > (((60n) - 0) + 80n) ? 100n : (((60n) - 0) + 80n)) * ((120n) / (ceil(((120n) - 5p) / (10u))))) : 0)) / 1           ps=(((120n) / (ceil(((120n) - 5p) / (10u)))) < 119.5n) ? (((2 * (50n > (((60n) - 0) + 60n) ? 50n : (((60n) - 0) + 60n))) + 340n) + (floor(((ceil(((120n) - 5p) / (10u))) - 1) / 2.0) * ((2 * (((60n) - 0) + 60n)) + 440n)) + ((((ceil(((120n) - 5p) / (10u))) / 2) - floor((ceil(((120n) - 5p) / (10u))) / 2) == 0) ? ((2 * (50n > (((60n) - 0) + 60n) ? 50n : (((60n) - 0) + 60n))) + 340n) : 0)) / 1 : (((2 * (100n > (((60n) - 0) + 80n) ? 100n : (((60n) - 0) + 80n))) + (2 * ((120n) / (ceil(((120n) - 5p) / (10u)))))) + (floor(((ceil(((120n) - 5p) / (10u))) - 1) / 2.0) * ((2 * (60n > (((60n) - 0) + 50n) ? 60n : (((60n) - 0) + 50n))) + (2 * ((120n) / (ceil(((120n) - 5p) / (10u))))))) + ((((ceil(((120n) - 5p) / (10u))) / 2) - floor((ceil(((120n) - 5p) / (10u))) / 2) == 0) ? ((2 * (100n > (((60n) - 0) + 80n) ? 100n : (((60n) - 0) + 80n))) + (2 * ((120n) / (ceil(((120n) - 5p) / (10u)))))) : 0)) / 1           pd=(((120n) / (ceil(((120n) - 5p) / (10u)))) < 119.5n) ? ((floor((ceil(((120n) - 5p) / (10u))) / 2.0) * ((2 * (((60n) - 0) + 60n)) + 440n)) + ((((ceil(((120n) - 5p) / (10u))) / 2) - floor((ceil(((120n) - 5p) / (10u))) / 2) != 0) ? ((2 * (50n > (((60n) - 0) + 60n) ? 50n : (((60n) - 0) + 60n))) + 340n) : 0)) / 1 : ((floor((ceil(((120n) - 5p) / (10u))) / 2.0) * ((2 * (60n > (((60n) - 0) + 50n) ? 60n : (((60n) - 0) + 50n))) + (2 * ((120n) / (ceil(((120n) - 5p) / (10u))))))) + ((((ceil(((120n) - 5p) / (10u))) / 2) - floor((ceil(((120n) - 5p) / (10u))) / 2) != 0) ? ((2 * (100n > (((60n) - 0) + 80n) ? 100n : (((60n) - 0) + 80n))) + (2 * ((120n) / (ceil(((120n) - 5p) / (10u)))))) : 0)) / 1           nrd=(((120n) / (ceil(((120n) - 5p) / (10u)))) < 119.5n) ? ((floor((ceil(((120n) - 5p) / (10u))) / 2.0) * (((((60n) - 0) + 60n) * 120n) + (((120n) / (ceil(((120n) - 5p) / (10u)))) * 100n))) + ((((ceil(((120n) - 5p) / (10u))) / 2) - floor((ceil(((120n) - 5p) / (10u))) / 2) != 0) ? (((50n > (((60n) - 0) + 60n) ? 50n : (((60n) - 0) + 60n)) * 120n) + (((120n) / (ceil(((120n) - 5p) / (10u)))) * 50n)) : 0)) / 1 : ((floor((ceil(((120n) - 5p) / (10u))) / 2.0) * ((60n > (((60n) - 0) + 50n) ? 60n : (((60n) - 0) + 50n)) * ((120n) / (ceil(((120n) - 5p) / (10u)))))) + ((((ceil(((120n) - 5p) / (10u))) / 2) - floor((ceil(((120n) - 5p) / (10u))) / 2) != 0) ? ((100n > (((60n) - 0) + 80n) ? 100n : (((60n) - 0) + 80n)) * ((120n) / (ceil(((120n) - 5p) / (10u))))) : 0)) / 1 / (((120n) / (ceil(((120n) - 5p) / (10u)))) * (ceil(((120n) - 5p) / (10u))) * ((120n) / (ceil(((120n) - 5p) / (10u)))) * (ceil(((120n) - 5p) / (10u))))           nrs=(((120n) / (ceil(((120n) - 5p) / (10u)))) < 119.5n) ? ((((50n > (((60n) - 0) + 60n) ? 50n : (((60n) - 0) + 60n)) * 120n) + (((120n) / (ceil(((120n) - 5p) / (10u)))) * 50n)) + (floor(((ceil(((120n) - 5p) / (10u))) - 1) / 2.0) * (((((60n) - 0) + 60n) * 120n) + (((120n) / (ceil(((120n) - 5p) / (10u)))) * 100n))) + ((((ceil(((120n) - 5p) / (10u))) / 2) - floor((ceil(((120n) - 5p) / (10u))) / 2) == 0) ? (((50n > (((60n) - 0) + 60n) ? 50n : (((60n) - 0) + 60n)) * 120n) + (((120n) / (ceil(((120n) - 5p) / (10u)))) * 50n)) : 0)) / 1 : (((100n > (((60n) - 0) + 80n) ? 100n : (((60n) - 0) + 80n)) * ((120n) / (ceil(((120n) - 5p) / (10u))))) + (floor(((ceil(((120n) - 5p) / (10u))) - 1) / 2.0) * ((60n > (((60n) - 0) + 50n) ? 60n : (((60n) - 0) + 50n)) * ((120n) / (ceil(((120n) - 5p) / (10u)))))) + ((((ceil(((120n) - 5p) / (10u))) / 2) - floor((ceil(((120n) - 5p) / (10u))) / 2) == 0) ? ((100n > (((60n) - 0) + 80n) ? 100n : (((60n) - 0) + 80n)) * ((120n) / (ceil(((120n) - 5p) / (10u))))) : 0)) / 1 / (((120n) / (ceil(((120n) - 5p) / (10u)))) * (ceil(((120n) - 5p) / (10u))) * ((120n) / (ceil(((120n) - 5p) / (10u)))) * (ceil(((120n) - 5p) / (10u))))           sa=(((120n) / (ceil(((120n) - 5p) / (10u)))) < 119.5n) ? (50n > (((60n) - 0) + 60n) ? 50n : (((60n) - 0) + 60n)) + 5e-08 : (100n > (((60n) - 0) + 80n) ? 100n : (((60n) - 0) + 80n))           sb=(((120n) / (ceil(((120n) - 5p) / (10u)))) < 119.5n) ? (50n > (((60n) - 0) + 60n) ? 50n : (((60n) - 0) + 60n)) + 5e-08 : (100n > (((60n) - 0) + 80n) ? 100n : (((60n) - 0) + 80n))           sd=(((120n) / (ceil(((120n) - 5p) / (10u)))) < 119.5n) ? (((60n) - 0) + 60n) + (2*5e-08) : (60n > (((60n) - 0) + 50n) ? 60n : (((60n) - 0) + 50n))           sca=(( ((120n) / (ceil(((120n) - 5p) / (10u)))) * ( (((1u) * (1u) / ((((120n) / (ceil(((120n) - 5p) / (10u)))) < 119.5n) ? (50n > (((60n) - 0) + 60n) ? 50n : (((60n) - 0) + 60n)) + 5e-08 : (100n > (((60n) - 0) + 80n) ? 100n : (((60n) - 0) + 80n))+60n)) - ((1u) * (1u) / (((((120n) / (ceil(((120n) - 5p) / (10u)))) < 119.5n) ? (50n > (((60n) - 0) + 60n) ? 50n : (((60n) - 0) + 60n)) + 5e-08 : (100n > (((60n) - 0) + 80n) ? 100n : (((60n) - 0) + 80n))+60n)+(45n)))) + ((1u) * (1u) / ((((120n) / (ceil(((120n) - 5p) / (10u)))) < 119.5n) ? (50n > (((60n) - 0) + 60n) ? 50n : (((60n) - 0) + 60n)) + 5e-08 : (100n > (((60n) - 0) + 80n) ? 100n : (((60n) - 0) + 80n))+60n)) - ((1u) * (1u)/ (((((120n) / (ceil(((120n) - 5p) / (10u)))) < 119.5n) ? (50n > (((60n) - 0) + 60n) ? 50n : (((60n) - 0) + 60n)) + 5e-08 : (100n > (((60n) - 0) + 80n) ? 100n : (((60n) - 0) + 80n))+60n)+(45n))))) + ( (45n) * ( (((1u) * (1u) / (60n)) - ((1u) * (1u) / ((60n)+((120n) / (ceil(((120n) - 5p) / (10u))))))) + ((1u) * (1u) / (60n)) - ((1u) * (1u)/ ((60n)+((120n) / (ceil(((120n) - 5p) / (10u))))))))) / (((120n) / (ceil(((120n) - 5p) / (10u)))) * (45n))           scb=((((120n) / (ceil(((120n) - 5p) / (10u)))) * ((((((120n) / (ceil(((120n) - 5p) / (10u)))) < 119.5n) ? (50n > (((60n) - 0) + 60n) ? 50n : (((60n) - 0) + 60n)) + 5e-08 : (100n > (((60n) - 0) + 80n) ? 100n : (((60n) - 0) + 80n))+60n)/10 + (1u)/100)*exp(-10 * ((((120n) / (ceil(((120n) - 5p) / (10u)))) < 119.5n) ? (50n > (((60n) - 0) + 60n) ? 50n : (((60n) - 0) + 60n)) + 5e-08 : (100n > (((60n) - 0) + 80n) ? 100n : (((60n) - 0) + 80n))+60n) / (1u)) - ((((((120n) / (ceil(((120n) - 5p) / (10u)))) < 119.5n) ? (50n > (((60n) - 0) + 60n) ? 50n : (((60n) - 0) + 60n)) + 5e-08 : (100n > (((60n) - 0) + 80n) ? 100n : (((60n) - 0) + 80n))+60n)+(45n))/10 + (1u)/100)*exp(-10 * (((((120n) / (ceil(((120n) - 5p) / (10u)))) < 119.5n) ? (50n > (((60n) - 0) + 60n) ? 50n : (((60n) - 0) + 60n)) + 5e-08 : (100n > (((60n) - 0) + 80n) ? 100n : (((60n) - 0) + 80n))+60n)+(45n)) / (1u)) + (((((120n) / (ceil(((120n) - 5p) / (10u)))) < 119.5n) ? (50n > (((60n) - 0) + 60n) ? 50n : (((60n) - 0) + 60n)) + 5e-08 : (100n > (((60n) - 0) + 80n) ? 100n : (((60n) - 0) + 80n))+60n)/10 + (1u)/100)*exp(-10 * ((((120n) / (ceil(((120n) - 5p) / (10u)))) < 119.5n) ? (50n > (((60n) - 0) + 60n) ? 50n : (((60n) - 0) + 60n)) + 5e-08 : (100n > (((60n) - 0) + 80n) ? 100n : (((60n) - 0) + 80n))+60n) / (1u)) - ((((((120n) / (ceil(((120n) - 5p) / (10u)))) < 119.5n) ? (50n > (((60n) - 0) + 60n) ? 50n : (((60n) - 0) + 60n)) + 5e-08 : (100n > (((60n) - 0) + 80n) ? 100n : (((60n) - 0) + 80n))+60n)+(45n))/10 + (1u)/100)*exp(-10 * (((((120n) / (ceil(((120n) - 5p) / (10u)))) < 119.5n) ? (50n > (((60n) - 0) + 60n) ? 50n : (((60n) - 0) + 60n)) + 5e-08 : (100n > (((60n) - 0) + 80n) ? 100n : (((60n) - 0) + 80n))+60n)+(45n)) / (1u)))) + ((45n) * (((60n)/10 + (1u)/100)*exp(-10 * (60n) / (1u)) - (((60n)+((120n) / (ceil(((120n) - 5p) / (10u)))))/10 + (1u)/100)*exp(-10 * ((60n)+((120n) / (ceil(((120n) - 5p) / (10u))))) / (1u)) + ((60n)/10 + (1u)/100)*exp(-10 * (60n) / (1u)) - (((60n)+((120n) / (ceil(((120n) - 5p) / (10u)))))/10 + (1u)/100)*exp(-10 * ((60n)+((120n) / (ceil(((120n) - 5p) / (10u))))) / (1u))))) / (((120n) / (ceil(((120n) - 5p) / (10u)))) * (45n))           scc=((((120n) / (ceil(((120n) - 5p) / (10u)))) * ((((((120n) / (ceil(((120n) - 5p) / (10u)))) < 119.5n) ? (50n > (((60n) - 0) + 60n) ? 50n : (((60n) - 0) + 60n)) + 5e-08 : (100n > (((60n) - 0) + 80n) ? 100n : (((60n) - 0) + 80n))+60n)/20 + (1u)/400)*exp(-20 * ((((120n) / (ceil(((120n) - 5p) / (10u)))) < 119.5n) ? (50n > (((60n) - 0) + 60n) ? 50n : (((60n) - 0) + 60n)) + 5e-08 : (100n > (((60n) - 0) + 80n) ? 100n : (((60n) - 0) + 80n))+60n) / (1u)) - ((((((120n) / (ceil(((120n) - 5p) / (10u)))) < 119.5n) ? (50n > (((60n) - 0) + 60n) ? 50n : (((60n) - 0) + 60n)) + 5e-08 : (100n > (((60n) - 0) + 80n) ? 100n : (((60n) - 0) + 80n))+60n)+(45n))/20 + (1u)/400)*exp(-20 * (((((120n) / (ceil(((120n) - 5p) / (10u)))) < 119.5n) ? (50n > (((60n) - 0) + 60n) ? 50n : (((60n) - 0) + 60n)) + 5e-08 : (100n > (((60n) - 0) + 80n) ? 100n : (((60n) - 0) + 80n))+60n)+(45n)) / (1u)) + (((((120n) / (ceil(((120n) - 5p) / (10u)))) < 119.5n) ? (50n > (((60n) - 0) + 60n) ? 50n : (((60n) - 0) + 60n)) + 5e-08 : (100n > (((60n) - 0) + 80n) ? 100n : (((60n) - 0) + 80n))+60n)/20 + (1u)/400)*exp(-20 * ((((120n) / (ceil(((120n) - 5p) / (10u)))) < 119.5n) ? (50n > (((60n) - 0) + 60n) ? 50n : (((60n) - 0) + 60n)) + 5e-08 : (100n > (((60n) - 0) + 80n) ? 100n : (((60n) - 0) + 80n))+60n) / (1u)) - ((((((120n) / (ceil(((120n) - 5p) / (10u)))) < 119.5n) ? (50n > (((60n) - 0) + 60n) ? 50n : (((60n) - 0) + 60n)) + 5e-08 : (100n > (((60n) - 0) + 80n) ? 100n : (((60n) - 0) + 80n))+60n)+(45n))/20 + (1u)/400)*exp(-20 * (((((120n) / (ceil(((120n) - 5p) / (10u)))) < 119.5n) ? (50n > (((60n) - 0) + 60n) ? 50n : (((60n) - 0) + 60n)) + 5e-08 : (100n > (((60n) - 0) + 80n) ? 100n : (((60n) - 0) + 80n))+60n)+(45n)) / (1u)))) + ((45n) * (((60n)/20 + (1u)/400)*exp(-20 * (60n) / (1u)) - (((60n)+((120n) / (ceil(((120n) - 5p) / (10u)))))/20 + (1u)/400)*exp(-20 * ((60n)+((120n) / (ceil(((120n) - 5p) / (10u))))) / (1u)) + ((60n)/20 + (1u)/400)*exp(-20 * (60n) / (1u)) - (((60n)+((120n) / (ceil(((120n) - 5p) / (10u)))))/20 + (1u)/400)*exp(-20 * ((60n)+((120n) / (ceil(((120n) - 5p) / (10u))))) / (1u))))) / (((120n) / (ceil(((120n) - 5p) / (10u)))) * (45n))           m=(1)
PM1 (Q Q_bar Vdd Vdd) g45p1svt w=(120n) l=45n nf=ceil(((120n) - 5p) / (10u))           as=(((120n) / (ceil(((120n) - 5p) / (10u)))) < 119.5n) ? ((((50n > (((60n) - 0) + 60n) ? 50n : (((60n) - 0) + 60n)) * 120n) + (((120n) / (ceil(((120n) - 5p) / (10u)))) * 50n)) + (floor(((ceil(((120n) - 5p) / (10u))) - 1) / 2.0) * (((((60n) - 0) + 60n) * 120n) + (((120n) / (ceil(((120n) - 5p) / (10u)))) * 100n))) + ((((ceil(((120n) - 5p) / (10u))) / 2) - floor((ceil(((120n) - 5p) / (10u))) / 2) == 0) ? (((50n > (((60n) - 0) + 60n) ? 50n : (((60n) - 0) + 60n)) * 120n) + (((120n) / (ceil(((120n) - 5p) / (10u)))) * 50n)) : 0)) / 1 : (((100n > (((60n) - 0) + 80n) ? 100n : (((60n) - 0) + 80n)) * ((120n) / (ceil(((120n) - 5p) / (10u))))) + (floor(((ceil(((120n) - 5p) / (10u))) - 1) / 2.0) * ((60n > (((60n) - 0) + 50n) ? 60n : (((60n) - 0) + 50n)) * ((120n) / (ceil(((120n) - 5p) / (10u)))))) + ((((ceil(((120n) - 5p) / (10u))) / 2) - floor((ceil(((120n) - 5p) / (10u))) / 2) == 0) ? ((100n > (((60n) - 0) + 80n) ? 100n : (((60n) - 0) + 80n)) * ((120n) / (ceil(((120n) - 5p) / (10u))))) : 0)) / 1           ad=(((120n) / (ceil(((120n) - 5p) / (10u)))) < 119.5n) ? ((floor((ceil(((120n) - 5p) / (10u))) / 2.0) * (((((60n) - 0) + 60n) * 120n) + (((120n) / (ceil(((120n) - 5p) / (10u)))) * 100n))) + ((((ceil(((120n) - 5p) / (10u))) / 2) - floor((ceil(((120n) - 5p) / (10u))) / 2) != 0) ? (((50n > (((60n) - 0) + 60n) ? 50n : (((60n) - 0) + 60n)) * 120n) + (((120n) / (ceil(((120n) - 5p) / (10u)))) * 50n)) : 0)) / 1 : ((floor((ceil(((120n) - 5p) / (10u))) / 2.0) * ((60n > (((60n) - 0) + 50n) ? 60n : (((60n) - 0) + 50n)) * ((120n) / (ceil(((120n) - 5p) / (10u)))))) + ((((ceil(((120n) - 5p) / (10u))) / 2) - floor((ceil(((120n) - 5p) / (10u))) / 2) != 0) ? ((100n > (((60n) - 0) + 80n) ? 100n : (((60n) - 0) + 80n)) * ((120n) / (ceil(((120n) - 5p) / (10u))))) : 0)) / 1           ps=(((120n) / (ceil(((120n) - 5p) / (10u)))) < 119.5n) ? (((2 * (50n > (((60n) - 0) + 60n) ? 50n : (((60n) - 0) + 60n))) + 340n) + (floor(((ceil(((120n) - 5p) / (10u))) - 1) / 2.0) * ((2 * (((60n) - 0) + 60n)) + 440n)) + ((((ceil(((120n) - 5p) / (10u))) / 2) - floor((ceil(((120n) - 5p) / (10u))) / 2) == 0) ? ((2 * (50n > (((60n) - 0) + 60n) ? 50n : (((60n) - 0) + 60n))) + 340n) : 0)) / 1 : (((2 * (100n > (((60n) - 0) + 80n) ? 100n : (((60n) - 0) + 80n))) + (2 * ((120n) / (ceil(((120n) - 5p) / (10u)))))) + (floor(((ceil(((120n) - 5p) / (10u))) - 1) / 2.0) * ((2 * (60n > (((60n) - 0) + 50n) ? 60n : (((60n) - 0) + 50n))) + (2 * ((120n) / (ceil(((120n) - 5p) / (10u))))))) + ((((ceil(((120n) - 5p) / (10u))) / 2) - floor((ceil(((120n) - 5p) / (10u))) / 2) == 0) ? ((2 * (100n > (((60n) - 0) + 80n) ? 100n : (((60n) - 0) + 80n))) + (2 * ((120n) / (ceil(((120n) - 5p) / (10u)))))) : 0)) / 1           pd=(((120n) / (ceil(((120n) - 5p) / (10u)))) < 119.5n) ? ((floor((ceil(((120n) - 5p) / (10u))) / 2.0) * ((2 * (((60n) - 0) + 60n)) + 440n)) + ((((ceil(((120n) - 5p) / (10u))) / 2) - floor((ceil(((120n) - 5p) / (10u))) / 2) != 0) ? ((2 * (50n > (((60n) - 0) + 60n) ? 50n : (((60n) - 0) + 60n))) + 340n) : 0)) / 1 : ((floor((ceil(((120n) - 5p) / (10u))) / 2.0) * ((2 * (60n > (((60n) - 0) + 50n) ? 60n : (((60n) - 0) + 50n))) + (2 * ((120n) / (ceil(((120n) - 5p) / (10u))))))) + ((((ceil(((120n) - 5p) / (10u))) / 2) - floor((ceil(((120n) - 5p) / (10u))) / 2) != 0) ? ((2 * (100n > (((60n) - 0) + 80n) ? 100n : (((60n) - 0) + 80n))) + (2 * ((120n) / (ceil(((120n) - 5p) / (10u)))))) : 0)) / 1           nrd=(((120n) / (ceil(((120n) - 5p) / (10u)))) < 119.5n) ? ((floor((ceil(((120n) - 5p) / (10u))) / 2.0) * (((((60n) - 0) + 60n) * 120n) + (((120n) / (ceil(((120n) - 5p) / (10u)))) * 100n))) + ((((ceil(((120n) - 5p) / (10u))) / 2) - floor((ceil(((120n) - 5p) / (10u))) / 2) != 0) ? (((50n > (((60n) - 0) + 60n) ? 50n : (((60n) - 0) + 60n)) * 120n) + (((120n) / (ceil(((120n) - 5p) / (10u)))) * 50n)) : 0)) / 1 : ((floor((ceil(((120n) - 5p) / (10u))) / 2.0) * ((60n > (((60n) - 0) + 50n) ? 60n : (((60n) - 0) + 50n)) * ((120n) / (ceil(((120n) - 5p) / (10u)))))) + ((((ceil(((120n) - 5p) / (10u))) / 2) - floor((ceil(((120n) - 5p) / (10u))) / 2) != 0) ? ((100n > (((60n) - 0) + 80n) ? 100n : (((60n) - 0) + 80n)) * ((120n) / (ceil(((120n) - 5p) / (10u))))) : 0)) / 1 / (((120n) / (ceil(((120n) - 5p) / (10u)))) * (ceil(((120n) - 5p) / (10u))) * ((120n) / (ceil(((120n) - 5p) / (10u)))) * (ceil(((120n) - 5p) / (10u))))           nrs=(((120n) / (ceil(((120n) - 5p) / (10u)))) < 119.5n) ? ((((50n > (((60n) - 0) + 60n) ? 50n : (((60n) - 0) + 60n)) * 120n) + (((120n) / (ceil(((120n) - 5p) / (10u)))) * 50n)) + (floor(((ceil(((120n) - 5p) / (10u))) - 1) / 2.0) * (((((60n) - 0) + 60n) * 120n) + (((120n) / (ceil(((120n) - 5p) / (10u)))) * 100n))) + ((((ceil(((120n) - 5p) / (10u))) / 2) - floor((ceil(((120n) - 5p) / (10u))) / 2) == 0) ? (((50n > (((60n) - 0) + 60n) ? 50n : (((60n) - 0) + 60n)) * 120n) + (((120n) / (ceil(((120n) - 5p) / (10u)))) * 50n)) : 0)) / 1 : (((100n > (((60n) - 0) + 80n) ? 100n : (((60n) - 0) + 80n)) * ((120n) / (ceil(((120n) - 5p) / (10u))))) + (floor(((ceil(((120n) - 5p) / (10u))) - 1) / 2.0) * ((60n > (((60n) - 0) + 50n) ? 60n : (((60n) - 0) + 50n)) * ((120n) / (ceil(((120n) - 5p) / (10u)))))) + ((((ceil(((120n) - 5p) / (10u))) / 2) - floor((ceil(((120n) - 5p) / (10u))) / 2) == 0) ? ((100n > (((60n) - 0) + 80n) ? 100n : (((60n) - 0) + 80n)) * ((120n) / (ceil(((120n) - 5p) / (10u))))) : 0)) / 1 / (((120n) / (ceil(((120n) - 5p) / (10u)))) * (ceil(((120n) - 5p) / (10u))) * ((120n) / (ceil(((120n) - 5p) / (10u)))) * (ceil(((120n) - 5p) / (10u))))           sa=(((120n) / (ceil(((120n) - 5p) / (10u)))) < 119.5n) ? (50n > (((60n) - 0) + 60n) ? 50n : (((60n) - 0) + 60n)) + 5e-08 : (100n > (((60n) - 0) + 80n) ? 100n : (((60n) - 0) + 80n))           sb=(((120n) / (ceil(((120n) - 5p) / (10u)))) < 119.5n) ? (50n > (((60n) - 0) + 60n) ? 50n : (((60n) - 0) + 60n)) + 5e-08 : (100n > (((60n) - 0) + 80n) ? 100n : (((60n) - 0) + 80n))           sd=(((120n) / (ceil(((120n) - 5p) / (10u)))) < 119.5n) ? (((60n) - 0) + 60n) + (2*5e-08) : (60n > (((60n) - 0) + 50n) ? 60n : (((60n) - 0) + 50n))           sca=(( ((120n) / (ceil(((120n) - 5p) / (10u)))) * ( (((1u) * (1u) / ((((120n) / (ceil(((120n) - 5p) / (10u)))) < 119.5n) ? (50n > (((60n) - 0) + 60n) ? 50n : (((60n) - 0) + 60n)) + 5e-08 : (100n > (((60n) - 0) + 80n) ? 100n : (((60n) - 0) + 80n))+60n)) - ((1u) * (1u) / (((((120n) / (ceil(((120n) - 5p) / (10u)))) < 119.5n) ? (50n > (((60n) - 0) + 60n) ? 50n : (((60n) - 0) + 60n)) + 5e-08 : (100n > (((60n) - 0) + 80n) ? 100n : (((60n) - 0) + 80n))+60n)+(45n)))) + ((1u) * (1u) / ((((120n) / (ceil(((120n) - 5p) / (10u)))) < 119.5n) ? (50n > (((60n) - 0) + 60n) ? 50n : (((60n) - 0) + 60n)) + 5e-08 : (100n > (((60n) - 0) + 80n) ? 100n : (((60n) - 0) + 80n))+60n)) - ((1u) * (1u)/ (((((120n) / (ceil(((120n) - 5p) / (10u)))) < 119.5n) ? (50n > (((60n) - 0) + 60n) ? 50n : (((60n) - 0) + 60n)) + 5e-08 : (100n > (((60n) - 0) + 80n) ? 100n : (((60n) - 0) + 80n))+60n)+(45n))))) + ( (45n) * ( (((1u) * (1u) / (60n)) - ((1u) * (1u) / ((60n)+((120n) / (ceil(((120n) - 5p) / (10u))))))) + ((1u) * (1u) / (60n)) - ((1u) * (1u)/ ((60n)+((120n) / (ceil(((120n) - 5p) / (10u))))))))) / (((120n) / (ceil(((120n) - 5p) / (10u)))) * (45n))           scb=((((120n) / (ceil(((120n) - 5p) / (10u)))) * ((((((120n) / (ceil(((120n) - 5p) / (10u)))) < 119.5n) ? (50n > (((60n) - 0) + 60n) ? 50n : (((60n) - 0) + 60n)) + 5e-08 : (100n > (((60n) - 0) + 80n) ? 100n : (((60n) - 0) + 80n))+60n)/10 + (1u)/100)*exp(-10 * ((((120n) / (ceil(((120n) - 5p) / (10u)))) < 119.5n) ? (50n > (((60n) - 0) + 60n) ? 50n : (((60n) - 0) + 60n)) + 5e-08 : (100n > (((60n) - 0) + 80n) ? 100n : (((60n) - 0) + 80n))+60n) / (1u)) - ((((((120n) / (ceil(((120n) - 5p) / (10u)))) < 119.5n) ? (50n > (((60n) - 0) + 60n) ? 50n : (((60n) - 0) + 60n)) + 5e-08 : (100n > (((60n) - 0) + 80n) ? 100n : (((60n) - 0) + 80n))+60n)+(45n))/10 + (1u)/100)*exp(-10 * (((((120n) / (ceil(((120n) - 5p) / (10u)))) < 119.5n) ? (50n > (((60n) - 0) + 60n) ? 50n : (((60n) - 0) + 60n)) + 5e-08 : (100n > (((60n) - 0) + 80n) ? 100n : (((60n) - 0) + 80n))+60n)+(45n)) / (1u)) + (((((120n) / (ceil(((120n) - 5p) / (10u)))) < 119.5n) ? (50n > (((60n) - 0) + 60n) ? 50n : (((60n) - 0) + 60n)) + 5e-08 : (100n > (((60n) - 0) + 80n) ? 100n : (((60n) - 0) + 80n))+60n)/10 + (1u)/100)*exp(-10 * ((((120n) / (ceil(((120n) - 5p) / (10u)))) < 119.5n) ? (50n > (((60n) - 0) + 60n) ? 50n : (((60n) - 0) + 60n)) + 5e-08 : (100n > (((60n) - 0) + 80n) ? 100n : (((60n) - 0) + 80n))+60n) / (1u)) - ((((((120n) / (ceil(((120n) - 5p) / (10u)))) < 119.5n) ? (50n > (((60n) - 0) + 60n) ? 50n : (((60n) - 0) + 60n)) + 5e-08 : (100n > (((60n) - 0) + 80n) ? 100n : (((60n) - 0) + 80n))+60n)+(45n))/10 + (1u)/100)*exp(-10 * (((((120n) / (ceil(((120n) - 5p) / (10u)))) < 119.5n) ? (50n > (((60n) - 0) + 60n) ? 50n : (((60n) - 0) + 60n)) + 5e-08 : (100n > (((60n) - 0) + 80n) ? 100n : (((60n) - 0) + 80n))+60n)+(45n)) / (1u)))) + ((45n) * (((60n)/10 + (1u)/100)*exp(-10 * (60n) / (1u)) - (((60n)+((120n) / (ceil(((120n) - 5p) / (10u)))))/10 + (1u)/100)*exp(-10 * ((60n)+((120n) / (ceil(((120n) - 5p) / (10u))))) / (1u)) + ((60n)/10 + (1u)/100)*exp(-10 * (60n) / (1u)) - (((60n)+((120n) / (ceil(((120n) - 5p) / (10u)))))/10 + (1u)/100)*exp(-10 * ((60n)+((120n) / (ceil(((120n) - 5p) / (10u))))) / (1u))))) / (((120n) / (ceil(((120n) - 5p) / (10u)))) * (45n))           scc=((((120n) / (ceil(((120n) - 5p) / (10u)))) * ((((((120n) / (ceil(((120n) - 5p) / (10u)))) < 119.5n) ? (50n > (((60n) - 0) + 60n) ? 50n : (((60n) - 0) + 60n)) + 5e-08 : (100n > (((60n) - 0) + 80n) ? 100n : (((60n) - 0) + 80n))+60n)/20 + (1u)/400)*exp(-20 * ((((120n) / (ceil(((120n) - 5p) / (10u)))) < 119.5n) ? (50n > (((60n) - 0) + 60n) ? 50n : (((60n) - 0) + 60n)) + 5e-08 : (100n > (((60n) - 0) + 80n) ? 100n : (((60n) - 0) + 80n))+60n) / (1u)) - ((((((120n) / (ceil(((120n) - 5p) / (10u)))) < 119.5n) ? (50n > (((60n) - 0) + 60n) ? 50n : (((60n) - 0) + 60n)) + 5e-08 : (100n > (((60n) - 0) + 80n) ? 100n : (((60n) - 0) + 80n))+60n)+(45n))/20 + (1u)/400)*exp(-20 * (((((120n) / (ceil(((120n) - 5p) / (10u)))) < 119.5n) ? (50n > (((60n) - 0) + 60n) ? 50n : (((60n) - 0) + 60n)) + 5e-08 : (100n > (((60n) - 0) + 80n) ? 100n : (((60n) - 0) + 80n))+60n)+(45n)) / (1u)) + (((((120n) / (ceil(((120n) - 5p) / (10u)))) < 119.5n) ? (50n > (((60n) - 0) + 60n) ? 50n : (((60n) - 0) + 60n)) + 5e-08 : (100n > (((60n) - 0) + 80n) ? 100n : (((60n) - 0) + 80n))+60n)/20 + (1u)/400)*exp(-20 * ((((120n) / (ceil(((120n) - 5p) / (10u)))) < 119.5n) ? (50n > (((60n) - 0) + 60n) ? 50n : (((60n) - 0) + 60n)) + 5e-08 : (100n > (((60n) - 0) + 80n) ? 100n : (((60n) - 0) + 80n))+60n) / (1u)) - ((((((120n) / (ceil(((120n) - 5p) / (10u)))) < 119.5n) ? (50n > (((60n) - 0) + 60n) ? 50n : (((60n) - 0) + 60n)) + 5e-08 : (100n > (((60n) - 0) + 80n) ? 100n : (((60n) - 0) + 80n))+60n)+(45n))/20 + (1u)/400)*exp(-20 * (((((120n) / (ceil(((120n) - 5p) / (10u)))) < 119.5n) ? (50n > (((60n) - 0) + 60n) ? 50n : (((60n) - 0) + 60n)) + 5e-08 : (100n > (((60n) - 0) + 80n) ? 100n : (((60n) - 0) + 80n))+60n)+(45n)) / (1u)))) + ((45n) * (((60n)/20 + (1u)/400)*exp(-20 * (60n) / (1u)) - (((60n)+((120n) / (ceil(((120n) - 5p) / (10u)))))/20 + (1u)/400)*exp(-20 * ((60n)+((120n) / (ceil(((120n) - 5p) / (10u))))) / (1u)) + ((60n)/20 + (1u)/400)*exp(-20 * (60n) / (1u)) - (((60n)+((120n) / (ceil(((120n) - 5p) / (10u)))))/20 + (1u)/400)*exp(-20 * ((60n)+((120n) / (ceil(((120n) - 5p) / (10u))))) / (1u))))) / (((120n) / (ceil(((120n) - 5p) / (10u)))) * (45n))           m=(1)
NM0 (Q_bar Q GND GND) g45n1svt w=(360n) l=45n nf=ceil(((360n) - 5p) / (10u))           as=(((360n) / (ceil(((360n) - 5p) / (10u)))) < 119.5n) ? ((((50n > (((60n) - 0) + 60n) ? 50n : (((60n) - 0) + 60n)) * 120n) + (((360n) / (ceil(((360n) - 5p) / (10u)))) * 50n)) + (floor(((ceil(((360n) - 5p) / (10u))) - 1) / 2.0) * (((((60n) - 0) + 60n) * 120n) + (((360n) / (ceil(((360n) - 5p) / (10u)))) * 100n))) + ((((ceil(((360n) - 5p) / (10u))) / 2) - floor((ceil(((360n) - 5p) / (10u))) / 2) == 0) ? (((50n > (((60n) - 0) + 60n) ? 50n : (((60n) - 0) + 60n)) * 120n) + (((360n) / (ceil(((360n) - 5p) / (10u)))) * 50n)) : 0)) / 1 : (((100n > (((60n) - 0) + 80n) ? 100n : (((60n) - 0) + 80n)) * ((360n) / (ceil(((360n) - 5p) / (10u))))) + (floor(((ceil(((360n) - 5p) / (10u))) - 1) / 2.0) * ((60n > (((60n) - 0) + 50n) ? 60n : (((60n) - 0) + 50n)) * ((360n) / (ceil(((360n) - 5p) / (10u)))))) + ((((ceil(((360n) - 5p) / (10u))) / 2) - floor((ceil(((360n) - 5p) / (10u))) / 2) == 0) ? ((100n > (((60n) - 0) + 80n) ? 100n : (((60n) - 0) + 80n)) * ((360n) / (ceil(((360n) - 5p) / (10u))))) : 0)) / 1           ad=(((360n) / (ceil(((360n) - 5p) / (10u)))) < 119.5n) ? ((floor((ceil(((360n) - 5p) / (10u))) / 2.0) * (((((60n) - 0) + 60n) * 120n) + (((360n) / (ceil(((360n) - 5p) / (10u)))) * 100n))) + ((((ceil(((360n) - 5p) / (10u))) / 2) - floor((ceil(((360n) - 5p) / (10u))) / 2) != 0) ? (((50n > (((60n) - 0) + 60n) ? 50n : (((60n) - 0) + 60n)) * 120n) + (((360n) / (ceil(((360n) - 5p) / (10u)))) * 50n)) : 0)) / 1 : ((floor((ceil(((360n) - 5p) / (10u))) / 2.0) * ((60n > (((60n) - 0) + 50n) ? 60n : (((60n) - 0) + 50n)) * ((360n) / (ceil(((360n) - 5p) / (10u)))))) + ((((ceil(((360n) - 5p) / (10u))) / 2) - floor((ceil(((360n) - 5p) / (10u))) / 2) != 0) ? ((100n > (((60n) - 0) + 80n) ? 100n : (((60n) - 0) + 80n)) * ((360n) / (ceil(((360n) - 5p) / (10u))))) : 0)) / 1           ps=(((360n) / (ceil(((360n) - 5p) / (10u)))) < 119.5n) ? (((2 * (50n > (((60n) - 0) + 60n) ? 50n : (((60n) - 0) + 60n))) + 340n) + (floor(((ceil(((360n) - 5p) / (10u))) - 1) / 2.0) * ((2 * (((60n) - 0) + 60n)) + 440n)) + ((((ceil(((360n) - 5p) / (10u))) / 2) - floor((ceil(((360n) - 5p) / (10u))) / 2) == 0) ? ((2 * (50n > (((60n) - 0) + 60n) ? 50n : (((60n) - 0) + 60n))) + 340n) : 0)) / 1 : (((2 * (100n > (((60n) - 0) + 80n) ? 100n : (((60n) - 0) + 80n))) + (2 * ((360n) / (ceil(((360n) - 5p) / (10u)))))) + (floor(((ceil(((360n) - 5p) / (10u))) - 1) / 2.0) * ((2 * (60n > (((60n) - 0) + 50n) ? 60n : (((60n) - 0) + 50n))) + (2 * ((360n) / (ceil(((360n) - 5p) / (10u))))))) + ((((ceil(((360n) - 5p) / (10u))) / 2) - floor((ceil(((360n) - 5p) / (10u))) / 2) == 0) ? ((2 * (100n > (((60n) - 0) + 80n) ? 100n : (((60n) - 0) + 80n))) + (2 * ((360n) / (ceil(((360n) - 5p) / (10u)))))) : 0)) / 1           pd=(((360n) / (ceil(((360n) - 5p) / (10u)))) < 119.5n) ? ((floor((ceil(((360n) - 5p) / (10u))) / 2.0) * ((2 * (((60n) - 0) + 60n)) + 440n)) + ((((ceil(((360n) - 5p) / (10u))) / 2) - floor((ceil(((360n) - 5p) / (10u))) / 2) != 0) ? ((2 * (50n > (((60n) - 0) + 60n) ? 50n : (((60n) - 0) + 60n))) + 340n) : 0)) / 1 : ((floor((ceil(((360n) - 5p) / (10u))) / 2.0) * ((2 * (60n > (((60n) - 0) + 50n) ? 60n : (((60n) - 0) + 50n))) + (2 * ((360n) / (ceil(((360n) - 5p) / (10u))))))) + ((((ceil(((360n) - 5p) / (10u))) / 2) - floor((ceil(((360n) - 5p) / (10u))) / 2) != 0) ? ((2 * (100n > (((60n) - 0) + 80n) ? 100n : (((60n) - 0) + 80n))) + (2 * ((360n) / (ceil(((360n) - 5p) / (10u)))))) : 0)) / 1           nrd=(((360n) / (ceil(((360n) - 5p) / (10u)))) < 119.5n) ? ((floor((ceil(((360n) - 5p) / (10u))) / 2.0) * (((((60n) - 0) + 60n) * 120n) + (((360n) / (ceil(((360n) - 5p) / (10u)))) * 100n))) + ((((ceil(((360n) - 5p) / (10u))) / 2) - floor((ceil(((360n) - 5p) / (10u))) / 2) != 0) ? (((50n > (((60n) - 0) + 60n) ? 50n : (((60n) - 0) + 60n)) * 120n) + (((360n) / (ceil(((360n) - 5p) / (10u)))) * 50n)) : 0)) / 1 : ((floor((ceil(((360n) - 5p) / (10u))) / 2.0) * ((60n > (((60n) - 0) + 50n) ? 60n : (((60n) - 0) + 50n)) * ((360n) / (ceil(((360n) - 5p) / (10u)))))) + ((((ceil(((360n) - 5p) / (10u))) / 2) - floor((ceil(((360n) - 5p) / (10u))) / 2) != 0) ? ((100n > (((60n) - 0) + 80n) ? 100n : (((60n) - 0) + 80n)) * ((360n) / (ceil(((360n) - 5p) / (10u))))) : 0)) / 1 / (((360n) / (ceil(((360n) - 5p) / (10u)))) * (ceil(((360n) - 5p) / (10u))) * ((360n) / (ceil(((360n) - 5p) / (10u)))) * (ceil(((360n) - 5p) / (10u))))           nrs=(((360n) / (ceil(((360n) - 5p) / (10u)))) < 119.5n) ? ((((50n > (((60n) - 0) + 60n) ? 50n : (((60n) - 0) + 60n)) * 120n) + (((360n) / (ceil(((360n) - 5p) / (10u)))) * 50n)) + (floor(((ceil(((360n) - 5p) / (10u))) - 1) / 2.0) * (((((60n) - 0) + 60n) * 120n) + (((360n) / (ceil(((360n) - 5p) / (10u)))) * 100n))) + ((((ceil(((360n) - 5p) / (10u))) / 2) - floor((ceil(((360n) - 5p) / (10u))) / 2) == 0) ? (((50n > (((60n) - 0) + 60n) ? 50n : (((60n) - 0) + 60n)) * 120n) + (((360n) / (ceil(((360n) - 5p) / (10u)))) * 50n)) : 0)) / 1 : (((100n > (((60n) - 0) + 80n) ? 100n : (((60n) - 0) + 80n)) * ((360n) / (ceil(((360n) - 5p) / (10u))))) + (floor(((ceil(((360n) - 5p) / (10u))) - 1) / 2.0) * ((60n > (((60n) - 0) + 50n) ? 60n : (((60n) - 0) + 50n)) * ((360n) / (ceil(((360n) - 5p) / (10u)))))) + ((((ceil(((360n) - 5p) / (10u))) / 2) - floor((ceil(((360n) - 5p) / (10u))) / 2) == 0) ? ((100n > (((60n) - 0) + 80n) ? 100n : (((60n) - 0) + 80n)) * ((360n) / (ceil(((360n) - 5p) / (10u))))) : 0)) / 1 / (((360n) / (ceil(((360n) - 5p) / (10u)))) * (ceil(((360n) - 5p) / (10u))) * ((360n) / (ceil(((360n) - 5p) / (10u)))) * (ceil(((360n) - 5p) / (10u))))           sa=(((360n) / (ceil(((360n) - 5p) / (10u)))) < 119.5n) ? (50n > (((60n) - 0) + 60n) ? 50n : (((60n) - 0) + 60n)) + 5e-08 : (100n > (((60n) - 0) + 80n) ? 100n : (((60n) - 0) + 80n))           sb=(((360n) / (ceil(((360n) - 5p) / (10u)))) < 119.5n) ? (50n > (((60n) - 0) + 60n) ? 50n : (((60n) - 0) + 60n)) + 5e-08 : (100n > (((60n) - 0) + 80n) ? 100n : (((60n) - 0) + 80n))           sd=(((360n) / (ceil(((360n) - 5p) / (10u)))) < 119.5n) ? (((60n) - 0) + 60n) + (2*5e-08) : (60n > (((60n) - 0) + 50n) ? 60n : (((60n) - 0) + 50n))           sca=(( ((360n) / (ceil(((360n) - 5p) / (10u)))) * ( (((1u) * (1u) / ((((360n) / (ceil(((360n) - 5p) / (10u)))) < 119.5n) ? (50n > (((60n) - 0) + 60n) ? 50n : (((60n) - 0) + 60n)) + 5e-08 : (100n > (((60n) - 0) + 80n) ? 100n : (((60n) - 0) + 80n))+60n)) - ((1u) * (1u) / (((((360n) / (ceil(((360n) - 5p) / (10u)))) < 119.5n) ? (50n > (((60n) - 0) + 60n) ? 50n : (((60n) - 0) + 60n)) + 5e-08 : (100n > (((60n) - 0) + 80n) ? 100n : (((60n) - 0) + 80n))+60n)+(45n)))) + ((1u) * (1u) / ((((360n) / (ceil(((360n) - 5p) / (10u)))) < 119.5n) ? (50n > (((60n) - 0) + 60n) ? 50n : (((60n) - 0) + 60n)) + 5e-08 : (100n > (((60n) - 0) + 80n) ? 100n : (((60n) - 0) + 80n))+60n)) - ((1u) * (1u)/ (((((360n) / (ceil(((360n) - 5p) / (10u)))) < 119.5n) ? (50n > (((60n) - 0) + 60n) ? 50n : (((60n) - 0) + 60n)) + 5e-08 : (100n > (((60n) - 0) + 80n) ? 100n : (((60n) - 0) + 80n))+60n)+(45n))))) + ( (45n) * ( (((1u) * (1u) / (60n)) - ((1u) * (1u) / ((60n)+((360n) / (ceil(((360n) - 5p) / (10u))))))) + ((1u) * (1u) / (60n)) - ((1u) * (1u)/ ((60n)+((360n) / (ceil(((360n) - 5p) / (10u))))))))) / (((360n) / (ceil(((360n) - 5p) / (10u)))) * (45n))           scb=((((360n) / (ceil(((360n) - 5p) / (10u)))) * ((((((360n) / (ceil(((360n) - 5p) / (10u)))) < 119.5n) ? (50n > (((60n) - 0) + 60n) ? 50n : (((60n) - 0) + 60n)) + 5e-08 : (100n > (((60n) - 0) + 80n) ? 100n : (((60n) - 0) + 80n))+60n)/10 + (1u)/100)*exp(-10 * ((((360n) / (ceil(((360n) - 5p) / (10u)))) < 119.5n) ? (50n > (((60n) - 0) + 60n) ? 50n : (((60n) - 0) + 60n)) + 5e-08 : (100n > (((60n) - 0) + 80n) ? 100n : (((60n) - 0) + 80n))+60n) / (1u)) - ((((((360n) / (ceil(((360n) - 5p) / (10u)))) < 119.5n) ? (50n > (((60n) - 0) + 60n) ? 50n : (((60n) - 0) + 60n)) + 5e-08 : (100n > (((60n) - 0) + 80n) ? 100n : (((60n) - 0) + 80n))+60n)+(45n))/10 + (1u)/100)*exp(-10 * (((((360n) / (ceil(((360n) - 5p) / (10u)))) < 119.5n) ? (50n > (((60n) - 0) + 60n) ? 50n : (((60n) - 0) + 60n)) + 5e-08 : (100n > (((60n) - 0) + 80n) ? 100n : (((60n) - 0) + 80n))+60n)+(45n)) / (1u)) + (((((360n) / (ceil(((360n) - 5p) / (10u)))) < 119.5n) ? (50n > (((60n) - 0) + 60n) ? 50n : (((60n) - 0) + 60n)) + 5e-08 : (100n > (((60n) - 0) + 80n) ? 100n : (((60n) - 0) + 80n))+60n)/10 + (1u)/100)*exp(-10 * ((((360n) / (ceil(((360n) - 5p) / (10u)))) < 119.5n) ? (50n > (((60n) - 0) + 60n) ? 50n : (((60n) - 0) + 60n)) + 5e-08 : (100n > (((60n) - 0) + 80n) ? 100n : (((60n) - 0) + 80n))+60n) / (1u)) - ((((((360n) / (ceil(((360n) - 5p) / (10u)))) < 119.5n) ? (50n > (((60n) - 0) + 60n) ? 50n : (((60n) - 0) + 60n)) + 5e-08 : (100n > (((60n) - 0) + 80n) ? 100n : (((60n) - 0) + 80n))+60n)+(45n))/10 + (1u)/100)*exp(-10 * (((((360n) / (ceil(((360n) - 5p) / (10u)))) < 119.5n) ? (50n > (((60n) - 0) + 60n) ? 50n : (((60n) - 0) + 60n)) + 5e-08 : (100n > (((60n) - 0) + 80n) ? 100n : (((60n) - 0) + 80n))+60n)+(45n)) / (1u)))) + ((45n) * (((60n)/10 + (1u)/100)*exp(-10 * (60n) / (1u)) - (((60n)+((360n) / (ceil(((360n) - 5p) / (10u)))))/10 + (1u)/100)*exp(-10 * ((60n)+((360n) / (ceil(((360n) - 5p) / (10u))))) / (1u)) + ((60n)/10 + (1u)/100)*exp(-10 * (60n) / (1u)) - (((60n)+((360n) / (ceil(((360n) - 5p) / (10u)))))/10 + (1u)/100)*exp(-10 * ((60n)+((360n) / (ceil(((360n) - 5p) / (10u))))) / (1u))))) / (((360n) / (ceil(((360n) - 5p) / (10u)))) * (45n))           scc=((((360n) / (ceil(((360n) - 5p) / (10u)))) * ((((((360n) / (ceil(((360n) - 5p) / (10u)))) < 119.5n) ? (50n > (((60n) - 0) + 60n) ? 50n : (((60n) - 0) + 60n)) + 5e-08 : (100n > (((60n) - 0) + 80n) ? 100n : (((60n) - 0) + 80n))+60n)/20 + (1u)/400)*exp(-20 * ((((360n) / (ceil(((360n) - 5p) / (10u)))) < 119.5n) ? (50n > (((60n) - 0) + 60n) ? 50n : (((60n) - 0) + 60n)) + 5e-08 : (100n > (((60n) - 0) + 80n) ? 100n : (((60n) - 0) + 80n))+60n) / (1u)) - ((((((360n) / (ceil(((360n) - 5p) / (10u)))) < 119.5n) ? (50n > (((60n) - 0) + 60n) ? 50n : (((60n) - 0) + 60n)) + 5e-08 : (100n > (((60n) - 0) + 80n) ? 100n : (((60n) - 0) + 80n))+60n)+(45n))/20 + (1u)/400)*exp(-20 * (((((360n) / (ceil(((360n) - 5p) / (10u)))) < 119.5n) ? (50n > (((60n) - 0) + 60n) ? 50n : (((60n) - 0) + 60n)) + 5e-08 : (100n > (((60n) - 0) + 80n) ? 100n : (((60n) - 0) + 80n))+60n)+(45n)) / (1u)) + (((((360n) / (ceil(((360n) - 5p) / (10u)))) < 119.5n) ? (50n > (((60n) - 0) + 60n) ? 50n : (((60n) - 0) + 60n)) + 5e-08 : (100n > (((60n) - 0) + 80n) ? 100n : (((60n) - 0) + 80n))+60n)/20 + (1u)/400)*exp(-20 * ((((360n) / (ceil(((360n) - 5p) / (10u)))) < 119.5n) ? (50n > (((60n) - 0) + 60n) ? 50n : (((60n) - 0) + 60n)) + 5e-08 : (100n > (((60n) - 0) + 80n) ? 100n : (((60n) - 0) + 80n))+60n) / (1u)) - ((((((360n) / (ceil(((360n) - 5p) / (10u)))) < 119.5n) ? (50n > (((60n) - 0) + 60n) ? 50n : (((60n) - 0) + 60n)) + 5e-08 : (100n > (((60n) - 0) + 80n) ? 100n : (((60n) - 0) + 80n))+60n)+(45n))/20 + (1u)/400)*exp(-20 * (((((360n) / (ceil(((360n) - 5p) / (10u)))) < 119.5n) ? (50n > (((60n) - 0) + 60n) ? 50n : (((60n) - 0) + 60n)) + 5e-08 : (100n > (((60n) - 0) + 80n) ? 100n : (((60n) - 0) + 80n))+60n)+(45n)) / (1u)))) + ((45n) * (((60n)/20 + (1u)/400)*exp(-20 * (60n) / (1u)) - (((60n)+((360n) / (ceil(((360n) - 5p) / (10u)))))/20 + (1u)/400)*exp(-20 * ((60n)+((360n) / (ceil(((360n) - 5p) / (10u))))) / (1u)) + ((60n)/20 + (1u)/400)*exp(-20 * (60n) / (1u)) - (((60n)+((360n) / (ceil(((360n) - 5p) / (10u)))))/20 + (1u)/400)*exp(-20 * ((60n)+((360n) / (ceil(((360n) - 5p) / (10u))))) / (1u))))) / (((360n) / (ceil(((360n) - 5p) / (10u)))) * (45n))           m=(1)
NM1 (Q Q_bar GND GND) g45n1svt w=(360n) l=45n nf=ceil(((360n) - 5p) / (10u))           as=(((360n) / (ceil(((360n) - 5p) / (10u)))) < 119.5n) ? ((((50n > (((60n) - 0) + 60n) ? 50n : (((60n) - 0) + 60n)) * 120n) + (((360n) / (ceil(((360n) - 5p) / (10u)))) * 50n)) + (floor(((ceil(((360n) - 5p) / (10u))) - 1) / 2.0) * (((((60n) - 0) + 60n) * 120n) + (((360n) / (ceil(((360n) - 5p) / (10u)))) * 100n))) + ((((ceil(((360n) - 5p) / (10u))) / 2) - floor((ceil(((360n) - 5p) / (10u))) / 2) == 0) ? (((50n > (((60n) - 0) + 60n) ? 50n : (((60n) - 0) + 60n)) * 120n) + (((360n) / (ceil(((360n) - 5p) / (10u)))) * 50n)) : 0)) / 1 : (((100n > (((60n) - 0) + 80n) ? 100n : (((60n) - 0) + 80n)) * ((360n) / (ceil(((360n) - 5p) / (10u))))) + (floor(((ceil(((360n) - 5p) / (10u))) - 1) / 2.0) * ((60n > (((60n) - 0) + 50n) ? 60n : (((60n) - 0) + 50n)) * ((360n) / (ceil(((360n) - 5p) / (10u)))))) + ((((ceil(((360n) - 5p) / (10u))) / 2) - floor((ceil(((360n) - 5p) / (10u))) / 2) == 0) ? ((100n > (((60n) - 0) + 80n) ? 100n : (((60n) - 0) + 80n)) * ((360n) / (ceil(((360n) - 5p) / (10u))))) : 0)) / 1           ad=(((360n) / (ceil(((360n) - 5p) / (10u)))) < 119.5n) ? ((floor((ceil(((360n) - 5p) / (10u))) / 2.0) * (((((60n) - 0) + 60n) * 120n) + (((360n) / (ceil(((360n) - 5p) / (10u)))) * 100n))) + ((((ceil(((360n) - 5p) / (10u))) / 2) - floor((ceil(((360n) - 5p) / (10u))) / 2) != 0) ? (((50n > (((60n) - 0) + 60n) ? 50n : (((60n) - 0) + 60n)) * 120n) + (((360n) / (ceil(((360n) - 5p) / (10u)))) * 50n)) : 0)) / 1 : ((floor((ceil(((360n) - 5p) / (10u))) / 2.0) * ((60n > (((60n) - 0) + 50n) ? 60n : (((60n) - 0) + 50n)) * ((360n) / (ceil(((360n) - 5p) / (10u)))))) + ((((ceil(((360n) - 5p) / (10u))) / 2) - floor((ceil(((360n) - 5p) / (10u))) / 2) != 0) ? ((100n > (((60n) - 0) + 80n) ? 100n : (((60n) - 0) + 80n)) * ((360n) / (ceil(((360n) - 5p) / (10u))))) : 0)) / 1           ps=(((360n) / (ceil(((360n) - 5p) / (10u)))) < 119.5n) ? (((2 * (50n > (((60n) - 0) + 60n) ? 50n : (((60n) - 0) + 60n))) + 340n) + (floor(((ceil(((360n) - 5p) / (10u))) - 1) / 2.0) * ((2 * (((60n) - 0) + 60n)) + 440n)) + ((((ceil(((360n) - 5p) / (10u))) / 2) - floor((ceil(((360n) - 5p) / (10u))) / 2) == 0) ? ((2 * (50n > (((60n) - 0) + 60n) ? 50n : (((60n) - 0) + 60n))) + 340n) : 0)) / 1 : (((2 * (100n > (((60n) - 0) + 80n) ? 100n : (((60n) - 0) + 80n))) + (2 * ((360n) / (ceil(((360n) - 5p) / (10u)))))) + (floor(((ceil(((360n) - 5p) / (10u))) - 1) / 2.0) * ((2 * (60n > (((60n) - 0) + 50n) ? 60n : (((60n) - 0) + 50n))) + (2 * ((360n) / (ceil(((360n) - 5p) / (10u))))))) + ((((ceil(((360n) - 5p) / (10u))) / 2) - floor((ceil(((360n) - 5p) / (10u))) / 2) == 0) ? ((2 * (100n > (((60n) - 0) + 80n) ? 100n : (((60n) - 0) + 80n))) + (2 * ((360n) / (ceil(((360n) - 5p) / (10u)))))) : 0)) / 1           pd=(((360n) / (ceil(((360n) - 5p) / (10u)))) < 119.5n) ? ((floor((ceil(((360n) - 5p) / (10u))) / 2.0) * ((2 * (((60n) - 0) + 60n)) + 440n)) + ((((ceil(((360n) - 5p) / (10u))) / 2) - floor((ceil(((360n) - 5p) / (10u))) / 2) != 0) ? ((2 * (50n > (((60n) - 0) + 60n) ? 50n : (((60n) - 0) + 60n))) + 340n) : 0)) / 1 : ((floor((ceil(((360n) - 5p) / (10u))) / 2.0) * ((2 * (60n > (((60n) - 0) + 50n) ? 60n : (((60n) - 0) + 50n))) + (2 * ((360n) / (ceil(((360n) - 5p) / (10u))))))) + ((((ceil(((360n) - 5p) / (10u))) / 2) - floor((ceil(((360n) - 5p) / (10u))) / 2) != 0) ? ((2 * (100n > (((60n) - 0) + 80n) ? 100n : (((60n) - 0) + 80n))) + (2 * ((360n) / (ceil(((360n) - 5p) / (10u)))))) : 0)) / 1           nrd=(((360n) / (ceil(((360n) - 5p) / (10u)))) < 119.5n) ? ((floor((ceil(((360n) - 5p) / (10u))) / 2.0) * (((((60n) - 0) + 60n) * 120n) + (((360n) / (ceil(((360n) - 5p) / (10u)))) * 100n))) + ((((ceil(((360n) - 5p) / (10u))) / 2) - floor((ceil(((360n) - 5p) / (10u))) / 2) != 0) ? (((50n > (((60n) - 0) + 60n) ? 50n : (((60n) - 0) + 60n)) * 120n) + (((360n) / (ceil(((360n) - 5p) / (10u)))) * 50n)) : 0)) / 1 : ((floor((ceil(((360n) - 5p) / (10u))) / 2.0) * ((60n > (((60n) - 0) + 50n) ? 60n : (((60n) - 0) + 50n)) * ((360n) / (ceil(((360n) - 5p) / (10u)))))) + ((((ceil(((360n) - 5p) / (10u))) / 2) - floor((ceil(((360n) - 5p) / (10u))) / 2) != 0) ? ((100n > (((60n) - 0) + 80n) ? 100n : (((60n) - 0) + 80n)) * ((360n) / (ceil(((360n) - 5p) / (10u))))) : 0)) / 1 / (((360n) / (ceil(((360n) - 5p) / (10u)))) * (ceil(((360n) - 5p) / (10u))) * ((360n) / (ceil(((360n) - 5p) / (10u)))) * (ceil(((360n) - 5p) / (10u))))           nrs=(((360n) / (ceil(((360n) - 5p) / (10u)))) < 119.5n) ? ((((50n > (((60n) - 0) + 60n) ? 50n : (((60n) - 0) + 60n)) * 120n) + (((360n) / (ceil(((360n) - 5p) / (10u)))) * 50n)) + (floor(((ceil(((360n) - 5p) / (10u))) - 1) / 2.0) * (((((60n) - 0) + 60n) * 120n) + (((360n) / (ceil(((360n) - 5p) / (10u)))) * 100n))) + ((((ceil(((360n) - 5p) / (10u))) / 2) - floor((ceil(((360n) - 5p) / (10u))) / 2) == 0) ? (((50n > (((60n) - 0) + 60n) ? 50n : (((60n) - 0) + 60n)) * 120n) + (((360n) / (ceil(((360n) - 5p) / (10u)))) * 50n)) : 0)) / 1 : (((100n > (((60n) - 0) + 80n) ? 100n : (((60n) - 0) + 80n)) * ((360n) / (ceil(((360n) - 5p) / (10u))))) + (floor(((ceil(((360n) - 5p) / (10u))) - 1) / 2.0) * ((60n > (((60n) - 0) + 50n) ? 60n : (((60n) - 0) + 50n)) * ((360n) / (ceil(((360n) - 5p) / (10u)))))) + ((((ceil(((360n) - 5p) / (10u))) / 2) - floor((ceil(((360n) - 5p) / (10u))) / 2) == 0) ? ((100n > (((60n) - 0) + 80n) ? 100n : (((60n) - 0) + 80n)) * ((360n) / (ceil(((360n) - 5p) / (10u))))) : 0)) / 1 / (((360n) / (ceil(((360n) - 5p) / (10u)))) * (ceil(((360n) - 5p) / (10u))) * ((360n) / (ceil(((360n) - 5p) / (10u)))) * (ceil(((360n) - 5p) / (10u))))           sa=(((360n) / (ceil(((360n) - 5p) / (10u)))) < 119.5n) ? (50n > (((60n) - 0) + 60n) ? 50n : (((60n) - 0) + 60n)) + 5e-08 : (100n > (((60n) - 0) + 80n) ? 100n : (((60n) - 0) + 80n))           sb=(((360n) / (ceil(((360n) - 5p) / (10u)))) < 119.5n) ? (50n > (((60n) - 0) + 60n) ? 50n : (((60n) - 0) + 60n)) + 5e-08 : (100n > (((60n) - 0) + 80n) ? 100n : (((60n) - 0) + 80n))           sd=(((360n) / (ceil(((360n) - 5p) / (10u)))) < 119.5n) ? (((60n) - 0) + 60n) + (2*5e-08) : (60n > (((60n) - 0) + 50n) ? 60n : (((60n) - 0) + 50n))           sca=(( ((360n) / (ceil(((360n) - 5p) / (10u)))) * ( (((1u) * (1u) / ((((360n) / (ceil(((360n) - 5p) / (10u)))) < 119.5n) ? (50n > (((60n) - 0) + 60n) ? 50n : (((60n) - 0) + 60n)) + 5e-08 : (100n > (((60n) - 0) + 80n) ? 100n : (((60n) - 0) + 80n))+60n)) - ((1u) * (1u) / (((((360n) / (ceil(((360n) - 5p) / (10u)))) < 119.5n) ? (50n > (((60n) - 0) + 60n) ? 50n : (((60n) - 0) + 60n)) + 5e-08 : (100n > (((60n) - 0) + 80n) ? 100n : (((60n) - 0) + 80n))+60n)+(45n)))) + ((1u) * (1u) / ((((360n) / (ceil(((360n) - 5p) / (10u)))) < 119.5n) ? (50n > (((60n) - 0) + 60n) ? 50n : (((60n) - 0) + 60n)) + 5e-08 : (100n > (((60n) - 0) + 80n) ? 100n : (((60n) - 0) + 80n))+60n)) - ((1u) * (1u)/ (((((360n) / (ceil(((360n) - 5p) / (10u)))) < 119.5n) ? (50n > (((60n) - 0) + 60n) ? 50n : (((60n) - 0) + 60n)) + 5e-08 : (100n > (((60n) - 0) + 80n) ? 100n : (((60n) - 0) + 80n))+60n)+(45n))))) + ( (45n) * ( (((1u) * (1u) / (60n)) - ((1u) * (1u) / ((60n)+((360n) / (ceil(((360n) - 5p) / (10u))))))) + ((1u) * (1u) / (60n)) - ((1u) * (1u)/ ((60n)+((360n) / (ceil(((360n) - 5p) / (10u))))))))) / (((360n) / (ceil(((360n) - 5p) / (10u)))) * (45n))           scb=((((360n) / (ceil(((360n) - 5p) / (10u)))) * ((((((360n) / (ceil(((360n) - 5p) / (10u)))) < 119.5n) ? (50n > (((60n) - 0) + 60n) ? 50n : (((60n) - 0) + 60n)) + 5e-08 : (100n > (((60n) - 0) + 80n) ? 100n : (((60n) - 0) + 80n))+60n)/10 + (1u)/100)*exp(-10 * ((((360n) / (ceil(((360n) - 5p) / (10u)))) < 119.5n) ? (50n > (((60n) - 0) + 60n) ? 50n : (((60n) - 0) + 60n)) + 5e-08 : (100n > (((60n) - 0) + 80n) ? 100n : (((60n) - 0) + 80n))+60n) / (1u)) - ((((((360n) / (ceil(((360n) - 5p) / (10u)))) < 119.5n) ? (50n > (((60n) - 0) + 60n) ? 50n : (((60n) - 0) + 60n)) + 5e-08 : (100n > (((60n) - 0) + 80n) ? 100n : (((60n) - 0) + 80n))+60n)+(45n))/10 + (1u)/100)*exp(-10 * (((((360n) / (ceil(((360n) - 5p) / (10u)))) < 119.5n) ? (50n > (((60n) - 0) + 60n) ? 50n : (((60n) - 0) + 60n)) + 5e-08 : (100n > (((60n) - 0) + 80n) ? 100n : (((60n) - 0) + 80n))+60n)+(45n)) / (1u)) + (((((360n) / (ceil(((360n) - 5p) / (10u)))) < 119.5n) ? (50n > (((60n) - 0) + 60n) ? 50n : (((60n) - 0) + 60n)) + 5e-08 : (100n > (((60n) - 0) + 80n) ? 100n : (((60n) - 0) + 80n))+60n)/10 + (1u)/100)*exp(-10 * ((((360n) / (ceil(((360n) - 5p) / (10u)))) < 119.5n) ? (50n > (((60n) - 0) + 60n) ? 50n : (((60n) - 0) + 60n)) + 5e-08 : (100n > (((60n) - 0) + 80n) ? 100n : (((60n) - 0) + 80n))+60n) / (1u)) - ((((((360n) / (ceil(((360n) - 5p) / (10u)))) < 119.5n) ? (50n > (((60n) - 0) + 60n) ? 50n : (((60n) - 0) + 60n)) + 5e-08 : (100n > (((60n) - 0) + 80n) ? 100n : (((60n) - 0) + 80n))+60n)+(45n))/10 + (1u)/100)*exp(-10 * (((((360n) / (ceil(((360n) - 5p) / (10u)))) < 119.5n) ? (50n > (((60n) - 0) + 60n) ? 50n : (((60n) - 0) + 60n)) + 5e-08 : (100n > (((60n) - 0) + 80n) ? 100n : (((60n) - 0) + 80n))+60n)+(45n)) / (1u)))) + ((45n) * (((60n)/10 + (1u)/100)*exp(-10 * (60n) / (1u)) - (((60n)+((360n) / (ceil(((360n) - 5p) / (10u)))))/10 + (1u)/100)*exp(-10 * ((60n)+((360n) / (ceil(((360n) - 5p) / (10u))))) / (1u)) + ((60n)/10 + (1u)/100)*exp(-10 * (60n) / (1u)) - (((60n)+((360n) / (ceil(((360n) - 5p) / (10u)))))/10 + (1u)/100)*exp(-10 * ((60n)+((360n) / (ceil(((360n) - 5p) / (10u))))) / (1u))))) / (((360n) / (ceil(((360n) - 5p) / (10u)))) * (45n))           scc=((((360n) / (ceil(((360n) - 5p) / (10u)))) * ((((((360n) / (ceil(((360n) - 5p) / (10u)))) < 119.5n) ? (50n > (((60n) - 0) + 60n) ? 50n : (((60n) - 0) + 60n)) + 5e-08 : (100n > (((60n) - 0) + 80n) ? 100n : (((60n) - 0) + 80n))+60n)/20 + (1u)/400)*exp(-20 * ((((360n) / (ceil(((360n) - 5p) / (10u)))) < 119.5n) ? (50n > (((60n) - 0) + 60n) ? 50n : (((60n) - 0) + 60n)) + 5e-08 : (100n > (((60n) - 0) + 80n) ? 100n : (((60n) - 0) + 80n))+60n) / (1u)) - ((((((360n) / (ceil(((360n) - 5p) / (10u)))) < 119.5n) ? (50n > (((60n) - 0) + 60n) ? 50n : (((60n) - 0) + 60n)) + 5e-08 : (100n > (((60n) - 0) + 80n) ? 100n : (((60n) - 0) + 80n))+60n)+(45n))/20 + (1u)/400)*exp(-20 * (((((360n) / (ceil(((360n) - 5p) / (10u)))) < 119.5n) ? (50n > (((60n) - 0) + 60n) ? 50n : (((60n) - 0) + 60n)) + 5e-08 : (100n > (((60n) - 0) + 80n) ? 100n : (((60n) - 0) + 80n))+60n)+(45n)) / (1u)) + (((((360n) / (ceil(((360n) - 5p) / (10u)))) < 119.5n) ? (50n > (((60n) - 0) + 60n) ? 50n : (((60n) - 0) + 60n)) + 5e-08 : (100n > (((60n) - 0) + 80n) ? 100n : (((60n) - 0) + 80n))+60n)/20 + (1u)/400)*exp(-20 * ((((360n) / (ceil(((360n) - 5p) / (10u)))) < 119.5n) ? (50n > (((60n) - 0) + 60n) ? 50n : (((60n) - 0) + 60n)) + 5e-08 : (100n > (((60n) - 0) + 80n) ? 100n : (((60n) - 0) + 80n))+60n) / (1u)) - ((((((360n) / (ceil(((360n) - 5p) / (10u)))) < 119.5n) ? (50n > (((60n) - 0) + 60n) ? 50n : (((60n) - 0) + 60n)) + 5e-08 : (100n > (((60n) - 0) + 80n) ? 100n : (((60n) - 0) + 80n))+60n)+(45n))/20 + (1u)/400)*exp(-20 * (((((360n) / (ceil(((360n) - 5p) / (10u)))) < 119.5n) ? (50n > (((60n) - 0) + 60n) ? 50n : (((60n) - 0) + 60n)) + 5e-08 : (100n > (((60n) - 0) + 80n) ? 100n : (((60n) - 0) + 80n))+60n)+(45n)) / (1u)))) + ((45n) * (((60n)/20 + (1u)/400)*exp(-20 * (60n) / (1u)) - (((60n)+((360n) / (ceil(((360n) - 5p) / (10u)))))/20 + (1u)/400)*exp(-20 * ((60n)+((360n) / (ceil(((360n) - 5p) / (10u))))) / (1u)) + ((60n)/20 + (1u)/400)*exp(-20 * (60n) / (1u)) - (((60n)+((360n) / (ceil(((360n) - 5p) / (10u)))))/20 + (1u)/400)*exp(-20 * ((60n)+((360n) / (ceil(((360n) - 5p) / (10u))))) / (1u))))) / (((360n) / (ceil(((360n) - 5p) / (10u)))) * (45n))           m=(1)
NM2 (Q_bar WL BL_bar GND) g45n1svt w=(240n) l=45n nf=ceil(((240n) - 5p) / (10u))           as=(((240n) / (ceil(((240n) - 5p) / (10u)))) < 119.5n) ? ((((50n > (((60n) - 0) + 60n) ? 50n : (((60n) - 0) + 60n)) * 120n) + (((240n) / (ceil(((240n) - 5p) / (10u)))) * 50n)) + (floor(((ceil(((240n) - 5p) / (10u))) - 1) / 2.0) * (((((60n) - 0) + 60n) * 120n) + (((240n) / (ceil(((240n) - 5p) / (10u)))) * 100n))) + ((((ceil(((240n) - 5p) / (10u))) / 2) - floor((ceil(((240n) - 5p) / (10u))) / 2) == 0) ? (((50n > (((60n) - 0) + 60n) ? 50n : (((60n) - 0) + 60n)) * 120n) + (((240n) / (ceil(((240n) - 5p) / (10u)))) * 50n)) : 0)) / 1 : (((100n > (((60n) - 0) + 80n) ? 100n : (((60n) - 0) + 80n)) * ((240n) / (ceil(((240n) - 5p) / (10u))))) + (floor(((ceil(((240n) - 5p) / (10u))) - 1) / 2.0) * ((60n > (((60n) - 0) + 50n) ? 60n : (((60n) - 0) + 50n)) * ((240n) / (ceil(((240n) - 5p) / (10u)))))) + ((((ceil(((240n) - 5p) / (10u))) / 2) - floor((ceil(((240n) - 5p) / (10u))) / 2) == 0) ? ((100n > (((60n) - 0) + 80n) ? 100n : (((60n) - 0) + 80n)) * ((240n) / (ceil(((240n) - 5p) / (10u))))) : 0)) / 1           ad=(((240n) / (ceil(((240n) - 5p) / (10u)))) < 119.5n) ? ((floor((ceil(((240n) - 5p) / (10u))) / 2.0) * (((((60n) - 0) + 60n) * 120n) + (((240n) / (ceil(((240n) - 5p) / (10u)))) * 100n))) + ((((ceil(((240n) - 5p) / (10u))) / 2) - floor((ceil(((240n) - 5p) / (10u))) / 2) != 0) ? (((50n > (((60n) - 0) + 60n) ? 50n : (((60n) - 0) + 60n)) * 120n) + (((240n) / (ceil(((240n) - 5p) / (10u)))) * 50n)) : 0)) / 1 : ((floor((ceil(((240n) - 5p) / (10u))) / 2.0) * ((60n > (((60n) - 0) + 50n) ? 60n : (((60n) - 0) + 50n)) * ((240n) / (ceil(((240n) - 5p) / (10u)))))) + ((((ceil(((240n) - 5p) / (10u))) / 2) - floor((ceil(((240n) - 5p) / (10u))) / 2) != 0) ? ((100n > (((60n) - 0) + 80n) ? 100n : (((60n) - 0) + 80n)) * ((240n) / (ceil(((240n) - 5p) / (10u))))) : 0)) / 1           ps=(((240n) / (ceil(((240n) - 5p) / (10u)))) < 119.5n) ? (((2 * (50n > (((60n) - 0) + 60n) ? 50n : (((60n) - 0) + 60n))) + 340n) + (floor(((ceil(((240n) - 5p) / (10u))) - 1) / 2.0) * ((2 * (((60n) - 0) + 60n)) + 440n)) + ((((ceil(((240n) - 5p) / (10u))) / 2) - floor((ceil(((240n) - 5p) / (10u))) / 2) == 0) ? ((2 * (50n > (((60n) - 0) + 60n) ? 50n : (((60n) - 0) + 60n))) + 340n) : 0)) / 1 : (((2 * (100n > (((60n) - 0) + 80n) ? 100n : (((60n) - 0) + 80n))) + (2 * ((240n) / (ceil(((240n) - 5p) / (10u)))))) + (floor(((ceil(((240n) - 5p) / (10u))) - 1) / 2.0) * ((2 * (60n > (((60n) - 0) + 50n) ? 60n : (((60n) - 0) + 50n))) + (2 * ((240n) / (ceil(((240n) - 5p) / (10u))))))) + ((((ceil(((240n) - 5p) / (10u))) / 2) - floor((ceil(((240n) - 5p) / (10u))) / 2) == 0) ? ((2 * (100n > (((60n) - 0) + 80n) ? 100n : (((60n) - 0) + 80n))) + (2 * ((240n) / (ceil(((240n) - 5p) / (10u)))))) : 0)) / 1           pd=(((240n) / (ceil(((240n) - 5p) / (10u)))) < 119.5n) ? ((floor((ceil(((240n) - 5p) / (10u))) / 2.0) * ((2 * (((60n) - 0) + 60n)) + 440n)) + ((((ceil(((240n) - 5p) / (10u))) / 2) - floor((ceil(((240n) - 5p) / (10u))) / 2) != 0) ? ((2 * (50n > (((60n) - 0) + 60n) ? 50n : (((60n) - 0) + 60n))) + 340n) : 0)) / 1 : ((floor((ceil(((240n) - 5p) / (10u))) / 2.0) * ((2 * (60n > (((60n) - 0) + 50n) ? 60n : (((60n) - 0) + 50n))) + (2 * ((240n) / (ceil(((240n) - 5p) / (10u))))))) + ((((ceil(((240n) - 5p) / (10u))) / 2) - floor((ceil(((240n) - 5p) / (10u))) / 2) != 0) ? ((2 * (100n > (((60n) - 0) + 80n) ? 100n : (((60n) - 0) + 80n))) + (2 * ((240n) / (ceil(((240n) - 5p) / (10u)))))) : 0)) / 1           nrd=(((240n) / (ceil(((240n) - 5p) / (10u)))) < 119.5n) ? ((floor((ceil(((240n) - 5p) / (10u))) / 2.0) * (((((60n) - 0) + 60n) * 120n) + (((240n) / (ceil(((240n) - 5p) / (10u)))) * 100n))) + ((((ceil(((240n) - 5p) / (10u))) / 2) - floor((ceil(((240n) - 5p) / (10u))) / 2) != 0) ? (((50n > (((60n) - 0) + 60n) ? 50n : (((60n) - 0) + 60n)) * 120n) + (((240n) / (ceil(((240n) - 5p) / (10u)))) * 50n)) : 0)) / 1 : ((floor((ceil(((240n) - 5p) / (10u))) / 2.0) * ((60n > (((60n) - 0) + 50n) ? 60n : (((60n) - 0) + 50n)) * ((240n) / (ceil(((240n) - 5p) / (10u)))))) + ((((ceil(((240n) - 5p) / (10u))) / 2) - floor((ceil(((240n) - 5p) / (10u))) / 2) != 0) ? ((100n > (((60n) - 0) + 80n) ? 100n : (((60n) - 0) + 80n)) * ((240n) / (ceil(((240n) - 5p) / (10u))))) : 0)) / 1 / (((240n) / (ceil(((240n) - 5p) / (10u)))) * (ceil(((240n) - 5p) / (10u))) * ((240n) / (ceil(((240n) - 5p) / (10u)))) * (ceil(((240n) - 5p) / (10u))))           nrs=(((240n) / (ceil(((240n) - 5p) / (10u)))) < 119.5n) ? ((((50n > (((60n) - 0) + 60n) ? 50n : (((60n) - 0) + 60n)) * 120n) + (((240n) / (ceil(((240n) - 5p) / (10u)))) * 50n)) + (floor(((ceil(((240n) - 5p) / (10u))) - 1) / 2.0) * (((((60n) - 0) + 60n) * 120n) + (((240n) / (ceil(((240n) - 5p) / (10u)))) * 100n))) + ((((ceil(((240n) - 5p) / (10u))) / 2) - floor((ceil(((240n) - 5p) / (10u))) / 2) == 0) ? (((50n > (((60n) - 0) + 60n) ? 50n : (((60n) - 0) + 60n)) * 120n) + (((240n) / (ceil(((240n) - 5p) / (10u)))) * 50n)) : 0)) / 1 : (((100n > (((60n) - 0) + 80n) ? 100n : (((60n) - 0) + 80n)) * ((240n) / (ceil(((240n) - 5p) / (10u))))) + (floor(((ceil(((240n) - 5p) / (10u))) - 1) / 2.0) * ((60n > (((60n) - 0) + 50n) ? 60n : (((60n) - 0) + 50n)) * ((240n) / (ceil(((240n) - 5p) / (10u)))))) + ((((ceil(((240n) - 5p) / (10u))) / 2) - floor((ceil(((240n) - 5p) / (10u))) / 2) == 0) ? ((100n > (((60n) - 0) + 80n) ? 100n : (((60n) - 0) + 80n)) * ((240n) / (ceil(((240n) - 5p) / (10u))))) : 0)) / 1 / (((240n) / (ceil(((240n) - 5p) / (10u)))) * (ceil(((240n) - 5p) / (10u))) * ((240n) / (ceil(((240n) - 5p) / (10u)))) * (ceil(((240n) - 5p) / (10u))))           sa=(((240n) / (ceil(((240n) - 5p) / (10u)))) < 119.5n) ? (50n > (((60n) - 0) + 60n) ? 50n : (((60n) - 0) + 60n)) + 5e-08 : (100n > (((60n) - 0) + 80n) ? 100n : (((60n) - 0) + 80n))           sb=(((240n) / (ceil(((240n) - 5p) / (10u)))) < 119.5n) ? (50n > (((60n) - 0) + 60n) ? 50n : (((60n) - 0) + 60n)) + 5e-08 : (100n > (((60n) - 0) + 80n) ? 100n : (((60n) - 0) + 80n))           sd=(((240n) / (ceil(((240n) - 5p) / (10u)))) < 119.5n) ? (((60n) - 0) + 60n) + (2*5e-08) : (60n > (((60n) - 0) + 50n) ? 60n : (((60n) - 0) + 50n))           sca=(( ((240n) / (ceil(((240n) - 5p) / (10u)))) * ( (((1u) * (1u) / ((((240n) / (ceil(((240n) - 5p) / (10u)))) < 119.5n) ? (50n > (((60n) - 0) + 60n) ? 50n : (((60n) - 0) + 60n)) + 5e-08 : (100n > (((60n) - 0) + 80n) ? 100n : (((60n) - 0) + 80n))+60n)) - ((1u) * (1u) / (((((240n) / (ceil(((240n) - 5p) / (10u)))) < 119.5n) ? (50n > (((60n) - 0) + 60n) ? 50n : (((60n) - 0) + 60n)) + 5e-08 : (100n > (((60n) - 0) + 80n) ? 100n : (((60n) - 0) + 80n))+60n)+(45n)))) + ((1u) * (1u) / ((((240n) / (ceil(((240n) - 5p) / (10u)))) < 119.5n) ? (50n > (((60n) - 0) + 60n) ? 50n : (((60n) - 0) + 60n)) + 5e-08 : (100n > (((60n) - 0) + 80n) ? 100n : (((60n) - 0) + 80n))+60n)) - ((1u) * (1u)/ (((((240n) / (ceil(((240n) - 5p) / (10u)))) < 119.5n) ? (50n > (((60n) - 0) + 60n) ? 50n : (((60n) - 0) + 60n)) + 5e-08 : (100n > (((60n) - 0) + 80n) ? 100n : (((60n) - 0) + 80n))+60n)+(45n))))) + ( (45n) * ( (((1u) * (1u) / (60n)) - ((1u) * (1u) / ((60n)+((240n) / (ceil(((240n) - 5p) / (10u))))))) + ((1u) * (1u) / (60n)) - ((1u) * (1u)/ ((60n)+((240n) / (ceil(((240n) - 5p) / (10u))))))))) / (((240n) / (ceil(((240n) - 5p) / (10u)))) * (45n))           scb=((((240n) / (ceil(((240n) - 5p) / (10u)))) * ((((((240n) / (ceil(((240n) - 5p) / (10u)))) < 119.5n) ? (50n > (((60n) - 0) + 60n) ? 50n : (((60n) - 0) + 60n)) + 5e-08 : (100n > (((60n) - 0) + 80n) ? 100n : (((60n) - 0) + 80n))+60n)/10 + (1u)/100)*exp(-10 * ((((240n) / (ceil(((240n) - 5p) / (10u)))) < 119.5n) ? (50n > (((60n) - 0) + 60n) ? 50n : (((60n) - 0) + 60n)) + 5e-08 : (100n > (((60n) - 0) + 80n) ? 100n : (((60n) - 0) + 80n))+60n) / (1u)) - ((((((240n) / (ceil(((240n) - 5p) / (10u)))) < 119.5n) ? (50n > (((60n) - 0) + 60n) ? 50n : (((60n) - 0) + 60n)) + 5e-08 : (100n > (((60n) - 0) + 80n) ? 100n : (((60n) - 0) + 80n))+60n)+(45n))/10 + (1u)/100)*exp(-10 * (((((240n) / (ceil(((240n) - 5p) / (10u)))) < 119.5n) ? (50n > (((60n) - 0) + 60n) ? 50n : (((60n) - 0) + 60n)) + 5e-08 : (100n > (((60n) - 0) + 80n) ? 100n : (((60n) - 0) + 80n))+60n)+(45n)) / (1u)) + (((((240n) / (ceil(((240n) - 5p) / (10u)))) < 119.5n) ? (50n > (((60n) - 0) + 60n) ? 50n : (((60n) - 0) + 60n)) + 5e-08 : (100n > (((60n) - 0) + 80n) ? 100n : (((60n) - 0) + 80n))+60n)/10 + (1u)/100)*exp(-10 * ((((240n) / (ceil(((240n) - 5p) / (10u)))) < 119.5n) ? (50n > (((60n) - 0) + 60n) ? 50n : (((60n) - 0) + 60n)) + 5e-08 : (100n > (((60n) - 0) + 80n) ? 100n : (((60n) - 0) + 80n))+60n) / (1u)) - ((((((240n) / (ceil(((240n) - 5p) / (10u)))) < 119.5n) ? (50n > (((60n) - 0) + 60n) ? 50n : (((60n) - 0) + 60n)) + 5e-08 : (100n > (((60n) - 0) + 80n) ? 100n : (((60n) - 0) + 80n))+60n)+(45n))/10 + (1u)/100)*exp(-10 * (((((240n) / (ceil(((240n) - 5p) / (10u)))) < 119.5n) ? (50n > (((60n) - 0) + 60n) ? 50n : (((60n) - 0) + 60n)) + 5e-08 : (100n > (((60n) - 0) + 80n) ? 100n : (((60n) - 0) + 80n))+60n)+(45n)) / (1u)))) + ((45n) * (((60n)/10 + (1u)/100)*exp(-10 * (60n) / (1u)) - (((60n)+((240n) / (ceil(((240n) - 5p) / (10u)))))/10 + (1u)/100)*exp(-10 * ((60n)+((240n) / (ceil(((240n) - 5p) / (10u))))) / (1u)) + ((60n)/10 + (1u)/100)*exp(-10 * (60n) / (1u)) - (((60n)+((240n) / (ceil(((240n) - 5p) / (10u)))))/10 + (1u)/100)*exp(-10 * ((60n)+((240n) / (ceil(((240n) - 5p) / (10u))))) / (1u))))) / (((240n) / (ceil(((240n) - 5p) / (10u)))) * (45n))           scc=((((240n) / (ceil(((240n) - 5p) / (10u)))) * ((((((240n) / (ceil(((240n) - 5p) / (10u)))) < 119.5n) ? (50n > (((60n) - 0) + 60n) ? 50n : (((60n) - 0) + 60n)) + 5e-08 : (100n > (((60n) - 0) + 80n) ? 100n : (((60n) - 0) + 80n))+60n)/20 + (1u)/400)*exp(-20 * ((((240n) / (ceil(((240n) - 5p) / (10u)))) < 119.5n) ? (50n > (((60n) - 0) + 60n) ? 50n : (((60n) - 0) + 60n)) + 5e-08 : (100n > (((60n) - 0) + 80n) ? 100n : (((60n) - 0) + 80n))+60n) / (1u)) - ((((((240n) / (ceil(((240n) - 5p) / (10u)))) < 119.5n) ? (50n > (((60n) - 0) + 60n) ? 50n : (((60n) - 0) + 60n)) + 5e-08 : (100n > (((60n) - 0) + 80n) ? 100n : (((60n) - 0) + 80n))+60n)+(45n))/20 + (1u)/400)*exp(-20 * (((((240n) / (ceil(((240n) - 5p) / (10u)))) < 119.5n) ? (50n > (((60n) - 0) + 60n) ? 50n : (((60n) - 0) + 60n)) + 5e-08 : (100n > (((60n) - 0) + 80n) ? 100n : (((60n) - 0) + 80n))+60n)+(45n)) / (1u)) + (((((240n) / (ceil(((240n) - 5p) / (10u)))) < 119.5n) ? (50n > (((60n) - 0) + 60n) ? 50n : (((60n) - 0) + 60n)) + 5e-08 : (100n > (((60n) - 0) + 80n) ? 100n : (((60n) - 0) + 80n))+60n)/20 + (1u)/400)*exp(-20 * ((((240n) / (ceil(((240n) - 5p) / (10u)))) < 119.5n) ? (50n > (((60n) - 0) + 60n) ? 50n : (((60n) - 0) + 60n)) + 5e-08 : (100n > (((60n) - 0) + 80n) ? 100n : (((60n) - 0) + 80n))+60n) / (1u)) - ((((((240n) / (ceil(((240n) - 5p) / (10u)))) < 119.5n) ? (50n > (((60n) - 0) + 60n) ? 50n : (((60n) - 0) + 60n)) + 5e-08 : (100n > (((60n) - 0) + 80n) ? 100n : (((60n) - 0) + 80n))+60n)+(45n))/20 + (1u)/400)*exp(-20 * (((((240n) / (ceil(((240n) - 5p) / (10u)))) < 119.5n) ? (50n > (((60n) - 0) + 60n) ? 50n : (((60n) - 0) + 60n)) + 5e-08 : (100n > (((60n) - 0) + 80n) ? 100n : (((60n) - 0) + 80n))+60n)+(45n)) / (1u)))) + ((45n) * (((60n)/20 + (1u)/400)*exp(-20 * (60n) / (1u)) - (((60n)+((240n) / (ceil(((240n) - 5p) / (10u)))))/20 + (1u)/400)*exp(-20 * ((60n)+((240n) / (ceil(((240n) - 5p) / (10u))))) / (1u)) + ((60n)/20 + (1u)/400)*exp(-20 * (60n) / (1u)) - (((60n)+((240n) / (ceil(((240n) - 5p) / (10u)))))/20 + (1u)/400)*exp(-20 * ((60n)+((240n) / (ceil(((240n) - 5p) / (10u))))) / (1u))))) / (((240n) / (ceil(((240n) - 5p) / (10u)))) * (45n))           m=(1)
NM3 (BL WL Q GND) g45n1svt w=(240n) l=45n nf=ceil(((240n) - 5p) / (10u))           as=(((240n) / (ceil(((240n) - 5p) / (10u)))) < 119.5n) ? ((((50n > (((60n) - 0) + 60n) ? 50n : (((60n) - 0) + 60n)) * 120n) + (((240n) / (ceil(((240n) - 5p) / (10u)))) * 50n)) + (floor(((ceil(((240n) - 5p) / (10u))) - 1) / 2.0) * (((((60n) - 0) + 60n) * 120n) + (((240n) / (ceil(((240n) - 5p) / (10u)))) * 100n))) + ((((ceil(((240n) - 5p) / (10u))) / 2) - floor((ceil(((240n) - 5p) / (10u))) / 2) == 0) ? (((50n > (((60n) - 0) + 60n) ? 50n : (((60n) - 0) + 60n)) * 120n) + (((240n) / (ceil(((240n) - 5p) / (10u)))) * 50n)) : 0)) / 1 : (((100n > (((60n) - 0) + 80n) ? 100n : (((60n) - 0) + 80n)) * ((240n) / (ceil(((240n) - 5p) / (10u))))) + (floor(((ceil(((240n) - 5p) / (10u))) - 1) / 2.0) * ((60n > (((60n) - 0) + 50n) ? 60n : (((60n) - 0) + 50n)) * ((240n) / (ceil(((240n) - 5p) / (10u)))))) + ((((ceil(((240n) - 5p) / (10u))) / 2) - floor((ceil(((240n) - 5p) / (10u))) / 2) == 0) ? ((100n > (((60n) - 0) + 80n) ? 100n : (((60n) - 0) + 80n)) * ((240n) / (ceil(((240n) - 5p) / (10u))))) : 0)) / 1           ad=(((240n) / (ceil(((240n) - 5p) / (10u)))) < 119.5n) ? ((floor((ceil(((240n) - 5p) / (10u))) / 2.0) * (((((60n) - 0) + 60n) * 120n) + (((240n) / (ceil(((240n) - 5p) / (10u)))) * 100n))) + ((((ceil(((240n) - 5p) / (10u))) / 2) - floor((ceil(((240n) - 5p) / (10u))) / 2) != 0) ? (((50n > (((60n) - 0) + 60n) ? 50n : (((60n) - 0) + 60n)) * 120n) + (((240n) / (ceil(((240n) - 5p) / (10u)))) * 50n)) : 0)) / 1 : ((floor((ceil(((240n) - 5p) / (10u))) / 2.0) * ((60n > (((60n) - 0) + 50n) ? 60n : (((60n) - 0) + 50n)) * ((240n) / (ceil(((240n) - 5p) / (10u)))))) + ((((ceil(((240n) - 5p) / (10u))) / 2) - floor((ceil(((240n) - 5p) / (10u))) / 2) != 0) ? ((100n > (((60n) - 0) + 80n) ? 100n : (((60n) - 0) + 80n)) * ((240n) / (ceil(((240n) - 5p) / (10u))))) : 0)) / 1           ps=(((240n) / (ceil(((240n) - 5p) / (10u)))) < 119.5n) ? (((2 * (50n > (((60n) - 0) + 60n) ? 50n : (((60n) - 0) + 60n))) + 340n) + (floor(((ceil(((240n) - 5p) / (10u))) - 1) / 2.0) * ((2 * (((60n) - 0) + 60n)) + 440n)) + ((((ceil(((240n) - 5p) / (10u))) / 2) - floor((ceil(((240n) - 5p) / (10u))) / 2) == 0) ? ((2 * (50n > (((60n) - 0) + 60n) ? 50n : (((60n) - 0) + 60n))) + 340n) : 0)) / 1 : (((2 * (100n > (((60n) - 0) + 80n) ? 100n : (((60n) - 0) + 80n))) + (2 * ((240n) / (ceil(((240n) - 5p) / (10u)))))) + (floor(((ceil(((240n) - 5p) / (10u))) - 1) / 2.0) * ((2 * (60n > (((60n) - 0) + 50n) ? 60n : (((60n) - 0) + 50n))) + (2 * ((240n) / (ceil(((240n) - 5p) / (10u))))))) + ((((ceil(((240n) - 5p) / (10u))) / 2) - floor((ceil(((240n) - 5p) / (10u))) / 2) == 0) ? ((2 * (100n > (((60n) - 0) + 80n) ? 100n : (((60n) - 0) + 80n))) + (2 * ((240n) / (ceil(((240n) - 5p) / (10u)))))) : 0)) / 1           pd=(((240n) / (ceil(((240n) - 5p) / (10u)))) < 119.5n) ? ((floor((ceil(((240n) - 5p) / (10u))) / 2.0) * ((2 * (((60n) - 0) + 60n)) + 440n)) + ((((ceil(((240n) - 5p) / (10u))) / 2) - floor((ceil(((240n) - 5p) / (10u))) / 2) != 0) ? ((2 * (50n > (((60n) - 0) + 60n) ? 50n : (((60n) - 0) + 60n))) + 340n) : 0)) / 1 : ((floor((ceil(((240n) - 5p) / (10u))) / 2.0) * ((2 * (60n > (((60n) - 0) + 50n) ? 60n : (((60n) - 0) + 50n))) + (2 * ((240n) / (ceil(((240n) - 5p) / (10u))))))) + ((((ceil(((240n) - 5p) / (10u))) / 2) - floor((ceil(((240n) - 5p) / (10u))) / 2) != 0) ? ((2 * (100n > (((60n) - 0) + 80n) ? 100n : (((60n) - 0) + 80n))) + (2 * ((240n) / (ceil(((240n) - 5p) / (10u)))))) : 0)) / 1           nrd=(((240n) / (ceil(((240n) - 5p) / (10u)))) < 119.5n) ? ((floor((ceil(((240n) - 5p) / (10u))) / 2.0) * (((((60n) - 0) + 60n) * 120n) + (((240n) / (ceil(((240n) - 5p) / (10u)))) * 100n))) + ((((ceil(((240n) - 5p) / (10u))) / 2) - floor((ceil(((240n) - 5p) / (10u))) / 2) != 0) ? (((50n > (((60n) - 0) + 60n) ? 50n : (((60n) - 0) + 60n)) * 120n) + (((240n) / (ceil(((240n) - 5p) / (10u)))) * 50n)) : 0)) / 1 : ((floor((ceil(((240n) - 5p) / (10u))) / 2.0) * ((60n > (((60n) - 0) + 50n) ? 60n : (((60n) - 0) + 50n)) * ((240n) / (ceil(((240n) - 5p) / (10u)))))) + ((((ceil(((240n) - 5p) / (10u))) / 2) - floor((ceil(((240n) - 5p) / (10u))) / 2) != 0) ? ((100n > (((60n) - 0) + 80n) ? 100n : (((60n) - 0) + 80n)) * ((240n) / (ceil(((240n) - 5p) / (10u))))) : 0)) / 1 / (((240n) / (ceil(((240n) - 5p) / (10u)))) * (ceil(((240n) - 5p) / (10u))) * ((240n) / (ceil(((240n) - 5p) / (10u)))) * (ceil(((240n) - 5p) / (10u))))           nrs=(((240n) / (ceil(((240n) - 5p) / (10u)))) < 119.5n) ? ((((50n > (((60n) - 0) + 60n) ? 50n : (((60n) - 0) + 60n)) * 120n) + (((240n) / (ceil(((240n) - 5p) / (10u)))) * 50n)) + (floor(((ceil(((240n) - 5p) / (10u))) - 1) / 2.0) * (((((60n) - 0) + 60n) * 120n) + (((240n) / (ceil(((240n) - 5p) / (10u)))) * 100n))) + ((((ceil(((240n) - 5p) / (10u))) / 2) - floor((ceil(((240n) - 5p) / (10u))) / 2) == 0) ? (((50n > (((60n) - 0) + 60n) ? 50n : (((60n) - 0) + 60n)) * 120n) + (((240n) / (ceil(((240n) - 5p) / (10u)))) * 50n)) : 0)) / 1 : (((100n > (((60n) - 0) + 80n) ? 100n : (((60n) - 0) + 80n)) * ((240n) / (ceil(((240n) - 5p) / (10u))))) + (floor(((ceil(((240n) - 5p) / (10u))) - 1) / 2.0) * ((60n > (((60n) - 0) + 50n) ? 60n : (((60n) - 0) + 50n)) * ((240n) / (ceil(((240n) - 5p) / (10u)))))) + ((((ceil(((240n) - 5p) / (10u))) / 2) - floor((ceil(((240n) - 5p) / (10u))) / 2) == 0) ? ((100n > (((60n) - 0) + 80n) ? 100n : (((60n) - 0) + 80n)) * ((240n) / (ceil(((240n) - 5p) / (10u))))) : 0)) / 1 / (((240n) / (ceil(((240n) - 5p) / (10u)))) * (ceil(((240n) - 5p) / (10u))) * ((240n) / (ceil(((240n) - 5p) / (10u)))) * (ceil(((240n) - 5p) / (10u))))           sa=(((240n) / (ceil(((240n) - 5p) / (10u)))) < 119.5n) ? (50n > (((60n) - 0) + 60n) ? 50n : (((60n) - 0) + 60n)) + 5e-08 : (100n > (((60n) - 0) + 80n) ? 100n : (((60n) - 0) + 80n))           sb=(((240n) / (ceil(((240n) - 5p) / (10u)))) < 119.5n) ? (50n > (((60n) - 0) + 60n) ? 50n : (((60n) - 0) + 60n)) + 5e-08 : (100n > (((60n) - 0) + 80n) ? 100n : (((60n) - 0) + 80n))           sd=(((240n) / (ceil(((240n) - 5p) / (10u)))) < 119.5n) ? (((60n) - 0) + 60n) + (2*5e-08) : (60n > (((60n) - 0) + 50n) ? 60n : (((60n) - 0) + 50n))           sca=(( ((240n) / (ceil(((240n) - 5p) / (10u)))) * ( (((1u) * (1u) / ((((240n) / (ceil(((240n) - 5p) / (10u)))) < 119.5n) ? (50n > (((60n) - 0) + 60n) ? 50n : (((60n) - 0) + 60n)) + 5e-08 : (100n > (((60n) - 0) + 80n) ? 100n : (((60n) - 0) + 80n))+60n)) - ((1u) * (1u) / (((((240n) / (ceil(((240n) - 5p) / (10u)))) < 119.5n) ? (50n > (((60n) - 0) + 60n) ? 50n : (((60n) - 0) + 60n)) + 5e-08 : (100n > (((60n) - 0) + 80n) ? 100n : (((60n) - 0) + 80n))+60n)+(45n)))) + ((1u) * (1u) / ((((240n) / (ceil(((240n) - 5p) / (10u)))) < 119.5n) ? (50n > (((60n) - 0) + 60n) ? 50n : (((60n) - 0) + 60n)) + 5e-08 : (100n > (((60n) - 0) + 80n) ? 100n : (((60n) - 0) + 80n))+60n)) - ((1u) * (1u)/ (((((240n) / (ceil(((240n) - 5p) / (10u)))) < 119.5n) ? (50n > (((60n) - 0) + 60n) ? 50n : (((60n) - 0) + 60n)) + 5e-08 : (100n > (((60n) - 0) + 80n) ? 100n : (((60n) - 0) + 80n))+60n)+(45n))))) + ( (45n) * ( (((1u) * (1u) / (60n)) - ((1u) * (1u) / ((60n)+((240n) / (ceil(((240n) - 5p) / (10u))))))) + ((1u) * (1u) / (60n)) - ((1u) * (1u)/ ((60n)+((240n) / (ceil(((240n) - 5p) / (10u))))))))) / (((240n) / (ceil(((240n) - 5p) / (10u)))) * (45n))           scb=((((240n) / (ceil(((240n) - 5p) / (10u)))) * ((((((240n) / (ceil(((240n) - 5p) / (10u)))) < 119.5n) ? (50n > (((60n) - 0) + 60n) ? 50n : (((60n) - 0) + 60n)) + 5e-08 : (100n > (((60n) - 0) + 80n) ? 100n : (((60n) - 0) + 80n))+60n)/10 + (1u)/100)*exp(-10 * ((((240n) / (ceil(((240n) - 5p) / (10u)))) < 119.5n) ? (50n > (((60n) - 0) + 60n) ? 50n : (((60n) - 0) + 60n)) + 5e-08 : (100n > (((60n) - 0) + 80n) ? 100n : (((60n) - 0) + 80n))+60n) / (1u)) - ((((((240n) / (ceil(((240n) - 5p) / (10u)))) < 119.5n) ? (50n > (((60n) - 0) + 60n) ? 50n : (((60n) - 0) + 60n)) + 5e-08 : (100n > (((60n) - 0) + 80n) ? 100n : (((60n) - 0) + 80n))+60n)+(45n))/10 + (1u)/100)*exp(-10 * (((((240n) / (ceil(((240n) - 5p) / (10u)))) < 119.5n) ? (50n > (((60n) - 0) + 60n) ? 50n : (((60n) - 0) + 60n)) + 5e-08 : (100n > (((60n) - 0) + 80n) ? 100n : (((60n) - 0) + 80n))+60n)+(45n)) / (1u)) + (((((240n) / (ceil(((240n) - 5p) / (10u)))) < 119.5n) ? (50n > (((60n) - 0) + 60n) ? 50n : (((60n) - 0) + 60n)) + 5e-08 : (100n > (((60n) - 0) + 80n) ? 100n : (((60n) - 0) + 80n))+60n)/10 + (1u)/100)*exp(-10 * ((((240n) / (ceil(((240n) - 5p) / (10u)))) < 119.5n) ? (50n > (((60n) - 0) + 60n) ? 50n : (((60n) - 0) + 60n)) + 5e-08 : (100n > (((60n) - 0) + 80n) ? 100n : (((60n) - 0) + 80n))+60n) / (1u)) - ((((((240n) / (ceil(((240n) - 5p) / (10u)))) < 119.5n) ? (50n > (((60n) - 0) + 60n) ? 50n : (((60n) - 0) + 60n)) + 5e-08 : (100n > (((60n) - 0) + 80n) ? 100n : (((60n) - 0) + 80n))+60n)+(45n))/10 + (1u)/100)*exp(-10 * (((((240n) / (ceil(((240n) - 5p) / (10u)))) < 119.5n) ? (50n > (((60n) - 0) + 60n) ? 50n : (((60n) - 0) + 60n)) + 5e-08 : (100n > (((60n) - 0) + 80n) ? 100n : (((60n) - 0) + 80n))+60n)+(45n)) / (1u)))) + ((45n) * (((60n)/10 + (1u)/100)*exp(-10 * (60n) / (1u)) - (((60n)+((240n) / (ceil(((240n) - 5p) / (10u)))))/10 + (1u)/100)*exp(-10 * ((60n)+((240n) / (ceil(((240n) - 5p) / (10u))))) / (1u)) + ((60n)/10 + (1u)/100)*exp(-10 * (60n) / (1u)) - (((60n)+((240n) / (ceil(((240n) - 5p) / (10u)))))/10 + (1u)/100)*exp(-10 * ((60n)+((240n) / (ceil(((240n) - 5p) / (10u))))) / (1u))))) / (((240n) / (ceil(((240n) - 5p) / (10u)))) * (45n))           scc=((((240n) / (ceil(((240n) - 5p) / (10u)))) * ((((((240n) / (ceil(((240n) - 5p) / (10u)))) < 119.5n) ? (50n > (((60n) - 0) + 60n) ? 50n : (((60n) - 0) + 60n)) + 5e-08 : (100n > (((60n) - 0) + 80n) ? 100n : (((60n) - 0) + 80n))+60n)/20 + (1u)/400)*exp(-20 * ((((240n) / (ceil(((240n) - 5p) / (10u)))) < 119.5n) ? (50n > (((60n) - 0) + 60n) ? 50n : (((60n) - 0) + 60n)) + 5e-08 : (100n > (((60n) - 0) + 80n) ? 100n : (((60n) - 0) + 80n))+60n) / (1u)) - ((((((240n) / (ceil(((240n) - 5p) / (10u)))) < 119.5n) ? (50n > (((60n) - 0) + 60n) ? 50n : (((60n) - 0) + 60n)) + 5e-08 : (100n > (((60n) - 0) + 80n) ? 100n : (((60n) - 0) + 80n))+60n)+(45n))/20 + (1u)/400)*exp(-20 * (((((240n) / (ceil(((240n) - 5p) / (10u)))) < 119.5n) ? (50n > (((60n) - 0) + 60n) ? 50n : (((60n) - 0) + 60n)) + 5e-08 : (100n > (((60n) - 0) + 80n) ? 100n : (((60n) - 0) + 80n))+60n)+(45n)) / (1u)) + (((((240n) / (ceil(((240n) - 5p) / (10u)))) < 119.5n) ? (50n > (((60n) - 0) + 60n) ? 50n : (((60n) - 0) + 60n)) + 5e-08 : (100n > (((60n) - 0) + 80n) ? 100n : (((60n) - 0) + 80n))+60n)/20 + (1u)/400)*exp(-20 * ((((240n) / (ceil(((240n) - 5p) / (10u)))) < 119.5n) ? (50n > (((60n) - 0) + 60n) ? 50n : (((60n) - 0) + 60n)) + 5e-08 : (100n > (((60n) - 0) + 80n) ? 100n : (((60n) - 0) + 80n))+60n) / (1u)) - ((((((240n) / (ceil(((240n) - 5p) / (10u)))) < 119.5n) ? (50n > (((60n) - 0) + 60n) ? 50n : (((60n) - 0) + 60n)) + 5e-08 : (100n > (((60n) - 0) + 80n) ? 100n : (((60n) - 0) + 80n))+60n)+(45n))/20 + (1u)/400)*exp(-20 * (((((240n) / (ceil(((240n) - 5p) / (10u)))) < 119.5n) ? (50n > (((60n) - 0) + 60n) ? 50n : (((60n) - 0) + 60n)) + 5e-08 : (100n > (((60n) - 0) + 80n) ? 100n : (((60n) - 0) + 80n))+60n)+(45n)) / (1u)))) + ((45n) * (((60n)/20 + (1u)/400)*exp(-20 * (60n) / (1u)) - (((60n)+((240n) / (ceil(((240n) - 5p) / (10u)))))/20 + (1u)/400)*exp(-20 * ((60n)+((240n) / (ceil(((240n) - 5p) / (10u))))) / (1u)) + ((60n)/20 + (1u)/400)*exp(-20 * (60n) / (1u)) - (((60n)+((240n) / (ceil(((240n) - 5p) / (10u)))))/20 + (1u)/400)*exp(-20 * ((60n)+((240n) / (ceil(((240n) - 5p) / (10u))))) / (1u))))) / (((240n) / (ceil(((240n) - 5p) / (10u)))) * (45n))           m=(1)
ends sram_cell
