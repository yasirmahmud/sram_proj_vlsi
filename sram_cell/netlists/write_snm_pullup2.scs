simulator lang=spectre
include "/ecel/UFAD/ymahmud/vlsi_sram_project/Project files/gpdk045_mos.scs" section=tt
parameters vdd=1.1 voffset=0
simOptions options reltol=1e-5 vabstol=1e-7 iabstol=1e-14 temp=27 gmin=1e-14
Vdd (Vdd 0) vsource dc=vdd
Vin (VIN 0) vsource dc=0
PVOUT1 (VOUT1 VIN Vdd Vdd) g45p1svt w=(240n) l=45n nf=ceil(((240n) - 5p) / (10u))           as=(((240n) / (ceil(((240n) - 5p) / (10u)))) < 119.5n) ? ((((50n > (((60n) - 0) + 60n) ? 50n : (((60n) - 0) + 60n)) * 120n) + (((240n) / (ceil(((240n) - 5p) / (10u)))) * 50n)) + (floor(((ceil(((240n) - 5p) / (10u))) - 1) / 2.0) * (((((60n) - 0) + 60n) * 120n) + (((240n) / (ceil(((240n) - 5p) / (10u)))) * 100n))) + ((((ceil(((240n) - 5p) / (10u))) / 2) - floor((ceil(((240n) - 5p) / (10u))) / 2) == 0) ? (((50n > (((60n) - 0) + 60n) ? 50n : (((60n) - 0) + 60n)) * 120n) + (((240n) / (ceil(((240n) - 5p) / (10u)))) * 50n)) : 0)) / 1 : (((100n > (((60n) - 0) + 80n) ? 100n : (((60n) - 0) + 80n)) * ((240n) / (ceil(((240n) - 5p) / (10u))))) + (floor(((ceil(((240n) - 5p) / (10u))) - 1) / 2.0) * ((60n > (((60n) - 0) + 50n) ? 60n : (((60n) - 0) + 50n)) * ((240n) / (ceil(((240n) - 5p) / (10u)))))) + ((((ceil(((240n) - 5p) / (10u))) / 2) - floor((ceil(((240n) - 5p) / (10u))) / 2) == 0) ? ((100n > (((60n) - 0) + 80n) ? 100n : (((60n) - 0) + 80n)) * ((240n) / (ceil(((240n) - 5p) / (10u))))) : 0)) / 1           ad=(((240n) / (ceil(((240n) - 5p) / (10u)))) < 119.5n) ? ((floor((ceil(((240n) - 5p) / (10u))) / 2.0) * (((((60n) - 0) + 60n) * 120n) + (((240n) / (ceil(((240n) - 5p) / (10u)))) * 100n))) + ((((ceil(((240n) - 5p) / (10u))) / 2) - floor((ceil(((240n) - 5p) / (10u))) / 2) != 0) ? (((50n > (((60n) - 0) + 60n) ? 50n : (((60n) - 0) + 60n)) * 120n) + (((240n) / (ceil(((240n) - 5p) / (10u)))) * 50n)) : 0)) / 1 : ((floor((ceil(((240n) - 5p) / (10u))) / 2.0) * ((60n > (((60n) - 0) + 50n) ? 60n : (((60n) - 0) + 50n)) * ((240n) / (ceil(((240n) - 5p) / (10u)))))) + ((((ceil(((240n) - 5p) / (10u))) / 2) - floor((ceil(((240n) - 5p) / (10u))) / 2) != 0) ? ((100n > (((60n) - 0) + 80n) ? 100n : (((60n) - 0) + 80n)) * ((240n) / (ceil(((240n) - 5p) / (10u))))) : 0)) / 1           ps=(((240n) / (ceil(((240n) - 5p) / (10u)))) < 119.5n) ? (((2 * (50n > (((60n) - 0) + 60n) ? 50n : (((60n) - 0) + 60n))) + 340n) + (floor(((ceil(((240n) - 5p) / (10u))) - 1) / 2.0) * ((2 * (((60n) - 0) + 60n)) + 440n)) + ((((ceil(((240n) - 5p) / (10u))) / 2) - floor((ceil(((240n) - 5p) / (10u))) / 2) == 0) ? ((2 * (50n > (((60n) - 0) + 60n) ? 50n : (((60n) - 0) + 60n))) + 340n) : 0)) / 1 : (((2 * (100n > (((60n) - 0) + 80n) ? 100n : (((60n) - 0) + 80n))) + (2 * ((240n) / (ceil(((240n) - 5p) / (10u)))))) + (floor(((ceil(((240n) - 5p) / (10u))) - 1) / 2.0) * ((2 * (60n > (((60n) - 0) + 50n) ? 60n : (((60n) - 0) + 50n))) + (2 * ((240n) / (ceil(((240n) - 5p) / (10u))))))) + ((((ceil(((240n) - 5p) / (10u))) / 2) - floor((ceil(((240n) - 5p) / (10u))) / 2) == 0) ? ((2 * (100n > (((60n) - 0) + 80n) ? 100n : (((60n) - 0) + 80n))) + (2 * ((240n) / (ceil(((240n) - 5p) / (10u)))))) : 0)) / 1           pd=(((240n) / (ceil(((240n) - 5p) / (10u)))) < 119.5n) ? ((floor((ceil(((240n) - 5p) / (10u))) / 2.0) * ((2 * (((60n) - 0) + 60n)) + 440n)) + ((((ceil(((240n) - 5p) / (10u))) / 2) - floor((ceil(((240n) - 5p) / (10u))) / 2) != 0) ? ((2 * (50n > (((60n) - 0) + 60n) ? 50n : (((60n) - 0) + 60n))) + 340n) : 0)) / 1 : ((floor((ceil(((240n) - 5p) / (10u))) / 2.0) * ((2 * (60n > (((60n) - 0) + 50n) ? 60n : (((60n) - 0) + 50n))) + (2 * ((240n) / (ceil(((240n) - 5p) / (10u))))))) + ((((ceil(((240n) - 5p) / (10u))) / 2) - floor((ceil(((240n) - 5p) / (10u))) / 2) != 0) ? ((2 * (100n > (((60n) - 0) + 80n) ? 100n : (((60n) - 0) + 80n))) + (2 * ((240n) / (ceil(((240n) - 5p) / (10u)))))) : 0)) / 1           nrd=(((240n) / (ceil(((240n) - 5p) / (10u)))) < 119.5n) ? ((floor((ceil(((240n) - 5p) / (10u))) / 2.0) * (((((60n) - 0) + 60n) * 120n) + (((240n) / (ceil(((240n) - 5p) / (10u)))) * 100n))) + ((((ceil(((240n) - 5p) / (10u))) / 2) - floor((ceil(((240n) - 5p) / (10u))) / 2) != 0) ? (((50n > (((60n) - 0) + 60n) ? 50n : (((60n) - 0) + 60n)) * 120n) + (((240n) / (ceil(((240n) - 5p) / (10u)))) * 50n)) : 0)) / 1 : ((floor((ceil(((240n) - 5p) / (10u))) / 2.0) * ((60n > (((60n) - 0) + 50n) ? 60n : (((60n) - 0) + 50n)) * ((240n) / (ceil(((240n) - 5p) / (10u)))))) + ((((ceil(((240n) - 5p) / (10u))) / 2) - floor((ceil(((240n) - 5p) / (10u))) / 2) != 0) ? ((100n > (((60n) - 0) + 80n) ? 100n : (((60n) - 0) + 80n)) * ((240n) / (ceil(((240n) - 5p) / (10u))))) : 0)) / 1 / (((240n) / (ceil(((240n) - 5p) / (10u)))) * (ceil(((240n) - 5p) / (10u))) * ((240n) / (ceil(((240n) - 5p) / (10u)))) * (ceil(((240n) - 5p) / (10u))))           nrs=(((240n) / (ceil(((240n) - 5p) / (10u)))) < 119.5n) ? ((((50n > (((60n) - 0) + 60n) ? 50n : (((60n) - 0) + 60n)) * 120n) + (((240n) / (ceil(((240n) - 5p) / (10u)))) * 50n)) + (floor(((ceil(((240n) - 5p) / (10u))) - 1) / 2.0) * (((((60n) - 0) + 60n) * 120n) + (((240n) / (ceil(((240n) - 5p) / (10u)))) * 100n))) + ((((ceil(((240n) - 5p) / (10u))) / 2) - floor((ceil(((240n) - 5p) / (10u))) / 2) == 0) ? (((50n > (((60n) - 0) + 60n) ? 50n : (((60n) - 0) + 60n)) * 120n) + (((240n) / (ceil(((240n) - 5p) / (10u)))) * 50n)) : 0)) / 1 : (((100n > (((60n) - 0) + 80n) ? 100n : (((60n) - 0) + 80n)) * ((240n) / (ceil(((240n) - 5p) / (10u))))) + (floor(((ceil(((240n) - 5p) / (10u))) - 1) / 2.0) * ((60n > (((60n) - 0) + 50n) ? 60n : (((60n) - 0) + 50n)) * ((240n) / (ceil(((240n) - 5p) / (10u)))))) + ((((ceil(((240n) - 5p) / (10u))) / 2) - floor((ceil(((240n) - 5p) / (10u))) / 2) == 0) ? ((100n > (((60n) - 0) + 80n) ? 100n : (((60n) - 0) + 80n)) * ((240n) / (ceil(((240n) - 5p) / (10u))))) : 0)) / 1 / (((240n) / (ceil(((240n) - 5p) / (10u)))) * (ceil(((240n) - 5p) / (10u))) * ((240n) / (ceil(((240n) - 5p) / (10u)))) * (ceil(((240n) - 5p) / (10u))))           sa=(((240n) / (ceil(((240n) - 5p) / (10u)))) < 119.5n) ? (50n > (((60n) - 0) + 60n) ? 50n : (((60n) - 0) + 60n)) + 5e-08 : (100n > (((60n) - 0) + 80n) ? 100n : (((60n) - 0) + 80n))           sb=(((240n) / (ceil(((240n) - 5p) / (10u)))) < 119.5n) ? (50n > (((60n) - 0) + 60n) ? 50n : (((60n) - 0) + 60n)) + 5e-08 : (100n > (((60n) - 0) + 80n) ? 100n : (((60n) - 0) + 80n))           sd=(((240n) / (ceil(((240n) - 5p) / (10u)))) < 119.5n) ? (((60n) - 0) + 60n) + (2*5e-08) : (60n > (((60n) - 0) + 50n) ? 60n : (((60n) - 0) + 50n))           sca=(( ((240n) / (ceil(((240n) - 5p) / (10u)))) * ( (((1u) * (1u) / ((((240n) / (ceil(((240n) - 5p) / (10u)))) < 119.5n) ? (50n > (((60n) - 0) + 60n) ? 50n : (((60n) - 0) + 60n)) + 5e-08 : (100n > (((60n) - 0) + 80n) ? 100n : (((60n) - 0) + 80n))+60n)) - ((1u) * (1u) / (((((240n) / (ceil(((240n) - 5p) / (10u)))) < 119.5n) ? (50n > (((60n) - 0) + 60n) ? 50n : (((60n) - 0) + 60n)) + 5e-08 : (100n > (((60n) - 0) + 80n) ? 100n : (((60n) - 0) + 80n))+60n)+(45n)))) + ((1u) * (1u) / ((((240n) / (ceil(((240n) - 5p) / (10u)))) < 119.5n) ? (50n > (((60n) - 0) + 60n) ? 50n : (((60n) - 0) + 60n)) + 5e-08 : (100n > (((60n) - 0) + 80n) ? 100n : (((60n) - 0) + 80n))+60n)) - ((1u) * (1u)/ (((((240n) / (ceil(((240n) - 5p) / (10u)))) < 119.5n) ? (50n > (((60n) - 0) + 60n) ? 50n : (((60n) - 0) + 60n)) + 5e-08 : (100n > (((60n) - 0) + 80n) ? 100n : (((60n) - 0) + 80n))+60n)+(45n))))) + ( (45n) * ( (((1u) * (1u) / (60n)) - ((1u) * (1u) / ((60n)+((240n) / (ceil(((240n) - 5p) / (10u))))))) + ((1u) * (1u) / (60n)) - ((1u) * (1u)/ ((60n)+((240n) / (ceil(((240n) - 5p) / (10u))))))))) / (((240n) / (ceil(((240n) - 5p) / (10u)))) * (45n))           scb=((((240n) / (ceil(((240n) - 5p) / (10u)))) * ((((((240n) / (ceil(((240n) - 5p) / (10u)))) < 119.5n) ? (50n > (((60n) - 0) + 60n) ? 50n : (((60n) - 0) + 60n)) + 5e-08 : (100n > (((60n) - 0) + 80n) ? 100n : (((60n) - 0) + 80n))+60n)/10 + (1u)/100)*exp(-10 * ((((240n) / (ceil(((240n) - 5p) / (10u)))) < 119.5n) ? (50n > (((60n) - 0) + 60n) ? 50n : (((60n) - 0) + 60n)) + 5e-08 : (100n > (((60n) - 0) + 80n) ? 100n : (((60n) - 0) + 80n))+60n) / (1u)) - ((((((240n) / (ceil(((240n) - 5p) / (10u)))) < 119.5n) ? (50n > (((60n) - 0) + 60n) ? 50n : (((60n) - 0) + 60n)) + 5e-08 : (100n > (((60n) - 0) + 80n) ? 100n : (((60n) - 0) + 80n))+60n)+(45n))/10 + (1u)/100)*exp(-10 * (((((240n) / (ceil(((240n) - 5p) / (10u)))) < 119.5n) ? (50n > (((60n) - 0) + 60n) ? 50n : (((60n) - 0) + 60n)) + 5e-08 : (100n > (((60n) - 0) + 80n) ? 100n : (((60n) - 0) + 80n))+60n)+(45n)) / (1u)) + (((((240n) / (ceil(((240n) - 5p) / (10u)))) < 119.5n) ? (50n > (((60n) - 0) + 60n) ? 50n : (((60n) - 0) + 60n)) + 5e-08 : (100n > (((60n) - 0) + 80n) ? 100n : (((60n) - 0) + 80n))+60n)/10 + (1u)/100)*exp(-10 * ((((240n) / (ceil(((240n) - 5p) / (10u)))) < 119.5n) ? (50n > (((60n) - 0) + 60n) ? 50n : (((60n) - 0) + 60n)) + 5e-08 : (100n > (((60n) - 0) + 80n) ? 100n : (((60n) - 0) + 80n))+60n) / (1u)) - ((((((240n) / (ceil(((240n) - 5p) / (10u)))) < 119.5n) ? (50n > (((60n) - 0) + 60n) ? 50n : (((60n) - 0) + 60n)) + 5e-08 : (100n > (((60n) - 0) + 80n) ? 100n : (((60n) - 0) + 80n))+60n)+(45n))/10 + (1u)/100)*exp(-10 * (((((240n) / (ceil(((240n) - 5p) / (10u)))) < 119.5n) ? (50n > (((60n) - 0) + 60n) ? 50n : (((60n) - 0) + 60n)) + 5e-08 : (100n > (((60n) - 0) + 80n) ? 100n : (((60n) - 0) + 80n))+60n)+(45n)) / (1u)))) + ((45n) * (((60n)/10 + (1u)/100)*exp(-10 * (60n) / (1u)) - (((60n)+((240n) / (ceil(((240n) - 5p) / (10u)))))/10 + (1u)/100)*exp(-10 * ((60n)+((240n) / (ceil(((240n) - 5p) / (10u))))) / (1u)) + ((60n)/10 + (1u)/100)*exp(-10 * (60n) / (1u)) - (((60n)+((240n) / (ceil(((240n) - 5p) / (10u)))))/10 + (1u)/100)*exp(-10 * ((60n)+((240n) / (ceil(((240n) - 5p) / (10u))))) / (1u))))) / (((240n) / (ceil(((240n) - 5p) / (10u)))) * (45n))           scc=((((240n) / (ceil(((240n) - 5p) / (10u)))) * ((((((240n) / (ceil(((240n) - 5p) / (10u)))) < 119.5n) ? (50n > (((60n) - 0) + 60n) ? 50n : (((60n) - 0) + 60n)) + 5e-08 : (100n > (((60n) - 0) + 80n) ? 100n : (((60n) - 0) + 80n))+60n)/20 + (1u)/400)*exp(-20 * ((((240n) / (ceil(((240n) - 5p) / (10u)))) < 119.5n) ? (50n > (((60n) - 0) + 60n) ? 50n : (((60n) - 0) + 60n)) + 5e-08 : (100n > (((60n) - 0) + 80n) ? 100n : (((60n) - 0) + 80n))+60n) / (1u)) - ((((((240n) / (ceil(((240n) - 5p) / (10u)))) < 119.5n) ? (50n > (((60n) - 0) + 60n) ? 50n : (((60n) - 0) + 60n)) + 5e-08 : (100n > (((60n) - 0) + 80n) ? 100n : (((60n) - 0) + 80n))+60n)+(45n))/20 + (1u)/400)*exp(-20 * (((((240n) / (ceil(((240n) - 5p) / (10u)))) < 119.5n) ? (50n > (((60n) - 0) + 60n) ? 50n : (((60n) - 0) + 60n)) + 5e-08 : (100n > (((60n) - 0) + 80n) ? 100n : (((60n) - 0) + 80n))+60n)+(45n)) / (1u)) + (((((240n) / (ceil(((240n) - 5p) / (10u)))) < 119.5n) ? (50n > (((60n) - 0) + 60n) ? 50n : (((60n) - 0) + 60n)) + 5e-08 : (100n > (((60n) - 0) + 80n) ? 100n : (((60n) - 0) + 80n))+60n)/20 + (1u)/400)*exp(-20 * ((((240n) / (ceil(((240n) - 5p) / (10u)))) < 119.5n) ? (50n > (((60n) - 0) + 60n) ? 50n : (((60n) - 0) + 60n)) + 5e-08 : (100n > (((60n) - 0) + 80n) ? 100n : (((60n) - 0) + 80n))+60n) / (1u)) - ((((((240n) / (ceil(((240n) - 5p) / (10u)))) < 119.5n) ? (50n > (((60n) - 0) + 60n) ? 50n : (((60n) - 0) + 60n)) + 5e-08 : (100n > (((60n) - 0) + 80n) ? 100n : (((60n) - 0) + 80n))+60n)+(45n))/20 + (1u)/400)*exp(-20 * (((((240n) / (ceil(((240n) - 5p) / (10u)))) < 119.5n) ? (50n > (((60n) - 0) + 60n) ? 50n : (((60n) - 0) + 60n)) + 5e-08 : (100n > (((60n) - 0) + 80n) ? 100n : (((60n) - 0) + 80n))+60n)+(45n)) / (1u)))) + ((45n) * (((60n)/20 + (1u)/400)*exp(-20 * (60n) / (1u)) - (((60n)+((240n) / (ceil(((240n) - 5p) / (10u)))))/20 + (1u)/400)*exp(-20 * ((60n)+((240n) / (ceil(((240n) - 5p) / (10u))))) / (1u)) + ((60n)/20 + (1u)/400)*exp(-20 * (60n) / (1u)) - (((60n)+((240n) / (ceil(((240n) - 5p) / (10u)))))/20 + (1u)/400)*exp(-20 * ((60n)+((240n) / (ceil(((240n) - 5p) / (10u))))) / (1u))))) / (((240n) / (ceil(((240n) - 5p) / (10u)))) * (45n))           m=(1)
NVOUT1 (VOUT1 VIN 0 0) g45n1svt w=(120n) l=45n nf=ceil(((120n) - 5p) / (10u))           as=(((120n) / (ceil(((120n) - 5p) / (10u)))) < 119.5n) ? ((((50n > (((60n) - 0) + 60n) ? 50n : (((60n) - 0) + 60n)) * 120n) + (((120n) / (ceil(((120n) - 5p) / (10u)))) * 50n)) + (floor(((ceil(((120n) - 5p) / (10u))) - 1) / 2.0) * (((((60n) - 0) + 60n) * 120n) + (((120n) / (ceil(((120n) - 5p) / (10u)))) * 100n))) + ((((ceil(((120n) - 5p) / (10u))) / 2) - floor((ceil(((120n) - 5p) / (10u))) / 2) == 0) ? (((50n > (((60n) - 0) + 60n) ? 50n : (((60n) - 0) + 60n)) * 120n) + (((120n) / (ceil(((120n) - 5p) / (10u)))) * 50n)) : 0)) / 1 : (((100n > (((60n) - 0) + 80n) ? 100n : (((60n) - 0) + 80n)) * ((120n) / (ceil(((120n) - 5p) / (10u))))) + (floor(((ceil(((120n) - 5p) / (10u))) - 1) / 2.0) * ((60n > (((60n) - 0) + 50n) ? 60n : (((60n) - 0) + 50n)) * ((120n) / (ceil(((120n) - 5p) / (10u)))))) + ((((ceil(((120n) - 5p) / (10u))) / 2) - floor((ceil(((120n) - 5p) / (10u))) / 2) == 0) ? ((100n > (((60n) - 0) + 80n) ? 100n : (((60n) - 0) + 80n)) * ((120n) / (ceil(((120n) - 5p) / (10u))))) : 0)) / 1           ad=(((120n) / (ceil(((120n) - 5p) / (10u)))) < 119.5n) ? ((floor((ceil(((120n) - 5p) / (10u))) / 2.0) * (((((60n) - 0) + 60n) * 120n) + (((120n) / (ceil(((120n) - 5p) / (10u)))) * 100n))) + ((((ceil(((120n) - 5p) / (10u))) / 2) - floor((ceil(((120n) - 5p) / (10u))) / 2) != 0) ? (((50n > (((60n) - 0) + 60n) ? 50n : (((60n) - 0) + 60n)) * 120n) + (((120n) / (ceil(((120n) - 5p) / (10u)))) * 50n)) : 0)) / 1 : ((floor((ceil(((120n) - 5p) / (10u))) / 2.0) * ((60n > (((60n) - 0) + 50n) ? 60n : (((60n) - 0) + 50n)) * ((120n) / (ceil(((120n) - 5p) / (10u)))))) + ((((ceil(((120n) - 5p) / (10u))) / 2) - floor((ceil(((120n) - 5p) / (10u))) / 2) != 0) ? ((100n > (((60n) - 0) + 80n) ? 100n : (((60n) - 0) + 80n)) * ((120n) / (ceil(((120n) - 5p) / (10u))))) : 0)) / 1           ps=(((120n) / (ceil(((120n) - 5p) / (10u)))) < 119.5n) ? (((2 * (50n > (((60n) - 0) + 60n) ? 50n : (((60n) - 0) + 60n))) + 340n) + (floor(((ceil(((120n) - 5p) / (10u))) - 1) / 2.0) * ((2 * (((60n) - 0) + 60n)) + 440n)) + ((((ceil(((120n) - 5p) / (10u))) / 2) - floor((ceil(((120n) - 5p) / (10u))) / 2) == 0) ? ((2 * (50n > (((60n) - 0) + 60n) ? 50n : (((60n) - 0) + 60n))) + 340n) : 0)) / 1 : (((2 * (100n > (((60n) - 0) + 80n) ? 100n : (((60n) - 0) + 80n))) + (2 * ((120n) / (ceil(((120n) - 5p) / (10u)))))) + (floor(((ceil(((120n) - 5p) / (10u))) - 1) / 2.0) * ((2 * (60n > (((60n) - 0) + 50n) ? 60n : (((60n) - 0) + 50n))) + (2 * ((120n) / (ceil(((120n) - 5p) / (10u))))))) + ((((ceil(((120n) - 5p) / (10u))) / 2) - floor((ceil(((120n) - 5p) / (10u))) / 2) == 0) ? ((2 * (100n > (((60n) - 0) + 80n) ? 100n : (((60n) - 0) + 80n))) + (2 * ((120n) / (ceil(((120n) - 5p) / (10u)))))) : 0)) / 1           pd=(((120n) / (ceil(((120n) - 5p) / (10u)))) < 119.5n) ? ((floor((ceil(((120n) - 5p) / (10u))) / 2.0) * ((2 * (((60n) - 0) + 60n)) + 440n)) + ((((ceil(((120n) - 5p) / (10u))) / 2) - floor((ceil(((120n) - 5p) / (10u))) / 2) != 0) ? ((2 * (50n > (((60n) - 0) + 60n) ? 50n : (((60n) - 0) + 60n))) + 340n) : 0)) / 1 : ((floor((ceil(((120n) - 5p) / (10u))) / 2.0) * ((2 * (60n > (((60n) - 0) + 50n) ? 60n : (((60n) - 0) + 50n))) + (2 * ((120n) / (ceil(((120n) - 5p) / (10u))))))) + ((((ceil(((120n) - 5p) / (10u))) / 2) - floor((ceil(((120n) - 5p) / (10u))) / 2) != 0) ? ((2 * (100n > (((60n) - 0) + 80n) ? 100n : (((60n) - 0) + 80n))) + (2 * ((120n) / (ceil(((120n) - 5p) / (10u)))))) : 0)) / 1           nrd=(((120n) / (ceil(((120n) - 5p) / (10u)))) < 119.5n) ? ((floor((ceil(((120n) - 5p) / (10u))) / 2.0) * (((((60n) - 0) + 60n) * 120n) + (((120n) / (ceil(((120n) - 5p) / (10u)))) * 100n))) + ((((ceil(((120n) - 5p) / (10u))) / 2) - floor((ceil(((120n) - 5p) / (10u))) / 2) != 0) ? (((50n > (((60n) - 0) + 60n) ? 50n : (((60n) - 0) + 60n)) * 120n) + (((120n) / (ceil(((120n) - 5p) / (10u)))) * 50n)) : 0)) / 1 : ((floor((ceil(((120n) - 5p) / (10u))) / 2.0) * ((60n > (((60n) - 0) + 50n) ? 60n : (((60n) - 0) + 50n)) * ((120n) / (ceil(((120n) - 5p) / (10u)))))) + ((((ceil(((120n) - 5p) / (10u))) / 2) - floor((ceil(((120n) - 5p) / (10u))) / 2) != 0) ? ((100n > (((60n) - 0) + 80n) ? 100n : (((60n) - 0) + 80n)) * ((120n) / (ceil(((120n) - 5p) / (10u))))) : 0)) / 1 / (((120n) / (ceil(((120n) - 5p) / (10u)))) * (ceil(((120n) - 5p) / (10u))) * ((120n) / (ceil(((120n) - 5p) / (10u)))) * (ceil(((120n) - 5p) / (10u))))           nrs=(((120n) / (ceil(((120n) - 5p) / (10u)))) < 119.5n) ? ((((50n > (((60n) - 0) + 60n) ? 50n : (((60n) - 0) + 60n)) * 120n) + (((120n) / (ceil(((120n) - 5p) / (10u)))) * 50n)) + (floor(((ceil(((120n) - 5p) / (10u))) - 1) / 2.0) * (((((60n) - 0) + 60n) * 120n) + (((120n) / (ceil(((120n) - 5p) / (10u)))) * 100n))) + ((((ceil(((120n) - 5p) / (10u))) / 2) - floor((ceil(((120n) - 5p) / (10u))) / 2) == 0) ? (((50n > (((60n) - 0) + 60n) ? 50n : (((60n) - 0) + 60n)) * 120n) + (((120n) / (ceil(((120n) - 5p) / (10u)))) * 50n)) : 0)) / 1 : (((100n > (((60n) - 0) + 80n) ? 100n : (((60n) - 0) + 80n)) * ((120n) / (ceil(((120n) - 5p) / (10u))))) + (floor(((ceil(((120n) - 5p) / (10u))) - 1) / 2.0) * ((60n > (((60n) - 0) + 50n) ? 60n : (((60n) - 0) + 50n)) * ((120n) / (ceil(((120n) - 5p) / (10u)))))) + ((((ceil(((120n) - 5p) / (10u))) / 2) - floor((ceil(((120n) - 5p) / (10u))) / 2) == 0) ? ((100n > (((60n) - 0) + 80n) ? 100n : (((60n) - 0) + 80n)) * ((120n) / (ceil(((120n) - 5p) / (10u))))) : 0)) / 1 / (((120n) / (ceil(((120n) - 5p) / (10u)))) * (ceil(((120n) - 5p) / (10u))) * ((120n) / (ceil(((120n) - 5p) / (10u)))) * (ceil(((120n) - 5p) / (10u))))           sa=(((120n) / (ceil(((120n) - 5p) / (10u)))) < 119.5n) ? (50n > (((60n) - 0) + 60n) ? 50n : (((60n) - 0) + 60n)) + 5e-08 : (100n > (((60n) - 0) + 80n) ? 100n : (((60n) - 0) + 80n))           sb=(((120n) / (ceil(((120n) - 5p) / (10u)))) < 119.5n) ? (50n > (((60n) - 0) + 60n) ? 50n : (((60n) - 0) + 60n)) + 5e-08 : (100n > (((60n) - 0) + 80n) ? 100n : (((60n) - 0) + 80n))           sd=(((120n) / (ceil(((120n) - 5p) / (10u)))) < 119.5n) ? (((60n) - 0) + 60n) + (2*5e-08) : (60n > (((60n) - 0) + 50n) ? 60n : (((60n) - 0) + 50n))           sca=(( ((120n) / (ceil(((120n) - 5p) / (10u)))) * ( (((1u) * (1u) / ((((120n) / (ceil(((120n) - 5p) / (10u)))) < 119.5n) ? (50n > (((60n) - 0) + 60n) ? 50n : (((60n) - 0) + 60n)) + 5e-08 : (100n > (((60n) - 0) + 80n) ? 100n : (((60n) - 0) + 80n))+60n)) - ((1u) * (1u) / (((((120n) / (ceil(((120n) - 5p) / (10u)))) < 119.5n) ? (50n > (((60n) - 0) + 60n) ? 50n : (((60n) - 0) + 60n)) + 5e-08 : (100n > (((60n) - 0) + 80n) ? 100n : (((60n) - 0) + 80n))+60n)+(45n)))) + ((1u) * (1u) / ((((120n) / (ceil(((120n) - 5p) / (10u)))) < 119.5n) ? (50n > (((60n) - 0) + 60n) ? 50n : (((60n) - 0) + 60n)) + 5e-08 : (100n > (((60n) - 0) + 80n) ? 100n : (((60n) - 0) + 80n))+60n)) - ((1u) * (1u)/ (((((120n) / (ceil(((120n) - 5p) / (10u)))) < 119.5n) ? (50n > (((60n) - 0) + 60n) ? 50n : (((60n) - 0) + 60n)) + 5e-08 : (100n > (((60n) - 0) + 80n) ? 100n : (((60n) - 0) + 80n))+60n)+(45n))))) + ( (45n) * ( (((1u) * (1u) / (60n)) - ((1u) * (1u) / ((60n)+((120n) / (ceil(((120n) - 5p) / (10u))))))) + ((1u) * (1u) / (60n)) - ((1u) * (1u)/ ((60n)+((120n) / (ceil(((120n) - 5p) / (10u))))))))) / (((120n) / (ceil(((120n) - 5p) / (10u)))) * (45n))           scb=((((120n) / (ceil(((120n) - 5p) / (10u)))) * ((((((120n) / (ceil(((120n) - 5p) / (10u)))) < 119.5n) ? (50n > (((60n) - 0) + 60n) ? 50n : (((60n) - 0) + 60n)) + 5e-08 : (100n > (((60n) - 0) + 80n) ? 100n : (((60n) - 0) + 80n))+60n)/10 + (1u)/100)*exp(-10 * ((((120n) / (ceil(((120n) - 5p) / (10u)))) < 119.5n) ? (50n > (((60n) - 0) + 60n) ? 50n : (((60n) - 0) + 60n)) + 5e-08 : (100n > (((60n) - 0) + 80n) ? 100n : (((60n) - 0) + 80n))+60n) / (1u)) - ((((((120n) / (ceil(((120n) - 5p) / (10u)))) < 119.5n) ? (50n > (((60n) - 0) + 60n) ? 50n : (((60n) - 0) + 60n)) + 5e-08 : (100n > (((60n) - 0) + 80n) ? 100n : (((60n) - 0) + 80n))+60n)+(45n))/10 + (1u)/100)*exp(-10 * (((((120n) / (ceil(((120n) - 5p) / (10u)))) < 119.5n) ? (50n > (((60n) - 0) + 60n) ? 50n : (((60n) - 0) + 60n)) + 5e-08 : (100n > (((60n) - 0) + 80n) ? 100n : (((60n) - 0) + 80n))+60n)+(45n)) / (1u)) + (((((120n) / (ceil(((120n) - 5p) / (10u)))) < 119.5n) ? (50n > (((60n) - 0) + 60n) ? 50n : (((60n) - 0) + 60n)) + 5e-08 : (100n > (((60n) - 0) + 80n) ? 100n : (((60n) - 0) + 80n))+60n)/10 + (1u)/100)*exp(-10 * ((((120n) / (ceil(((120n) - 5p) / (10u)))) < 119.5n) ? (50n > (((60n) - 0) + 60n) ? 50n : (((60n) - 0) + 60n)) + 5e-08 : (100n > (((60n) - 0) + 80n) ? 100n : (((60n) - 0) + 80n))+60n) / (1u)) - ((((((120n) / (ceil(((120n) - 5p) / (10u)))) < 119.5n) ? (50n > (((60n) - 0) + 60n) ? 50n : (((60n) - 0) + 60n)) + 5e-08 : (100n > (((60n) - 0) + 80n) ? 100n : (((60n) - 0) + 80n))+60n)+(45n))/10 + (1u)/100)*exp(-10 * (((((120n) / (ceil(((120n) - 5p) / (10u)))) < 119.5n) ? (50n > (((60n) - 0) + 60n) ? 50n : (((60n) - 0) + 60n)) + 5e-08 : (100n > (((60n) - 0) + 80n) ? 100n : (((60n) - 0) + 80n))+60n)+(45n)) / (1u)))) + ((45n) * (((60n)/10 + (1u)/100)*exp(-10 * (60n) / (1u)) - (((60n)+((120n) / (ceil(((120n) - 5p) / (10u)))))/10 + (1u)/100)*exp(-10 * ((60n)+((120n) / (ceil(((120n) - 5p) / (10u))))) / (1u)) + ((60n)/10 + (1u)/100)*exp(-10 * (60n) / (1u)) - (((60n)+((120n) / (ceil(((120n) - 5p) / (10u)))))/10 + (1u)/100)*exp(-10 * ((60n)+((120n) / (ceil(((120n) - 5p) / (10u))))) / (1u))))) / (((120n) / (ceil(((120n) - 5p) / (10u)))) * (45n))           scc=((((120n) / (ceil(((120n) - 5p) / (10u)))) * ((((((120n) / (ceil(((120n) - 5p) / (10u)))) < 119.5n) ? (50n > (((60n) - 0) + 60n) ? 50n : (((60n) - 0) + 60n)) + 5e-08 : (100n > (((60n) - 0) + 80n) ? 100n : (((60n) - 0) + 80n))+60n)/20 + (1u)/400)*exp(-20 * ((((120n) / (ceil(((120n) - 5p) / (10u)))) < 119.5n) ? (50n > (((60n) - 0) + 60n) ? 50n : (((60n) - 0) + 60n)) + 5e-08 : (100n > (((60n) - 0) + 80n) ? 100n : (((60n) - 0) + 80n))+60n) / (1u)) - ((((((120n) / (ceil(((120n) - 5p) / (10u)))) < 119.5n) ? (50n > (((60n) - 0) + 60n) ? 50n : (((60n) - 0) + 60n)) + 5e-08 : (100n > (((60n) - 0) + 80n) ? 100n : (((60n) - 0) + 80n))+60n)+(45n))/20 + (1u)/400)*exp(-20 * (((((120n) / (ceil(((120n) - 5p) / (10u)))) < 119.5n) ? (50n > (((60n) - 0) + 60n) ? 50n : (((60n) - 0) + 60n)) + 5e-08 : (100n > (((60n) - 0) + 80n) ? 100n : (((60n) - 0) + 80n))+60n)+(45n)) / (1u)) + (((((120n) / (ceil(((120n) - 5p) / (10u)))) < 119.5n) ? (50n > (((60n) - 0) + 60n) ? 50n : (((60n) - 0) + 60n)) + 5e-08 : (100n > (((60n) - 0) + 80n) ? 100n : (((60n) - 0) + 80n))+60n)/20 + (1u)/400)*exp(-20 * ((((120n) / (ceil(((120n) - 5p) / (10u)))) < 119.5n) ? (50n > (((60n) - 0) + 60n) ? 50n : (((60n) - 0) + 60n)) + 5e-08 : (100n > (((60n) - 0) + 80n) ? 100n : (((60n) - 0) + 80n))+60n) / (1u)) - ((((((120n) / (ceil(((120n) - 5p) / (10u)))) < 119.5n) ? (50n > (((60n) - 0) + 60n) ? 50n : (((60n) - 0) + 60n)) + 5e-08 : (100n > (((60n) - 0) + 80n) ? 100n : (((60n) - 0) + 80n))+60n)+(45n))/20 + (1u)/400)*exp(-20 * (((((120n) / (ceil(((120n) - 5p) / (10u)))) < 119.5n) ? (50n > (((60n) - 0) + 60n) ? 50n : (((60n) - 0) + 60n)) + 5e-08 : (100n > (((60n) - 0) + 80n) ? 100n : (((60n) - 0) + 80n))+60n)+(45n)) / (1u)))) + ((45n) * (((60n)/20 + (1u)/400)*exp(-20 * (60n) / (1u)) - (((60n)+((120n) / (ceil(((120n) - 5p) / (10u)))))/20 + (1u)/400)*exp(-20 * ((60n)+((120n) / (ceil(((120n) - 5p) / (10u))))) / (1u)) + ((60n)/20 + (1u)/400)*exp(-20 * (60n) / (1u)) - (((60n)+((120n) / (ceil(((120n) - 5p) / (10u)))))/20 + (1u)/400)*exp(-20 * ((60n)+((120n) / (ceil(((120n) - 5p) / (10u))))) / (1u))))) / (((120n) / (ceil(((120n) - 5p) / (10u)))) * (45n))           m=(1)
AVOUT1 (VOUT1 Vdd Vdd 0) g45n1svt w=(120n) l=45n nf=ceil(((120n) - 5p) / (10u))           as=(((120n) / (ceil(((120n) - 5p) / (10u)))) < 119.5n) ? ((((50n > (((60n) - 0) + 60n) ? 50n : (((60n) - 0) + 60n)) * 120n) + (((120n) / (ceil(((120n) - 5p) / (10u)))) * 50n)) + (floor(((ceil(((120n) - 5p) / (10u))) - 1) / 2.0) * (((((60n) - 0) + 60n) * 120n) + (((120n) / (ceil(((120n) - 5p) / (10u)))) * 100n))) + ((((ceil(((120n) - 5p) / (10u))) / 2) - floor((ceil(((120n) - 5p) / (10u))) / 2) == 0) ? (((50n > (((60n) - 0) + 60n) ? 50n : (((60n) - 0) + 60n)) * 120n) + (((120n) / (ceil(((120n) - 5p) / (10u)))) * 50n)) : 0)) / 1 : (((100n > (((60n) - 0) + 80n) ? 100n : (((60n) - 0) + 80n)) * ((120n) / (ceil(((120n) - 5p) / (10u))))) + (floor(((ceil(((120n) - 5p) / (10u))) - 1) / 2.0) * ((60n > (((60n) - 0) + 50n) ? 60n : (((60n) - 0) + 50n)) * ((120n) / (ceil(((120n) - 5p) / (10u)))))) + ((((ceil(((120n) - 5p) / (10u))) / 2) - floor((ceil(((120n) - 5p) / (10u))) / 2) == 0) ? ((100n > (((60n) - 0) + 80n) ? 100n : (((60n) - 0) + 80n)) * ((120n) / (ceil(((120n) - 5p) / (10u))))) : 0)) / 1           ad=(((120n) / (ceil(((120n) - 5p) / (10u)))) < 119.5n) ? ((floor((ceil(((120n) - 5p) / (10u))) / 2.0) * (((((60n) - 0) + 60n) * 120n) + (((120n) / (ceil(((120n) - 5p) / (10u)))) * 100n))) + ((((ceil(((120n) - 5p) / (10u))) / 2) - floor((ceil(((120n) - 5p) / (10u))) / 2) != 0) ? (((50n > (((60n) - 0) + 60n) ? 50n : (((60n) - 0) + 60n)) * 120n) + (((120n) / (ceil(((120n) - 5p) / (10u)))) * 50n)) : 0)) / 1 : ((floor((ceil(((120n) - 5p) / (10u))) / 2.0) * ((60n > (((60n) - 0) + 50n) ? 60n : (((60n) - 0) + 50n)) * ((120n) / (ceil(((120n) - 5p) / (10u)))))) + ((((ceil(((120n) - 5p) / (10u))) / 2) - floor((ceil(((120n) - 5p) / (10u))) / 2) != 0) ? ((100n > (((60n) - 0) + 80n) ? 100n : (((60n) - 0) + 80n)) * ((120n) / (ceil(((120n) - 5p) / (10u))))) : 0)) / 1           ps=(((120n) / (ceil(((120n) - 5p) / (10u)))) < 119.5n) ? (((2 * (50n > (((60n) - 0) + 60n) ? 50n : (((60n) - 0) + 60n))) + 340n) + (floor(((ceil(((120n) - 5p) / (10u))) - 1) / 2.0) * ((2 * (((60n) - 0) + 60n)) + 440n)) + ((((ceil(((120n) - 5p) / (10u))) / 2) - floor((ceil(((120n) - 5p) / (10u))) / 2) == 0) ? ((2 * (50n > (((60n) - 0) + 60n) ? 50n : (((60n) - 0) + 60n))) + 340n) : 0)) / 1 : (((2 * (100n > (((60n) - 0) + 80n) ? 100n : (((60n) - 0) + 80n))) + (2 * ((120n) / (ceil(((120n) - 5p) / (10u)))))) + (floor(((ceil(((120n) - 5p) / (10u))) - 1) / 2.0) * ((2 * (60n > (((60n) - 0) + 50n) ? 60n : (((60n) - 0) + 50n))) + (2 * ((120n) / (ceil(((120n) - 5p) / (10u))))))) + ((((ceil(((120n) - 5p) / (10u))) / 2) - floor((ceil(((120n) - 5p) / (10u))) / 2) == 0) ? ((2 * (100n > (((60n) - 0) + 80n) ? 100n : (((60n) - 0) + 80n))) + (2 * ((120n) / (ceil(((120n) - 5p) / (10u)))))) : 0)) / 1           pd=(((120n) / (ceil(((120n) - 5p) / (10u)))) < 119.5n) ? ((floor((ceil(((120n) - 5p) / (10u))) / 2.0) * ((2 * (((60n) - 0) + 60n)) + 440n)) + ((((ceil(((120n) - 5p) / (10u))) / 2) - floor((ceil(((120n) - 5p) / (10u))) / 2) != 0) ? ((2 * (50n > (((60n) - 0) + 60n) ? 50n : (((60n) - 0) + 60n))) + 340n) : 0)) / 1 : ((floor((ceil(((120n) - 5p) / (10u))) / 2.0) * ((2 * (60n > (((60n) - 0) + 50n) ? 60n : (((60n) - 0) + 50n))) + (2 * ((120n) / (ceil(((120n) - 5p) / (10u))))))) + ((((ceil(((120n) - 5p) / (10u))) / 2) - floor((ceil(((120n) - 5p) / (10u))) / 2) != 0) ? ((2 * (100n > (((60n) - 0) + 80n) ? 100n : (((60n) - 0) + 80n))) + (2 * ((120n) / (ceil(((120n) - 5p) / (10u)))))) : 0)) / 1           nrd=(((120n) / (ceil(((120n) - 5p) / (10u)))) < 119.5n) ? ((floor((ceil(((120n) - 5p) / (10u))) / 2.0) * (((((60n) - 0) + 60n) * 120n) + (((120n) / (ceil(((120n) - 5p) / (10u)))) * 100n))) + ((((ceil(((120n) - 5p) / (10u))) / 2) - floor((ceil(((120n) - 5p) / (10u))) / 2) != 0) ? (((50n > (((60n) - 0) + 60n) ? 50n : (((60n) - 0) + 60n)) * 120n) + (((120n) / (ceil(((120n) - 5p) / (10u)))) * 50n)) : 0)) / 1 : ((floor((ceil(((120n) - 5p) / (10u))) / 2.0) * ((60n > (((60n) - 0) + 50n) ? 60n : (((60n) - 0) + 50n)) * ((120n) / (ceil(((120n) - 5p) / (10u)))))) + ((((ceil(((120n) - 5p) / (10u))) / 2) - floor((ceil(((120n) - 5p) / (10u))) / 2) != 0) ? ((100n > (((60n) - 0) + 80n) ? 100n : (((60n) - 0) + 80n)) * ((120n) / (ceil(((120n) - 5p) / (10u))))) : 0)) / 1 / (((120n) / (ceil(((120n) - 5p) / (10u)))) * (ceil(((120n) - 5p) / (10u))) * ((120n) / (ceil(((120n) - 5p) / (10u)))) * (ceil(((120n) - 5p) / (10u))))           nrs=(((120n) / (ceil(((120n) - 5p) / (10u)))) < 119.5n) ? ((((50n > (((60n) - 0) + 60n) ? 50n : (((60n) - 0) + 60n)) * 120n) + (((120n) / (ceil(((120n) - 5p) / (10u)))) * 50n)) + (floor(((ceil(((120n) - 5p) / (10u))) - 1) / 2.0) * (((((60n) - 0) + 60n) * 120n) + (((120n) / (ceil(((120n) - 5p) / (10u)))) * 100n))) + ((((ceil(((120n) - 5p) / (10u))) / 2) - floor((ceil(((120n) - 5p) / (10u))) / 2) == 0) ? (((50n > (((60n) - 0) + 60n) ? 50n : (((60n) - 0) + 60n)) * 120n) + (((120n) / (ceil(((120n) - 5p) / (10u)))) * 50n)) : 0)) / 1 : (((100n > (((60n) - 0) + 80n) ? 100n : (((60n) - 0) + 80n)) * ((120n) / (ceil(((120n) - 5p) / (10u))))) + (floor(((ceil(((120n) - 5p) / (10u))) - 1) / 2.0) * ((60n > (((60n) - 0) + 50n) ? 60n : (((60n) - 0) + 50n)) * ((120n) / (ceil(((120n) - 5p) / (10u)))))) + ((((ceil(((120n) - 5p) / (10u))) / 2) - floor((ceil(((120n) - 5p) / (10u))) / 2) == 0) ? ((100n > (((60n) - 0) + 80n) ? 100n : (((60n) - 0) + 80n)) * ((120n) / (ceil(((120n) - 5p) / (10u))))) : 0)) / 1 / (((120n) / (ceil(((120n) - 5p) / (10u)))) * (ceil(((120n) - 5p) / (10u))) * ((120n) / (ceil(((120n) - 5p) / (10u)))) * (ceil(((120n) - 5p) / (10u))))           sa=(((120n) / (ceil(((120n) - 5p) / (10u)))) < 119.5n) ? (50n > (((60n) - 0) + 60n) ? 50n : (((60n) - 0) + 60n)) + 5e-08 : (100n > (((60n) - 0) + 80n) ? 100n : (((60n) - 0) + 80n))           sb=(((120n) / (ceil(((120n) - 5p) / (10u)))) < 119.5n) ? (50n > (((60n) - 0) + 60n) ? 50n : (((60n) - 0) + 60n)) + 5e-08 : (100n > (((60n) - 0) + 80n) ? 100n : (((60n) - 0) + 80n))           sd=(((120n) / (ceil(((120n) - 5p) / (10u)))) < 119.5n) ? (((60n) - 0) + 60n) + (2*5e-08) : (60n > (((60n) - 0) + 50n) ? 60n : (((60n) - 0) + 50n))           sca=(( ((120n) / (ceil(((120n) - 5p) / (10u)))) * ( (((1u) * (1u) / ((((120n) / (ceil(((120n) - 5p) / (10u)))) < 119.5n) ? (50n > (((60n) - 0) + 60n) ? 50n : (((60n) - 0) + 60n)) + 5e-08 : (100n > (((60n) - 0) + 80n) ? 100n : (((60n) - 0) + 80n))+60n)) - ((1u) * (1u) / (((((120n) / (ceil(((120n) - 5p) / (10u)))) < 119.5n) ? (50n > (((60n) - 0) + 60n) ? 50n : (((60n) - 0) + 60n)) + 5e-08 : (100n > (((60n) - 0) + 80n) ? 100n : (((60n) - 0) + 80n))+60n)+(45n)))) + ((1u) * (1u) / ((((120n) / (ceil(((120n) - 5p) / (10u)))) < 119.5n) ? (50n > (((60n) - 0) + 60n) ? 50n : (((60n) - 0) + 60n)) + 5e-08 : (100n > (((60n) - 0) + 80n) ? 100n : (((60n) - 0) + 80n))+60n)) - ((1u) * (1u)/ (((((120n) / (ceil(((120n) - 5p) / (10u)))) < 119.5n) ? (50n > (((60n) - 0) + 60n) ? 50n : (((60n) - 0) + 60n)) + 5e-08 : (100n > (((60n) - 0) + 80n) ? 100n : (((60n) - 0) + 80n))+60n)+(45n))))) + ( (45n) * ( (((1u) * (1u) / (60n)) - ((1u) * (1u) / ((60n)+((120n) / (ceil(((120n) - 5p) / (10u))))))) + ((1u) * (1u) / (60n)) - ((1u) * (1u)/ ((60n)+((120n) / (ceil(((120n) - 5p) / (10u))))))))) / (((120n) / (ceil(((120n) - 5p) / (10u)))) * (45n))           scb=((((120n) / (ceil(((120n) - 5p) / (10u)))) * ((((((120n) / (ceil(((120n) - 5p) / (10u)))) < 119.5n) ? (50n > (((60n) - 0) + 60n) ? 50n : (((60n) - 0) + 60n)) + 5e-08 : (100n > (((60n) - 0) + 80n) ? 100n : (((60n) - 0) + 80n))+60n)/10 + (1u)/100)*exp(-10 * ((((120n) / (ceil(((120n) - 5p) / (10u)))) < 119.5n) ? (50n > (((60n) - 0) + 60n) ? 50n : (((60n) - 0) + 60n)) + 5e-08 : (100n > (((60n) - 0) + 80n) ? 100n : (((60n) - 0) + 80n))+60n) / (1u)) - ((((((120n) / (ceil(((120n) - 5p) / (10u)))) < 119.5n) ? (50n > (((60n) - 0) + 60n) ? 50n : (((60n) - 0) + 60n)) + 5e-08 : (100n > (((60n) - 0) + 80n) ? 100n : (((60n) - 0) + 80n))+60n)+(45n))/10 + (1u)/100)*exp(-10 * (((((120n) / (ceil(((120n) - 5p) / (10u)))) < 119.5n) ? (50n > (((60n) - 0) + 60n) ? 50n : (((60n) - 0) + 60n)) + 5e-08 : (100n > (((60n) - 0) + 80n) ? 100n : (((60n) - 0) + 80n))+60n)+(45n)) / (1u)) + (((((120n) / (ceil(((120n) - 5p) / (10u)))) < 119.5n) ? (50n > (((60n) - 0) + 60n) ? 50n : (((60n) - 0) + 60n)) + 5e-08 : (100n > (((60n) - 0) + 80n) ? 100n : (((60n) - 0) + 80n))+60n)/10 + (1u)/100)*exp(-10 * ((((120n) / (ceil(((120n) - 5p) / (10u)))) < 119.5n) ? (50n > (((60n) - 0) + 60n) ? 50n : (((60n) - 0) + 60n)) + 5e-08 : (100n > (((60n) - 0) + 80n) ? 100n : (((60n) - 0) + 80n))+60n) / (1u)) - ((((((120n) / (ceil(((120n) - 5p) / (10u)))) < 119.5n) ? (50n > (((60n) - 0) + 60n) ? 50n : (((60n) - 0) + 60n)) + 5e-08 : (100n > (((60n) - 0) + 80n) ? 100n : (((60n) - 0) + 80n))+60n)+(45n))/10 + (1u)/100)*exp(-10 * (((((120n) / (ceil(((120n) - 5p) / (10u)))) < 119.5n) ? (50n > (((60n) - 0) + 60n) ? 50n : (((60n) - 0) + 60n)) + 5e-08 : (100n > (((60n) - 0) + 80n) ? 100n : (((60n) - 0) + 80n))+60n)+(45n)) / (1u)))) + ((45n) * (((60n)/10 + (1u)/100)*exp(-10 * (60n) / (1u)) - (((60n)+((120n) / (ceil(((120n) - 5p) / (10u)))))/10 + (1u)/100)*exp(-10 * ((60n)+((120n) / (ceil(((120n) - 5p) / (10u))))) / (1u)) + ((60n)/10 + (1u)/100)*exp(-10 * (60n) / (1u)) - (((60n)+((120n) / (ceil(((120n) - 5p) / (10u)))))/10 + (1u)/100)*exp(-10 * ((60n)+((120n) / (ceil(((120n) - 5p) / (10u))))) / (1u))))) / (((120n) / (ceil(((120n) - 5p) / (10u)))) * (45n))           scc=((((120n) / (ceil(((120n) - 5p) / (10u)))) * ((((((120n) / (ceil(((120n) - 5p) / (10u)))) < 119.5n) ? (50n > (((60n) - 0) + 60n) ? 50n : (((60n) - 0) + 60n)) + 5e-08 : (100n > (((60n) - 0) + 80n) ? 100n : (((60n) - 0) + 80n))+60n)/20 + (1u)/400)*exp(-20 * ((((120n) / (ceil(((120n) - 5p) / (10u)))) < 119.5n) ? (50n > (((60n) - 0) + 60n) ? 50n : (((60n) - 0) + 60n)) + 5e-08 : (100n > (((60n) - 0) + 80n) ? 100n : (((60n) - 0) + 80n))+60n) / (1u)) - ((((((120n) / (ceil(((120n) - 5p) / (10u)))) < 119.5n) ? (50n > (((60n) - 0) + 60n) ? 50n : (((60n) - 0) + 60n)) + 5e-08 : (100n > (((60n) - 0) + 80n) ? 100n : (((60n) - 0) + 80n))+60n)+(45n))/20 + (1u)/400)*exp(-20 * (((((120n) / (ceil(((120n) - 5p) / (10u)))) < 119.5n) ? (50n > (((60n) - 0) + 60n) ? 50n : (((60n) - 0) + 60n)) + 5e-08 : (100n > (((60n) - 0) + 80n) ? 100n : (((60n) - 0) + 80n))+60n)+(45n)) / (1u)) + (((((120n) / (ceil(((120n) - 5p) / (10u)))) < 119.5n) ? (50n > (((60n) - 0) + 60n) ? 50n : (((60n) - 0) + 60n)) + 5e-08 : (100n > (((60n) - 0) + 80n) ? 100n : (((60n) - 0) + 80n))+60n)/20 + (1u)/400)*exp(-20 * ((((120n) / (ceil(((120n) - 5p) / (10u)))) < 119.5n) ? (50n > (((60n) - 0) + 60n) ? 50n : (((60n) - 0) + 60n)) + 5e-08 : (100n > (((60n) - 0) + 80n) ? 100n : (((60n) - 0) + 80n))+60n) / (1u)) - ((((((120n) / (ceil(((120n) - 5p) / (10u)))) < 119.5n) ? (50n > (((60n) - 0) + 60n) ? 50n : (((60n) - 0) + 60n)) + 5e-08 : (100n > (((60n) - 0) + 80n) ? 100n : (((60n) - 0) + 80n))+60n)+(45n))/20 + (1u)/400)*exp(-20 * (((((120n) / (ceil(((120n) - 5p) / (10u)))) < 119.5n) ? (50n > (((60n) - 0) + 60n) ? 50n : (((60n) - 0) + 60n)) + 5e-08 : (100n > (((60n) - 0) + 80n) ? 100n : (((60n) - 0) + 80n))+60n)+(45n)) / (1u)))) + ((45n) * (((60n)/20 + (1u)/400)*exp(-20 * (60n) / (1u)) - (((60n)+((120n) / (ceil(((120n) - 5p) / (10u)))))/20 + (1u)/400)*exp(-20 * ((60n)+((120n) / (ceil(((120n) - 5p) / (10u))))) / (1u)) + ((60n)/20 + (1u)/400)*exp(-20 * (60n) / (1u)) - (((60n)+((120n) / (ceil(((120n) - 5p) / (10u)))))/20 + (1u)/400)*exp(-20 * ((60n)+((120n) / (ceil(((120n) - 5p) / (10u))))) / (1u))))) / (((120n) / (ceil(((120n) - 5p) / (10u)))) * (45n))           m=(1)
PVOUT2 (VOUT2 VIN Vdd Vdd) g45p1svt w=(240n) l=45n nf=ceil(((240n) - 5p) / (10u))           as=(((240n) / (ceil(((240n) - 5p) / (10u)))) < 119.5n) ? ((((50n > (((60n) - 0) + 60n) ? 50n : (((60n) - 0) + 60n)) * 120n) + (((240n) / (ceil(((240n) - 5p) / (10u)))) * 50n)) + (floor(((ceil(((240n) - 5p) / (10u))) - 1) / 2.0) * (((((60n) - 0) + 60n) * 120n) + (((240n) / (ceil(((240n) - 5p) / (10u)))) * 100n))) + ((((ceil(((240n) - 5p) / (10u))) / 2) - floor((ceil(((240n) - 5p) / (10u))) / 2) == 0) ? (((50n > (((60n) - 0) + 60n) ? 50n : (((60n) - 0) + 60n)) * 120n) + (((240n) / (ceil(((240n) - 5p) / (10u)))) * 50n)) : 0)) / 1 : (((100n > (((60n) - 0) + 80n) ? 100n : (((60n) - 0) + 80n)) * ((240n) / (ceil(((240n) - 5p) / (10u))))) + (floor(((ceil(((240n) - 5p) / (10u))) - 1) / 2.0) * ((60n > (((60n) - 0) + 50n) ? 60n : (((60n) - 0) + 50n)) * ((240n) / (ceil(((240n) - 5p) / (10u)))))) + ((((ceil(((240n) - 5p) / (10u))) / 2) - floor((ceil(((240n) - 5p) / (10u))) / 2) == 0) ? ((100n > (((60n) - 0) + 80n) ? 100n : (((60n) - 0) + 80n)) * ((240n) / (ceil(((240n) - 5p) / (10u))))) : 0)) / 1           ad=(((240n) / (ceil(((240n) - 5p) / (10u)))) < 119.5n) ? ((floor((ceil(((240n) - 5p) / (10u))) / 2.0) * (((((60n) - 0) + 60n) * 120n) + (((240n) / (ceil(((240n) - 5p) / (10u)))) * 100n))) + ((((ceil(((240n) - 5p) / (10u))) / 2) - floor((ceil(((240n) - 5p) / (10u))) / 2) != 0) ? (((50n > (((60n) - 0) + 60n) ? 50n : (((60n) - 0) + 60n)) * 120n) + (((240n) / (ceil(((240n) - 5p) / (10u)))) * 50n)) : 0)) / 1 : ((floor((ceil(((240n) - 5p) / (10u))) / 2.0) * ((60n > (((60n) - 0) + 50n) ? 60n : (((60n) - 0) + 50n)) * ((240n) / (ceil(((240n) - 5p) / (10u)))))) + ((((ceil(((240n) - 5p) / (10u))) / 2) - floor((ceil(((240n) - 5p) / (10u))) / 2) != 0) ? ((100n > (((60n) - 0) + 80n) ? 100n : (((60n) - 0) + 80n)) * ((240n) / (ceil(((240n) - 5p) / (10u))))) : 0)) / 1           ps=(((240n) / (ceil(((240n) - 5p) / (10u)))) < 119.5n) ? (((2 * (50n > (((60n) - 0) + 60n) ? 50n : (((60n) - 0) + 60n))) + 340n) + (floor(((ceil(((240n) - 5p) / (10u))) - 1) / 2.0) * ((2 * (((60n) - 0) + 60n)) + 440n)) + ((((ceil(((240n) - 5p) / (10u))) / 2) - floor((ceil(((240n) - 5p) / (10u))) / 2) == 0) ? ((2 * (50n > (((60n) - 0) + 60n) ? 50n : (((60n) - 0) + 60n))) + 340n) : 0)) / 1 : (((2 * (100n > (((60n) - 0) + 80n) ? 100n : (((60n) - 0) + 80n))) + (2 * ((240n) / (ceil(((240n) - 5p) / (10u)))))) + (floor(((ceil(((240n) - 5p) / (10u))) - 1) / 2.0) * ((2 * (60n > (((60n) - 0) + 50n) ? 60n : (((60n) - 0) + 50n))) + (2 * ((240n) / (ceil(((240n) - 5p) / (10u))))))) + ((((ceil(((240n) - 5p) / (10u))) / 2) - floor((ceil(((240n) - 5p) / (10u))) / 2) == 0) ? ((2 * (100n > (((60n) - 0) + 80n) ? 100n : (((60n) - 0) + 80n))) + (2 * ((240n) / (ceil(((240n) - 5p) / (10u)))))) : 0)) / 1           pd=(((240n) / (ceil(((240n) - 5p) / (10u)))) < 119.5n) ? ((floor((ceil(((240n) - 5p) / (10u))) / 2.0) * ((2 * (((60n) - 0) + 60n)) + 440n)) + ((((ceil(((240n) - 5p) / (10u))) / 2) - floor((ceil(((240n) - 5p) / (10u))) / 2) != 0) ? ((2 * (50n > (((60n) - 0) + 60n) ? 50n : (((60n) - 0) + 60n))) + 340n) : 0)) / 1 : ((floor((ceil(((240n) - 5p) / (10u))) / 2.0) * ((2 * (60n > (((60n) - 0) + 50n) ? 60n : (((60n) - 0) + 50n))) + (2 * ((240n) / (ceil(((240n) - 5p) / (10u))))))) + ((((ceil(((240n) - 5p) / (10u))) / 2) - floor((ceil(((240n) - 5p) / (10u))) / 2) != 0) ? ((2 * (100n > (((60n) - 0) + 80n) ? 100n : (((60n) - 0) + 80n))) + (2 * ((240n) / (ceil(((240n) - 5p) / (10u)))))) : 0)) / 1           nrd=(((240n) / (ceil(((240n) - 5p) / (10u)))) < 119.5n) ? ((floor((ceil(((240n) - 5p) / (10u))) / 2.0) * (((((60n) - 0) + 60n) * 120n) + (((240n) / (ceil(((240n) - 5p) / (10u)))) * 100n))) + ((((ceil(((240n) - 5p) / (10u))) / 2) - floor((ceil(((240n) - 5p) / (10u))) / 2) != 0) ? (((50n > (((60n) - 0) + 60n) ? 50n : (((60n) - 0) + 60n)) * 120n) + (((240n) / (ceil(((240n) - 5p) / (10u)))) * 50n)) : 0)) / 1 : ((floor((ceil(((240n) - 5p) / (10u))) / 2.0) * ((60n > (((60n) - 0) + 50n) ? 60n : (((60n) - 0) + 50n)) * ((240n) / (ceil(((240n) - 5p) / (10u)))))) + ((((ceil(((240n) - 5p) / (10u))) / 2) - floor((ceil(((240n) - 5p) / (10u))) / 2) != 0) ? ((100n > (((60n) - 0) + 80n) ? 100n : (((60n) - 0) + 80n)) * ((240n) / (ceil(((240n) - 5p) / (10u))))) : 0)) / 1 / (((240n) / (ceil(((240n) - 5p) / (10u)))) * (ceil(((240n) - 5p) / (10u))) * ((240n) / (ceil(((240n) - 5p) / (10u)))) * (ceil(((240n) - 5p) / (10u))))           nrs=(((240n) / (ceil(((240n) - 5p) / (10u)))) < 119.5n) ? ((((50n > (((60n) - 0) + 60n) ? 50n : (((60n) - 0) + 60n)) * 120n) + (((240n) / (ceil(((240n) - 5p) / (10u)))) * 50n)) + (floor(((ceil(((240n) - 5p) / (10u))) - 1) / 2.0) * (((((60n) - 0) + 60n) * 120n) + (((240n) / (ceil(((240n) - 5p) / (10u)))) * 100n))) + ((((ceil(((240n) - 5p) / (10u))) / 2) - floor((ceil(((240n) - 5p) / (10u))) / 2) == 0) ? (((50n > (((60n) - 0) + 60n) ? 50n : (((60n) - 0) + 60n)) * 120n) + (((240n) / (ceil(((240n) - 5p) / (10u)))) * 50n)) : 0)) / 1 : (((100n > (((60n) - 0) + 80n) ? 100n : (((60n) - 0) + 80n)) * ((240n) / (ceil(((240n) - 5p) / (10u))))) + (floor(((ceil(((240n) - 5p) / (10u))) - 1) / 2.0) * ((60n > (((60n) - 0) + 50n) ? 60n : (((60n) - 0) + 50n)) * ((240n) / (ceil(((240n) - 5p) / (10u)))))) + ((((ceil(((240n) - 5p) / (10u))) / 2) - floor((ceil(((240n) - 5p) / (10u))) / 2) == 0) ? ((100n > (((60n) - 0) + 80n) ? 100n : (((60n) - 0) + 80n)) * ((240n) / (ceil(((240n) - 5p) / (10u))))) : 0)) / 1 / (((240n) / (ceil(((240n) - 5p) / (10u)))) * (ceil(((240n) - 5p) / (10u))) * ((240n) / (ceil(((240n) - 5p) / (10u)))) * (ceil(((240n) - 5p) / (10u))))           sa=(((240n) / (ceil(((240n) - 5p) / (10u)))) < 119.5n) ? (50n > (((60n) - 0) + 60n) ? 50n : (((60n) - 0) + 60n)) + 5e-08 : (100n > (((60n) - 0) + 80n) ? 100n : (((60n) - 0) + 80n))           sb=(((240n) / (ceil(((240n) - 5p) / (10u)))) < 119.5n) ? (50n > (((60n) - 0) + 60n) ? 50n : (((60n) - 0) + 60n)) + 5e-08 : (100n > (((60n) - 0) + 80n) ? 100n : (((60n) - 0) + 80n))           sd=(((240n) / (ceil(((240n) - 5p) / (10u)))) < 119.5n) ? (((60n) - 0) + 60n) + (2*5e-08) : (60n > (((60n) - 0) + 50n) ? 60n : (((60n) - 0) + 50n))           sca=(( ((240n) / (ceil(((240n) - 5p) / (10u)))) * ( (((1u) * (1u) / ((((240n) / (ceil(((240n) - 5p) / (10u)))) < 119.5n) ? (50n > (((60n) - 0) + 60n) ? 50n : (((60n) - 0) + 60n)) + 5e-08 : (100n > (((60n) - 0) + 80n) ? 100n : (((60n) - 0) + 80n))+60n)) - ((1u) * (1u) / (((((240n) / (ceil(((240n) - 5p) / (10u)))) < 119.5n) ? (50n > (((60n) - 0) + 60n) ? 50n : (((60n) - 0) + 60n)) + 5e-08 : (100n > (((60n) - 0) + 80n) ? 100n : (((60n) - 0) + 80n))+60n)+(45n)))) + ((1u) * (1u) / ((((240n) / (ceil(((240n) - 5p) / (10u)))) < 119.5n) ? (50n > (((60n) - 0) + 60n) ? 50n : (((60n) - 0) + 60n)) + 5e-08 : (100n > (((60n) - 0) + 80n) ? 100n : (((60n) - 0) + 80n))+60n)) - ((1u) * (1u)/ (((((240n) / (ceil(((240n) - 5p) / (10u)))) < 119.5n) ? (50n > (((60n) - 0) + 60n) ? 50n : (((60n) - 0) + 60n)) + 5e-08 : (100n > (((60n) - 0) + 80n) ? 100n : (((60n) - 0) + 80n))+60n)+(45n))))) + ( (45n) * ( (((1u) * (1u) / (60n)) - ((1u) * (1u) / ((60n)+((240n) / (ceil(((240n) - 5p) / (10u))))))) + ((1u) * (1u) / (60n)) - ((1u) * (1u)/ ((60n)+((240n) / (ceil(((240n) - 5p) / (10u))))))))) / (((240n) / (ceil(((240n) - 5p) / (10u)))) * (45n))           scb=((((240n) / (ceil(((240n) - 5p) / (10u)))) * ((((((240n) / (ceil(((240n) - 5p) / (10u)))) < 119.5n) ? (50n > (((60n) - 0) + 60n) ? 50n : (((60n) - 0) + 60n)) + 5e-08 : (100n > (((60n) - 0) + 80n) ? 100n : (((60n) - 0) + 80n))+60n)/10 + (1u)/100)*exp(-10 * ((((240n) / (ceil(((240n) - 5p) / (10u)))) < 119.5n) ? (50n > (((60n) - 0) + 60n) ? 50n : (((60n) - 0) + 60n)) + 5e-08 : (100n > (((60n) - 0) + 80n) ? 100n : (((60n) - 0) + 80n))+60n) / (1u)) - ((((((240n) / (ceil(((240n) - 5p) / (10u)))) < 119.5n) ? (50n > (((60n) - 0) + 60n) ? 50n : (((60n) - 0) + 60n)) + 5e-08 : (100n > (((60n) - 0) + 80n) ? 100n : (((60n) - 0) + 80n))+60n)+(45n))/10 + (1u)/100)*exp(-10 * (((((240n) / (ceil(((240n) - 5p) / (10u)))) < 119.5n) ? (50n > (((60n) - 0) + 60n) ? 50n : (((60n) - 0) + 60n)) + 5e-08 : (100n > (((60n) - 0) + 80n) ? 100n : (((60n) - 0) + 80n))+60n)+(45n)) / (1u)) + (((((240n) / (ceil(((240n) - 5p) / (10u)))) < 119.5n) ? (50n > (((60n) - 0) + 60n) ? 50n : (((60n) - 0) + 60n)) + 5e-08 : (100n > (((60n) - 0) + 80n) ? 100n : (((60n) - 0) + 80n))+60n)/10 + (1u)/100)*exp(-10 * ((((240n) / (ceil(((240n) - 5p) / (10u)))) < 119.5n) ? (50n > (((60n) - 0) + 60n) ? 50n : (((60n) - 0) + 60n)) + 5e-08 : (100n > (((60n) - 0) + 80n) ? 100n : (((60n) - 0) + 80n))+60n) / (1u)) - ((((((240n) / (ceil(((240n) - 5p) / (10u)))) < 119.5n) ? (50n > (((60n) - 0) + 60n) ? 50n : (((60n) - 0) + 60n)) + 5e-08 : (100n > (((60n) - 0) + 80n) ? 100n : (((60n) - 0) + 80n))+60n)+(45n))/10 + (1u)/100)*exp(-10 * (((((240n) / (ceil(((240n) - 5p) / (10u)))) < 119.5n) ? (50n > (((60n) - 0) + 60n) ? 50n : (((60n) - 0) + 60n)) + 5e-08 : (100n > (((60n) - 0) + 80n) ? 100n : (((60n) - 0) + 80n))+60n)+(45n)) / (1u)))) + ((45n) * (((60n)/10 + (1u)/100)*exp(-10 * (60n) / (1u)) - (((60n)+((240n) / (ceil(((240n) - 5p) / (10u)))))/10 + (1u)/100)*exp(-10 * ((60n)+((240n) / (ceil(((240n) - 5p) / (10u))))) / (1u)) + ((60n)/10 + (1u)/100)*exp(-10 * (60n) / (1u)) - (((60n)+((240n) / (ceil(((240n) - 5p) / (10u)))))/10 + (1u)/100)*exp(-10 * ((60n)+((240n) / (ceil(((240n) - 5p) / (10u))))) / (1u))))) / (((240n) / (ceil(((240n) - 5p) / (10u)))) * (45n))           scc=((((240n) / (ceil(((240n) - 5p) / (10u)))) * ((((((240n) / (ceil(((240n) - 5p) / (10u)))) < 119.5n) ? (50n > (((60n) - 0) + 60n) ? 50n : (((60n) - 0) + 60n)) + 5e-08 : (100n > (((60n) - 0) + 80n) ? 100n : (((60n) - 0) + 80n))+60n)/20 + (1u)/400)*exp(-20 * ((((240n) / (ceil(((240n) - 5p) / (10u)))) < 119.5n) ? (50n > (((60n) - 0) + 60n) ? 50n : (((60n) - 0) + 60n)) + 5e-08 : (100n > (((60n) - 0) + 80n) ? 100n : (((60n) - 0) + 80n))+60n) / (1u)) - ((((((240n) / (ceil(((240n) - 5p) / (10u)))) < 119.5n) ? (50n > (((60n) - 0) + 60n) ? 50n : (((60n) - 0) + 60n)) + 5e-08 : (100n > (((60n) - 0) + 80n) ? 100n : (((60n) - 0) + 80n))+60n)+(45n))/20 + (1u)/400)*exp(-20 * (((((240n) / (ceil(((240n) - 5p) / (10u)))) < 119.5n) ? (50n > (((60n) - 0) + 60n) ? 50n : (((60n) - 0) + 60n)) + 5e-08 : (100n > (((60n) - 0) + 80n) ? 100n : (((60n) - 0) + 80n))+60n)+(45n)) / (1u)) + (((((240n) / (ceil(((240n) - 5p) / (10u)))) < 119.5n) ? (50n > (((60n) - 0) + 60n) ? 50n : (((60n) - 0) + 60n)) + 5e-08 : (100n > (((60n) - 0) + 80n) ? 100n : (((60n) - 0) + 80n))+60n)/20 + (1u)/400)*exp(-20 * ((((240n) / (ceil(((240n) - 5p) / (10u)))) < 119.5n) ? (50n > (((60n) - 0) + 60n) ? 50n : (((60n) - 0) + 60n)) + 5e-08 : (100n > (((60n) - 0) + 80n) ? 100n : (((60n) - 0) + 80n))+60n) / (1u)) - ((((((240n) / (ceil(((240n) - 5p) / (10u)))) < 119.5n) ? (50n > (((60n) - 0) + 60n) ? 50n : (((60n) - 0) + 60n)) + 5e-08 : (100n > (((60n) - 0) + 80n) ? 100n : (((60n) - 0) + 80n))+60n)+(45n))/20 + (1u)/400)*exp(-20 * (((((240n) / (ceil(((240n) - 5p) / (10u)))) < 119.5n) ? (50n > (((60n) - 0) + 60n) ? 50n : (((60n) - 0) + 60n)) + 5e-08 : (100n > (((60n) - 0) + 80n) ? 100n : (((60n) - 0) + 80n))+60n)+(45n)) / (1u)))) + ((45n) * (((60n)/20 + (1u)/400)*exp(-20 * (60n) / (1u)) - (((60n)+((240n) / (ceil(((240n) - 5p) / (10u)))))/20 + (1u)/400)*exp(-20 * ((60n)+((240n) / (ceil(((240n) - 5p) / (10u))))) / (1u)) + ((60n)/20 + (1u)/400)*exp(-20 * (60n) / (1u)) - (((60n)+((240n) / (ceil(((240n) - 5p) / (10u)))))/20 + (1u)/400)*exp(-20 * ((60n)+((240n) / (ceil(((240n) - 5p) / (10u))))) / (1u))))) / (((240n) / (ceil(((240n) - 5p) / (10u)))) * (45n))           m=(1)
NVOUT2 (VOUT2 VIN 0 0) g45n1svt w=(120n) l=45n nf=ceil(((120n) - 5p) / (10u))           as=(((120n) / (ceil(((120n) - 5p) / (10u)))) < 119.5n) ? ((((50n > (((60n) - 0) + 60n) ? 50n : (((60n) - 0) + 60n)) * 120n) + (((120n) / (ceil(((120n) - 5p) / (10u)))) * 50n)) + (floor(((ceil(((120n) - 5p) / (10u))) - 1) / 2.0) * (((((60n) - 0) + 60n) * 120n) + (((120n) / (ceil(((120n) - 5p) / (10u)))) * 100n))) + ((((ceil(((120n) - 5p) / (10u))) / 2) - floor((ceil(((120n) - 5p) / (10u))) / 2) == 0) ? (((50n > (((60n) - 0) + 60n) ? 50n : (((60n) - 0) + 60n)) * 120n) + (((120n) / (ceil(((120n) - 5p) / (10u)))) * 50n)) : 0)) / 1 : (((100n > (((60n) - 0) + 80n) ? 100n : (((60n) - 0) + 80n)) * ((120n) / (ceil(((120n) - 5p) / (10u))))) + (floor(((ceil(((120n) - 5p) / (10u))) - 1) / 2.0) * ((60n > (((60n) - 0) + 50n) ? 60n : (((60n) - 0) + 50n)) * ((120n) / (ceil(((120n) - 5p) / (10u)))))) + ((((ceil(((120n) - 5p) / (10u))) / 2) - floor((ceil(((120n) - 5p) / (10u))) / 2) == 0) ? ((100n > (((60n) - 0) + 80n) ? 100n : (((60n) - 0) + 80n)) * ((120n) / (ceil(((120n) - 5p) / (10u))))) : 0)) / 1           ad=(((120n) / (ceil(((120n) - 5p) / (10u)))) < 119.5n) ? ((floor((ceil(((120n) - 5p) / (10u))) / 2.0) * (((((60n) - 0) + 60n) * 120n) + (((120n) / (ceil(((120n) - 5p) / (10u)))) * 100n))) + ((((ceil(((120n) - 5p) / (10u))) / 2) - floor((ceil(((120n) - 5p) / (10u))) / 2) != 0) ? (((50n > (((60n) - 0) + 60n) ? 50n : (((60n) - 0) + 60n)) * 120n) + (((120n) / (ceil(((120n) - 5p) / (10u)))) * 50n)) : 0)) / 1 : ((floor((ceil(((120n) - 5p) / (10u))) / 2.0) * ((60n > (((60n) - 0) + 50n) ? 60n : (((60n) - 0) + 50n)) * ((120n) / (ceil(((120n) - 5p) / (10u)))))) + ((((ceil(((120n) - 5p) / (10u))) / 2) - floor((ceil(((120n) - 5p) / (10u))) / 2) != 0) ? ((100n > (((60n) - 0) + 80n) ? 100n : (((60n) - 0) + 80n)) * ((120n) / (ceil(((120n) - 5p) / (10u))))) : 0)) / 1           ps=(((120n) / (ceil(((120n) - 5p) / (10u)))) < 119.5n) ? (((2 * (50n > (((60n) - 0) + 60n) ? 50n : (((60n) - 0) + 60n))) + 340n) + (floor(((ceil(((120n) - 5p) / (10u))) - 1) / 2.0) * ((2 * (((60n) - 0) + 60n)) + 440n)) + ((((ceil(((120n) - 5p) / (10u))) / 2) - floor((ceil(((120n) - 5p) / (10u))) / 2) == 0) ? ((2 * (50n > (((60n) - 0) + 60n) ? 50n : (((60n) - 0) + 60n))) + 340n) : 0)) / 1 : (((2 * (100n > (((60n) - 0) + 80n) ? 100n : (((60n) - 0) + 80n))) + (2 * ((120n) / (ceil(((120n) - 5p) / (10u)))))) + (floor(((ceil(((120n) - 5p) / (10u))) - 1) / 2.0) * ((2 * (60n > (((60n) - 0) + 50n) ? 60n : (((60n) - 0) + 50n))) + (2 * ((120n) / (ceil(((120n) - 5p) / (10u))))))) + ((((ceil(((120n) - 5p) / (10u))) / 2) - floor((ceil(((120n) - 5p) / (10u))) / 2) == 0) ? ((2 * (100n > (((60n) - 0) + 80n) ? 100n : (((60n) - 0) + 80n))) + (2 * ((120n) / (ceil(((120n) - 5p) / (10u)))))) : 0)) / 1           pd=(((120n) / (ceil(((120n) - 5p) / (10u)))) < 119.5n) ? ((floor((ceil(((120n) - 5p) / (10u))) / 2.0) * ((2 * (((60n) - 0) + 60n)) + 440n)) + ((((ceil(((120n) - 5p) / (10u))) / 2) - floor((ceil(((120n) - 5p) / (10u))) / 2) != 0) ? ((2 * (50n > (((60n) - 0) + 60n) ? 50n : (((60n) - 0) + 60n))) + 340n) : 0)) / 1 : ((floor((ceil(((120n) - 5p) / (10u))) / 2.0) * ((2 * (60n > (((60n) - 0) + 50n) ? 60n : (((60n) - 0) + 50n))) + (2 * ((120n) / (ceil(((120n) - 5p) / (10u))))))) + ((((ceil(((120n) - 5p) / (10u))) / 2) - floor((ceil(((120n) - 5p) / (10u))) / 2) != 0) ? ((2 * (100n > (((60n) - 0) + 80n) ? 100n : (((60n) - 0) + 80n))) + (2 * ((120n) / (ceil(((120n) - 5p) / (10u)))))) : 0)) / 1           nrd=(((120n) / (ceil(((120n) - 5p) / (10u)))) < 119.5n) ? ((floor((ceil(((120n) - 5p) / (10u))) / 2.0) * (((((60n) - 0) + 60n) * 120n) + (((120n) / (ceil(((120n) - 5p) / (10u)))) * 100n))) + ((((ceil(((120n) - 5p) / (10u))) / 2) - floor((ceil(((120n) - 5p) / (10u))) / 2) != 0) ? (((50n > (((60n) - 0) + 60n) ? 50n : (((60n) - 0) + 60n)) * 120n) + (((120n) / (ceil(((120n) - 5p) / (10u)))) * 50n)) : 0)) / 1 : ((floor((ceil(((120n) - 5p) / (10u))) / 2.0) * ((60n > (((60n) - 0) + 50n) ? 60n : (((60n) - 0) + 50n)) * ((120n) / (ceil(((120n) - 5p) / (10u)))))) + ((((ceil(((120n) - 5p) / (10u))) / 2) - floor((ceil(((120n) - 5p) / (10u))) / 2) != 0) ? ((100n > (((60n) - 0) + 80n) ? 100n : (((60n) - 0) + 80n)) * ((120n) / (ceil(((120n) - 5p) / (10u))))) : 0)) / 1 / (((120n) / (ceil(((120n) - 5p) / (10u)))) * (ceil(((120n) - 5p) / (10u))) * ((120n) / (ceil(((120n) - 5p) / (10u)))) * (ceil(((120n) - 5p) / (10u))))           nrs=(((120n) / (ceil(((120n) - 5p) / (10u)))) < 119.5n) ? ((((50n > (((60n) - 0) + 60n) ? 50n : (((60n) - 0) + 60n)) * 120n) + (((120n) / (ceil(((120n) - 5p) / (10u)))) * 50n)) + (floor(((ceil(((120n) - 5p) / (10u))) - 1) / 2.0) * (((((60n) - 0) + 60n) * 120n) + (((120n) / (ceil(((120n) - 5p) / (10u)))) * 100n))) + ((((ceil(((120n) - 5p) / (10u))) / 2) - floor((ceil(((120n) - 5p) / (10u))) / 2) == 0) ? (((50n > (((60n) - 0) + 60n) ? 50n : (((60n) - 0) + 60n)) * 120n) + (((120n) / (ceil(((120n) - 5p) / (10u)))) * 50n)) : 0)) / 1 : (((100n > (((60n) - 0) + 80n) ? 100n : (((60n) - 0) + 80n)) * ((120n) / (ceil(((120n) - 5p) / (10u))))) + (floor(((ceil(((120n) - 5p) / (10u))) - 1) / 2.0) * ((60n > (((60n) - 0) + 50n) ? 60n : (((60n) - 0) + 50n)) * ((120n) / (ceil(((120n) - 5p) / (10u)))))) + ((((ceil(((120n) - 5p) / (10u))) / 2) - floor((ceil(((120n) - 5p) / (10u))) / 2) == 0) ? ((100n > (((60n) - 0) + 80n) ? 100n : (((60n) - 0) + 80n)) * ((120n) / (ceil(((120n) - 5p) / (10u))))) : 0)) / 1 / (((120n) / (ceil(((120n) - 5p) / (10u)))) * (ceil(((120n) - 5p) / (10u))) * ((120n) / (ceil(((120n) - 5p) / (10u)))) * (ceil(((120n) - 5p) / (10u))))           sa=(((120n) / (ceil(((120n) - 5p) / (10u)))) < 119.5n) ? (50n > (((60n) - 0) + 60n) ? 50n : (((60n) - 0) + 60n)) + 5e-08 : (100n > (((60n) - 0) + 80n) ? 100n : (((60n) - 0) + 80n))           sb=(((120n) / (ceil(((120n) - 5p) / (10u)))) < 119.5n) ? (50n > (((60n) - 0) + 60n) ? 50n : (((60n) - 0) + 60n)) + 5e-08 : (100n > (((60n) - 0) + 80n) ? 100n : (((60n) - 0) + 80n))           sd=(((120n) / (ceil(((120n) - 5p) / (10u)))) < 119.5n) ? (((60n) - 0) + 60n) + (2*5e-08) : (60n > (((60n) - 0) + 50n) ? 60n : (((60n) - 0) + 50n))           sca=(( ((120n) / (ceil(((120n) - 5p) / (10u)))) * ( (((1u) * (1u) / ((((120n) / (ceil(((120n) - 5p) / (10u)))) < 119.5n) ? (50n > (((60n) - 0) + 60n) ? 50n : (((60n) - 0) + 60n)) + 5e-08 : (100n > (((60n) - 0) + 80n) ? 100n : (((60n) - 0) + 80n))+60n)) - ((1u) * (1u) / (((((120n) / (ceil(((120n) - 5p) / (10u)))) < 119.5n) ? (50n > (((60n) - 0) + 60n) ? 50n : (((60n) - 0) + 60n)) + 5e-08 : (100n > (((60n) - 0) + 80n) ? 100n : (((60n) - 0) + 80n))+60n)+(45n)))) + ((1u) * (1u) / ((((120n) / (ceil(((120n) - 5p) / (10u)))) < 119.5n) ? (50n > (((60n) - 0) + 60n) ? 50n : (((60n) - 0) + 60n)) + 5e-08 : (100n > (((60n) - 0) + 80n) ? 100n : (((60n) - 0) + 80n))+60n)) - ((1u) * (1u)/ (((((120n) / (ceil(((120n) - 5p) / (10u)))) < 119.5n) ? (50n > (((60n) - 0) + 60n) ? 50n : (((60n) - 0) + 60n)) + 5e-08 : (100n > (((60n) - 0) + 80n) ? 100n : (((60n) - 0) + 80n))+60n)+(45n))))) + ( (45n) * ( (((1u) * (1u) / (60n)) - ((1u) * (1u) / ((60n)+((120n) / (ceil(((120n) - 5p) / (10u))))))) + ((1u) * (1u) / (60n)) - ((1u) * (1u)/ ((60n)+((120n) / (ceil(((120n) - 5p) / (10u))))))))) / (((120n) / (ceil(((120n) - 5p) / (10u)))) * (45n))           scb=((((120n) / (ceil(((120n) - 5p) / (10u)))) * ((((((120n) / (ceil(((120n) - 5p) / (10u)))) < 119.5n) ? (50n > (((60n) - 0) + 60n) ? 50n : (((60n) - 0) + 60n)) + 5e-08 : (100n > (((60n) - 0) + 80n) ? 100n : (((60n) - 0) + 80n))+60n)/10 + (1u)/100)*exp(-10 * ((((120n) / (ceil(((120n) - 5p) / (10u)))) < 119.5n) ? (50n > (((60n) - 0) + 60n) ? 50n : (((60n) - 0) + 60n)) + 5e-08 : (100n > (((60n) - 0) + 80n) ? 100n : (((60n) - 0) + 80n))+60n) / (1u)) - ((((((120n) / (ceil(((120n) - 5p) / (10u)))) < 119.5n) ? (50n > (((60n) - 0) + 60n) ? 50n : (((60n) - 0) + 60n)) + 5e-08 : (100n > (((60n) - 0) + 80n) ? 100n : (((60n) - 0) + 80n))+60n)+(45n))/10 + (1u)/100)*exp(-10 * (((((120n) / (ceil(((120n) - 5p) / (10u)))) < 119.5n) ? (50n > (((60n) - 0) + 60n) ? 50n : (((60n) - 0) + 60n)) + 5e-08 : (100n > (((60n) - 0) + 80n) ? 100n : (((60n) - 0) + 80n))+60n)+(45n)) / (1u)) + (((((120n) / (ceil(((120n) - 5p) / (10u)))) < 119.5n) ? (50n > (((60n) - 0) + 60n) ? 50n : (((60n) - 0) + 60n)) + 5e-08 : (100n > (((60n) - 0) + 80n) ? 100n : (((60n) - 0) + 80n))+60n)/10 + (1u)/100)*exp(-10 * ((((120n) / (ceil(((120n) - 5p) / (10u)))) < 119.5n) ? (50n > (((60n) - 0) + 60n) ? 50n : (((60n) - 0) + 60n)) + 5e-08 : (100n > (((60n) - 0) + 80n) ? 100n : (((60n) - 0) + 80n))+60n) / (1u)) - ((((((120n) / (ceil(((120n) - 5p) / (10u)))) < 119.5n) ? (50n > (((60n) - 0) + 60n) ? 50n : (((60n) - 0) + 60n)) + 5e-08 : (100n > (((60n) - 0) + 80n) ? 100n : (((60n) - 0) + 80n))+60n)+(45n))/10 + (1u)/100)*exp(-10 * (((((120n) / (ceil(((120n) - 5p) / (10u)))) < 119.5n) ? (50n > (((60n) - 0) + 60n) ? 50n : (((60n) - 0) + 60n)) + 5e-08 : (100n > (((60n) - 0) + 80n) ? 100n : (((60n) - 0) + 80n))+60n)+(45n)) / (1u)))) + ((45n) * (((60n)/10 + (1u)/100)*exp(-10 * (60n) / (1u)) - (((60n)+((120n) / (ceil(((120n) - 5p) / (10u)))))/10 + (1u)/100)*exp(-10 * ((60n)+((120n) / (ceil(((120n) - 5p) / (10u))))) / (1u)) + ((60n)/10 + (1u)/100)*exp(-10 * (60n) / (1u)) - (((60n)+((120n) / (ceil(((120n) - 5p) / (10u)))))/10 + (1u)/100)*exp(-10 * ((60n)+((120n) / (ceil(((120n) - 5p) / (10u))))) / (1u))))) / (((120n) / (ceil(((120n) - 5p) / (10u)))) * (45n))           scc=((((120n) / (ceil(((120n) - 5p) / (10u)))) * ((((((120n) / (ceil(((120n) - 5p) / (10u)))) < 119.5n) ? (50n > (((60n) - 0) + 60n) ? 50n : (((60n) - 0) + 60n)) + 5e-08 : (100n > (((60n) - 0) + 80n) ? 100n : (((60n) - 0) + 80n))+60n)/20 + (1u)/400)*exp(-20 * ((((120n) / (ceil(((120n) - 5p) / (10u)))) < 119.5n) ? (50n > (((60n) - 0) + 60n) ? 50n : (((60n) - 0) + 60n)) + 5e-08 : (100n > (((60n) - 0) + 80n) ? 100n : (((60n) - 0) + 80n))+60n) / (1u)) - ((((((120n) / (ceil(((120n) - 5p) / (10u)))) < 119.5n) ? (50n > (((60n) - 0) + 60n) ? 50n : (((60n) - 0) + 60n)) + 5e-08 : (100n > (((60n) - 0) + 80n) ? 100n : (((60n) - 0) + 80n))+60n)+(45n))/20 + (1u)/400)*exp(-20 * (((((120n) / (ceil(((120n) - 5p) / (10u)))) < 119.5n) ? (50n > (((60n) - 0) + 60n) ? 50n : (((60n) - 0) + 60n)) + 5e-08 : (100n > (((60n) - 0) + 80n) ? 100n : (((60n) - 0) + 80n))+60n)+(45n)) / (1u)) + (((((120n) / (ceil(((120n) - 5p) / (10u)))) < 119.5n) ? (50n > (((60n) - 0) + 60n) ? 50n : (((60n) - 0) + 60n)) + 5e-08 : (100n > (((60n) - 0) + 80n) ? 100n : (((60n) - 0) + 80n))+60n)/20 + (1u)/400)*exp(-20 * ((((120n) / (ceil(((120n) - 5p) / (10u)))) < 119.5n) ? (50n > (((60n) - 0) + 60n) ? 50n : (((60n) - 0) + 60n)) + 5e-08 : (100n > (((60n) - 0) + 80n) ? 100n : (((60n) - 0) + 80n))+60n) / (1u)) - ((((((120n) / (ceil(((120n) - 5p) / (10u)))) < 119.5n) ? (50n > (((60n) - 0) + 60n) ? 50n : (((60n) - 0) + 60n)) + 5e-08 : (100n > (((60n) - 0) + 80n) ? 100n : (((60n) - 0) + 80n))+60n)+(45n))/20 + (1u)/400)*exp(-20 * (((((120n) / (ceil(((120n) - 5p) / (10u)))) < 119.5n) ? (50n > (((60n) - 0) + 60n) ? 50n : (((60n) - 0) + 60n)) + 5e-08 : (100n > (((60n) - 0) + 80n) ? 100n : (((60n) - 0) + 80n))+60n)+(45n)) / (1u)))) + ((45n) * (((60n)/20 + (1u)/400)*exp(-20 * (60n) / (1u)) - (((60n)+((120n) / (ceil(((120n) - 5p) / (10u)))))/20 + (1u)/400)*exp(-20 * ((60n)+((120n) / (ceil(((120n) - 5p) / (10u))))) / (1u)) + ((60n)/20 + (1u)/400)*exp(-20 * (60n) / (1u)) - (((60n)+((120n) / (ceil(((120n) - 5p) / (10u)))))/20 + (1u)/400)*exp(-20 * ((60n)+((120n) / (ceil(((120n) - 5p) / (10u))))) / (1u))))) / (((120n) / (ceil(((120n) - 5p) / (10u)))) * (45n))           m=(1)
AVOUT2 (VOUT2 Vdd 0 0) g45n1svt w=(120n) l=45n nf=ceil(((120n) - 5p) / (10u))           as=(((120n) / (ceil(((120n) - 5p) / (10u)))) < 119.5n) ? ((((50n > (((60n) - 0) + 60n) ? 50n : (((60n) - 0) + 60n)) * 120n) + (((120n) / (ceil(((120n) - 5p) / (10u)))) * 50n)) + (floor(((ceil(((120n) - 5p) / (10u))) - 1) / 2.0) * (((((60n) - 0) + 60n) * 120n) + (((120n) / (ceil(((120n) - 5p) / (10u)))) * 100n))) + ((((ceil(((120n) - 5p) / (10u))) / 2) - floor((ceil(((120n) - 5p) / (10u))) / 2) == 0) ? (((50n > (((60n) - 0) + 60n) ? 50n : (((60n) - 0) + 60n)) * 120n) + (((120n) / (ceil(((120n) - 5p) / (10u)))) * 50n)) : 0)) / 1 : (((100n > (((60n) - 0) + 80n) ? 100n : (((60n) - 0) + 80n)) * ((120n) / (ceil(((120n) - 5p) / (10u))))) + (floor(((ceil(((120n) - 5p) / (10u))) - 1) / 2.0) * ((60n > (((60n) - 0) + 50n) ? 60n : (((60n) - 0) + 50n)) * ((120n) / (ceil(((120n) - 5p) / (10u)))))) + ((((ceil(((120n) - 5p) / (10u))) / 2) - floor((ceil(((120n) - 5p) / (10u))) / 2) == 0) ? ((100n > (((60n) - 0) + 80n) ? 100n : (((60n) - 0) + 80n)) * ((120n) / (ceil(((120n) - 5p) / (10u))))) : 0)) / 1           ad=(((120n) / (ceil(((120n) - 5p) / (10u)))) < 119.5n) ? ((floor((ceil(((120n) - 5p) / (10u))) / 2.0) * (((((60n) - 0) + 60n) * 120n) + (((120n) / (ceil(((120n) - 5p) / (10u)))) * 100n))) + ((((ceil(((120n) - 5p) / (10u))) / 2) - floor((ceil(((120n) - 5p) / (10u))) / 2) != 0) ? (((50n > (((60n) - 0) + 60n) ? 50n : (((60n) - 0) + 60n)) * 120n) + (((120n) / (ceil(((120n) - 5p) / (10u)))) * 50n)) : 0)) / 1 : ((floor((ceil(((120n) - 5p) / (10u))) / 2.0) * ((60n > (((60n) - 0) + 50n) ? 60n : (((60n) - 0) + 50n)) * ((120n) / (ceil(((120n) - 5p) / (10u)))))) + ((((ceil(((120n) - 5p) / (10u))) / 2) - floor((ceil(((120n) - 5p) / (10u))) / 2) != 0) ? ((100n > (((60n) - 0) + 80n) ? 100n : (((60n) - 0) + 80n)) * ((120n) / (ceil(((120n) - 5p) / (10u))))) : 0)) / 1           ps=(((120n) / (ceil(((120n) - 5p) / (10u)))) < 119.5n) ? (((2 * (50n > (((60n) - 0) + 60n) ? 50n : (((60n) - 0) + 60n))) + 340n) + (floor(((ceil(((120n) - 5p) / (10u))) - 1) / 2.0) * ((2 * (((60n) - 0) + 60n)) + 440n)) + ((((ceil(((120n) - 5p) / (10u))) / 2) - floor((ceil(((120n) - 5p) / (10u))) / 2) == 0) ? ((2 * (50n > (((60n) - 0) + 60n) ? 50n : (((60n) - 0) + 60n))) + 340n) : 0)) / 1 : (((2 * (100n > (((60n) - 0) + 80n) ? 100n : (((60n) - 0) + 80n))) + (2 * ((120n) / (ceil(((120n) - 5p) / (10u)))))) + (floor(((ceil(((120n) - 5p) / (10u))) - 1) / 2.0) * ((2 * (60n > (((60n) - 0) + 50n) ? 60n : (((60n) - 0) + 50n))) + (2 * ((120n) / (ceil(((120n) - 5p) / (10u))))))) + ((((ceil(((120n) - 5p) / (10u))) / 2) - floor((ceil(((120n) - 5p) / (10u))) / 2) == 0) ? ((2 * (100n > (((60n) - 0) + 80n) ? 100n : (((60n) - 0) + 80n))) + (2 * ((120n) / (ceil(((120n) - 5p) / (10u)))))) : 0)) / 1           pd=(((120n) / (ceil(((120n) - 5p) / (10u)))) < 119.5n) ? ((floor((ceil(((120n) - 5p) / (10u))) / 2.0) * ((2 * (((60n) - 0) + 60n)) + 440n)) + ((((ceil(((120n) - 5p) / (10u))) / 2) - floor((ceil(((120n) - 5p) / (10u))) / 2) != 0) ? ((2 * (50n > (((60n) - 0) + 60n) ? 50n : (((60n) - 0) + 60n))) + 340n) : 0)) / 1 : ((floor((ceil(((120n) - 5p) / (10u))) / 2.0) * ((2 * (60n > (((60n) - 0) + 50n) ? 60n : (((60n) - 0) + 50n))) + (2 * ((120n) / (ceil(((120n) - 5p) / (10u))))))) + ((((ceil(((120n) - 5p) / (10u))) / 2) - floor((ceil(((120n) - 5p) / (10u))) / 2) != 0) ? ((2 * (100n > (((60n) - 0) + 80n) ? 100n : (((60n) - 0) + 80n))) + (2 * ((120n) / (ceil(((120n) - 5p) / (10u)))))) : 0)) / 1           nrd=(((120n) / (ceil(((120n) - 5p) / (10u)))) < 119.5n) ? ((floor((ceil(((120n) - 5p) / (10u))) / 2.0) * (((((60n) - 0) + 60n) * 120n) + (((120n) / (ceil(((120n) - 5p) / (10u)))) * 100n))) + ((((ceil(((120n) - 5p) / (10u))) / 2) - floor((ceil(((120n) - 5p) / (10u))) / 2) != 0) ? (((50n > (((60n) - 0) + 60n) ? 50n : (((60n) - 0) + 60n)) * 120n) + (((120n) / (ceil(((120n) - 5p) / (10u)))) * 50n)) : 0)) / 1 : ((floor((ceil(((120n) - 5p) / (10u))) / 2.0) * ((60n > (((60n) - 0) + 50n) ? 60n : (((60n) - 0) + 50n)) * ((120n) / (ceil(((120n) - 5p) / (10u)))))) + ((((ceil(((120n) - 5p) / (10u))) / 2) - floor((ceil(((120n) - 5p) / (10u))) / 2) != 0) ? ((100n > (((60n) - 0) + 80n) ? 100n : (((60n) - 0) + 80n)) * ((120n) / (ceil(((120n) - 5p) / (10u))))) : 0)) / 1 / (((120n) / (ceil(((120n) - 5p) / (10u)))) * (ceil(((120n) - 5p) / (10u))) * ((120n) / (ceil(((120n) - 5p) / (10u)))) * (ceil(((120n) - 5p) / (10u))))           nrs=(((120n) / (ceil(((120n) - 5p) / (10u)))) < 119.5n) ? ((((50n > (((60n) - 0) + 60n) ? 50n : (((60n) - 0) + 60n)) * 120n) + (((120n) / (ceil(((120n) - 5p) / (10u)))) * 50n)) + (floor(((ceil(((120n) - 5p) / (10u))) - 1) / 2.0) * (((((60n) - 0) + 60n) * 120n) + (((120n) / (ceil(((120n) - 5p) / (10u)))) * 100n))) + ((((ceil(((120n) - 5p) / (10u))) / 2) - floor((ceil(((120n) - 5p) / (10u))) / 2) == 0) ? (((50n > (((60n) - 0) + 60n) ? 50n : (((60n) - 0) + 60n)) * 120n) + (((120n) / (ceil(((120n) - 5p) / (10u)))) * 50n)) : 0)) / 1 : (((100n > (((60n) - 0) + 80n) ? 100n : (((60n) - 0) + 80n)) * ((120n) / (ceil(((120n) - 5p) / (10u))))) + (floor(((ceil(((120n) - 5p) / (10u))) - 1) / 2.0) * ((60n > (((60n) - 0) + 50n) ? 60n : (((60n) - 0) + 50n)) * ((120n) / (ceil(((120n) - 5p) / (10u)))))) + ((((ceil(((120n) - 5p) / (10u))) / 2) - floor((ceil(((120n) - 5p) / (10u))) / 2) == 0) ? ((100n > (((60n) - 0) + 80n) ? 100n : (((60n) - 0) + 80n)) * ((120n) / (ceil(((120n) - 5p) / (10u))))) : 0)) / 1 / (((120n) / (ceil(((120n) - 5p) / (10u)))) * (ceil(((120n) - 5p) / (10u))) * ((120n) / (ceil(((120n) - 5p) / (10u)))) * (ceil(((120n) - 5p) / (10u))))           sa=(((120n) / (ceil(((120n) - 5p) / (10u)))) < 119.5n) ? (50n > (((60n) - 0) + 60n) ? 50n : (((60n) - 0) + 60n)) + 5e-08 : (100n > (((60n) - 0) + 80n) ? 100n : (((60n) - 0) + 80n))           sb=(((120n) / (ceil(((120n) - 5p) / (10u)))) < 119.5n) ? (50n > (((60n) - 0) + 60n) ? 50n : (((60n) - 0) + 60n)) + 5e-08 : (100n > (((60n) - 0) + 80n) ? 100n : (((60n) - 0) + 80n))           sd=(((120n) / (ceil(((120n) - 5p) / (10u)))) < 119.5n) ? (((60n) - 0) + 60n) + (2*5e-08) : (60n > (((60n) - 0) + 50n) ? 60n : (((60n) - 0) + 50n))           sca=(( ((120n) / (ceil(((120n) - 5p) / (10u)))) * ( (((1u) * (1u) / ((((120n) / (ceil(((120n) - 5p) / (10u)))) < 119.5n) ? (50n > (((60n) - 0) + 60n) ? 50n : (((60n) - 0) + 60n)) + 5e-08 : (100n > (((60n) - 0) + 80n) ? 100n : (((60n) - 0) + 80n))+60n)) - ((1u) * (1u) / (((((120n) / (ceil(((120n) - 5p) / (10u)))) < 119.5n) ? (50n > (((60n) - 0) + 60n) ? 50n : (((60n) - 0) + 60n)) + 5e-08 : (100n > (((60n) - 0) + 80n) ? 100n : (((60n) - 0) + 80n))+60n)+(45n)))) + ((1u) * (1u) / ((((120n) / (ceil(((120n) - 5p) / (10u)))) < 119.5n) ? (50n > (((60n) - 0) + 60n) ? 50n : (((60n) - 0) + 60n)) + 5e-08 : (100n > (((60n) - 0) + 80n) ? 100n : (((60n) - 0) + 80n))+60n)) - ((1u) * (1u)/ (((((120n) / (ceil(((120n) - 5p) / (10u)))) < 119.5n) ? (50n > (((60n) - 0) + 60n) ? 50n : (((60n) - 0) + 60n)) + 5e-08 : (100n > (((60n) - 0) + 80n) ? 100n : (((60n) - 0) + 80n))+60n)+(45n))))) + ( (45n) * ( (((1u) * (1u) / (60n)) - ((1u) * (1u) / ((60n)+((120n) / (ceil(((120n) - 5p) / (10u))))))) + ((1u) * (1u) / (60n)) - ((1u) * (1u)/ ((60n)+((120n) / (ceil(((120n) - 5p) / (10u))))))))) / (((120n) / (ceil(((120n) - 5p) / (10u)))) * (45n))           scb=((((120n) / (ceil(((120n) - 5p) / (10u)))) * ((((((120n) / (ceil(((120n) - 5p) / (10u)))) < 119.5n) ? (50n > (((60n) - 0) + 60n) ? 50n : (((60n) - 0) + 60n)) + 5e-08 : (100n > (((60n) - 0) + 80n) ? 100n : (((60n) - 0) + 80n))+60n)/10 + (1u)/100)*exp(-10 * ((((120n) / (ceil(((120n) - 5p) / (10u)))) < 119.5n) ? (50n > (((60n) - 0) + 60n) ? 50n : (((60n) - 0) + 60n)) + 5e-08 : (100n > (((60n) - 0) + 80n) ? 100n : (((60n) - 0) + 80n))+60n) / (1u)) - ((((((120n) / (ceil(((120n) - 5p) / (10u)))) < 119.5n) ? (50n > (((60n) - 0) + 60n) ? 50n : (((60n) - 0) + 60n)) + 5e-08 : (100n > (((60n) - 0) + 80n) ? 100n : (((60n) - 0) + 80n))+60n)+(45n))/10 + (1u)/100)*exp(-10 * (((((120n) / (ceil(((120n) - 5p) / (10u)))) < 119.5n) ? (50n > (((60n) - 0) + 60n) ? 50n : (((60n) - 0) + 60n)) + 5e-08 : (100n > (((60n) - 0) + 80n) ? 100n : (((60n) - 0) + 80n))+60n)+(45n)) / (1u)) + (((((120n) / (ceil(((120n) - 5p) / (10u)))) < 119.5n) ? (50n > (((60n) - 0) + 60n) ? 50n : (((60n) - 0) + 60n)) + 5e-08 : (100n > (((60n) - 0) + 80n) ? 100n : (((60n) - 0) + 80n))+60n)/10 + (1u)/100)*exp(-10 * ((((120n) / (ceil(((120n) - 5p) / (10u)))) < 119.5n) ? (50n > (((60n) - 0) + 60n) ? 50n : (((60n) - 0) + 60n)) + 5e-08 : (100n > (((60n) - 0) + 80n) ? 100n : (((60n) - 0) + 80n))+60n) / (1u)) - ((((((120n) / (ceil(((120n) - 5p) / (10u)))) < 119.5n) ? (50n > (((60n) - 0) + 60n) ? 50n : (((60n) - 0) + 60n)) + 5e-08 : (100n > (((60n) - 0) + 80n) ? 100n : (((60n) - 0) + 80n))+60n)+(45n))/10 + (1u)/100)*exp(-10 * (((((120n) / (ceil(((120n) - 5p) / (10u)))) < 119.5n) ? (50n > (((60n) - 0) + 60n) ? 50n : (((60n) - 0) + 60n)) + 5e-08 : (100n > (((60n) - 0) + 80n) ? 100n : (((60n) - 0) + 80n))+60n)+(45n)) / (1u)))) + ((45n) * (((60n)/10 + (1u)/100)*exp(-10 * (60n) / (1u)) - (((60n)+((120n) / (ceil(((120n) - 5p) / (10u)))))/10 + (1u)/100)*exp(-10 * ((60n)+((120n) / (ceil(((120n) - 5p) / (10u))))) / (1u)) + ((60n)/10 + (1u)/100)*exp(-10 * (60n) / (1u)) - (((60n)+((120n) / (ceil(((120n) - 5p) / (10u)))))/10 + (1u)/100)*exp(-10 * ((60n)+((120n) / (ceil(((120n) - 5p) / (10u))))) / (1u))))) / (((120n) / (ceil(((120n) - 5p) / (10u)))) * (45n))           scc=((((120n) / (ceil(((120n) - 5p) / (10u)))) * ((((((120n) / (ceil(((120n) - 5p) / (10u)))) < 119.5n) ? (50n > (((60n) - 0) + 60n) ? 50n : (((60n) - 0) + 60n)) + 5e-08 : (100n > (((60n) - 0) + 80n) ? 100n : (((60n) - 0) + 80n))+60n)/20 + (1u)/400)*exp(-20 * ((((120n) / (ceil(((120n) - 5p) / (10u)))) < 119.5n) ? (50n > (((60n) - 0) + 60n) ? 50n : (((60n) - 0) + 60n)) + 5e-08 : (100n > (((60n) - 0) + 80n) ? 100n : (((60n) - 0) + 80n))+60n) / (1u)) - ((((((120n) / (ceil(((120n) - 5p) / (10u)))) < 119.5n) ? (50n > (((60n) - 0) + 60n) ? 50n : (((60n) - 0) + 60n)) + 5e-08 : (100n > (((60n) - 0) + 80n) ? 100n : (((60n) - 0) + 80n))+60n)+(45n))/20 + (1u)/400)*exp(-20 * (((((120n) / (ceil(((120n) - 5p) / (10u)))) < 119.5n) ? (50n > (((60n) - 0) + 60n) ? 50n : (((60n) - 0) + 60n)) + 5e-08 : (100n > (((60n) - 0) + 80n) ? 100n : (((60n) - 0) + 80n))+60n)+(45n)) / (1u)) + (((((120n) / (ceil(((120n) - 5p) / (10u)))) < 119.5n) ? (50n > (((60n) - 0) + 60n) ? 50n : (((60n) - 0) + 60n)) + 5e-08 : (100n > (((60n) - 0) + 80n) ? 100n : (((60n) - 0) + 80n))+60n)/20 + (1u)/400)*exp(-20 * ((((120n) / (ceil(((120n) - 5p) / (10u)))) < 119.5n) ? (50n > (((60n) - 0) + 60n) ? 50n : (((60n) - 0) + 60n)) + 5e-08 : (100n > (((60n) - 0) + 80n) ? 100n : (((60n) - 0) + 80n))+60n) / (1u)) - ((((((120n) / (ceil(((120n) - 5p) / (10u)))) < 119.5n) ? (50n > (((60n) - 0) + 60n) ? 50n : (((60n) - 0) + 60n)) + 5e-08 : (100n > (((60n) - 0) + 80n) ? 100n : (((60n) - 0) + 80n))+60n)+(45n))/20 + (1u)/400)*exp(-20 * (((((120n) / (ceil(((120n) - 5p) / (10u)))) < 119.5n) ? (50n > (((60n) - 0) + 60n) ? 50n : (((60n) - 0) + 60n)) + 5e-08 : (100n > (((60n) - 0) + 80n) ? 100n : (((60n) - 0) + 80n))+60n)+(45n)) / (1u)))) + ((45n) * (((60n)/20 + (1u)/400)*exp(-20 * (60n) / (1u)) - (((60n)+((120n) / (ceil(((120n) - 5p) / (10u)))))/20 + (1u)/400)*exp(-20 * ((60n)+((120n) / (ceil(((120n) - 5p) / (10u))))) / (1u)) + ((60n)/20 + (1u)/400)*exp(-20 * (60n) / (1u)) - (((60n)+((120n) / (ceil(((120n) - 5p) / (10u)))))/20 + (1u)/400)*exp(-20 * ((60n)+((120n) / (ceil(((120n) - 5p) / (10u))))) / (1u))))) / (((120n) / (ceil(((120n) - 5p) / (10u)))) * (45n))           m=(1)
dc1 dc dev=Vin param=dc start=0 stop=1.1 step=0.0005
save VIN VOUT1 VOUT2
