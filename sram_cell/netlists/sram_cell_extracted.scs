simulator lang=spectre
subckt sram_cell_physical (GND Vdd WL Q Q_bar BL_bar BL)
M6 (BL_bar WL Q_bar GND) g45n1svt l=4.5e-08 w=2.4e-07 ad=3.36e-14 as=3.36e-14 pd=7.6e-07 ps=7.6e-07 sa=1.4e-07 sb=1.4e-07 sca=9.45211 scb=0.00821004 scc=0.000286958
M7 (GND Q Q_bar GND) g45n1svt l=4.5e-08 w=3.6e-07 ad=5.04e-14 as=5.04e-14 pd=1e-06 ps=1e-06 sa=1.4e-07 sb=1.4e-07 sca=5.75838 scb=0.0022385 scc=1.60319e-05
M8 (GND Q_bar Q GND) g45n1svt l=4.5e-08 w=3.6e-07 ad=5.04e-14 as=5.04e-14 pd=1e-06 ps=1e-06 sa=1.4e-07 sb=1.4e-07 sca=5.75838 scb=0.0022385 scc=1.60319e-05
M9 (Q WL BL GND) g45n1svt l=4.5e-08 w=2.4e-07 ad=3.36e-14 as=3.36e-14 pd=7.6e-07 ps=7.6e-07 sa=1.4e-07 sb=1.4e-07 sca=6.06571 scb=0.00385227 scc=0.000152152
M10 (Vdd Q Q_bar Vdd) g45p1svt l=4.5e-08 w=1.2e-07 ad=1.68e-14 as=1.68e-14 pd=5.2e-07 ps=5.2e-07 sa=1.4e-07 sb=1.4e-07 sca=57.0437 scb=0.0528056 scc=0.00752443
M11 (Q Q_bar Vdd Vdd) g45p1svt l=4.5e-08 w=1.2e-07 ad=1.68e-14 as=1.68e-14 pd=5.2e-07 ps=5.2e-07 sa=1.4e-07 sb=1.4e-07 sca=73.81 scb=0.0749781 scc=0.0101674
ends sram_cell_physical
subckt sram_cell (BL BL_bar WL Q Q_bar Vdd GND)
Xphysical (GND Vdd WL Q Q_bar BL_bar BL) sram_cell_physical
ends sram_cell
