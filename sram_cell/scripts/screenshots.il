w=deOpenCellView("sram_cell" "sram_cell" "schematic" "schematic" nil "r")
hiZoomIn(w w~>cellView~>bBox)
hiExportImage(?fileName "results/figures/schematic_cadence.png" ?window w ?exportRegion 'entireDesign ?width 1800)
w2=deOpenCellView("sram_cell" "sram_cell" "layout" "maskLayout" nil "r")
geSetAreaViewLevel(w2 w2~>cellView~>bBox 0 32)
hiExportImage(?fileName "results/figures/layout_cadence.png" ?window w2 ?exportRegion 'entireDesign ?width 1600)
foreach(layer '("Metal1" "Metal2" "Metal3")
 leSetLayerVisible(list(layer "pin") nil)
 leSetLayerVisible(list(layer "label") nil))
hiExportImage(?fileName "results/figures/layout_compact.png" ?window w2 ?exportRegion 'entireDesign ?width 1800)
printf("SCREENSHOTS_COMPLETE\n")
exit()
