cellName=getShellEnvVar("SRAM_CELL_NAME")
unless(cellName cellName="sram_cell")
c=dbOpenCellViewByType("sram_cell" cellName "schematic" "" "r")
f=outfile(sprintf(nil "netlists/%s.cdl" cellName))
fprintf(f "* Exported from native OA schematic sram_cell/%s/schematic\n.SUBCKT %s BL BL_bar WL Q Q_bar Vdd GND\n" cellName cellName)
foreach(i c~>instances when(member(i~>cellName '("nmos1v" "pmos1v"))
 fprintf(f "M%s" i~>name)
 foreach(tn '("D" "G" "S" "B") it=car(setof(x i~>instTerms x~>name==tn)) fprintf(f " %s" it~>net~>name))
 fprintf(f " %s W=%s L=%s\n" if(i~>cellName=="nmos1v" then "g45n1svt" else "g45p1svt") cdfGetInstCDF(i)~>w~>value cdfGetInstCDF(i)~>l~>value)
))
fprintf(f ".ENDS %s\n" cellName) close(f)
exit()
