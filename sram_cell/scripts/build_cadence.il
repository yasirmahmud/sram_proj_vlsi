lib=ddGetObj("sram_cell")
unless(lib lib=ddCreateLib("sram_cell" "./cadence"))
techBindTechFile(lib "gpdk045")
foreach(view '("schematic" "symbol")
 src=dbOpenCellViewByType("reference" "sram_cell" view "" "r")
 dst=dbCopyCellView(src "sram_cell" "sram_cell" view nil nil t)
 dbSave(dst) dbClose(dst)
)
src=dbOpenCellViewByType("reference" "sram_cell" "schematic" "" "r")
dst=dbCopyCellView(src "sram_cell" "sram_cell_default" "schematic" nil nil t)
foreach(i dst~>instances when(member(i~>cellName '("nmos1v" "pmos1v")) dbReplaceProp(i "w" "string" "120n")))
dbSave(dst) dbClose(dst)
src=dbOpenCellViewByType("reference" "sram_cell_layout_no_power" "layout" "" "r")
dst=dbCopyCellView(src "sram_cell" "sram_cell" "layout" nil nil t)
f=outfile("results/layout_inventory.txt")
printf("COPY_LAYOUT %L\n" dst)
foreach(s dst~>shapes fprintf(f "SHAPE %s %L %L %L %L\n" s~>objType s~>lpp s~>bBox s~>points s~>theLabel))
foreach(i dst~>instances fprintf(f "INST %s %s %L %L %L\n" i~>name i~>cellName i~>xy i~>orient i~>bBox) foreach(te i~>master~>terminals foreach(pi te~>pins fprintf(f "TERM %s %L\n" te~>name dbTransformBBox(pi~>fig~>bBox i~>transform)))))
close(f)
dbSave(dst) dbClose(dst)
printf("BUILD_COMPLETE\n")
exit()
