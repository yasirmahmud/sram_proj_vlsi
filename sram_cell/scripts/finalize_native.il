; Add observable storage terminals and consistent reusable symbols.
pinMaster=dbOpenCellViewByType("basic" "iopin" "symbol" "" "r")
symMaster=dbOpenCellViewByType("basic" "sympin" "symbol" "" "r")
foreach(cellName '("sram_cell" "sram_cell_default")
 c=dbOpenCellViewByType("sram_cell" cellName "schematic" "" "a")
 foreach(spec '(("Q" "NM3" "S") ("Q_bar" "NM2" "D"))
  name=car(spec) i=dbFindAnyInstByName(c cadr(spec))
  loc=dbTransformPoint(centerBox(car(dbFindTermByName(i~>master caddr(spec))~>pins)~>fig~>bBox) i~>transform)
  existing=dbFindTermByName(c name)
  when(existing && null(existing~>pins) dbDeleteObject(existing))
  unless(dbFindTermByName(c name) schCreatePin(c pinMaster name "inputOutput" nil loc "R0"))
 )
 dbSave(c) dbClose(c)
 s=dbOpenCellViewByType("sram_cell" cellName "symbol" "schematicSymbol" "w")
 dbCreateRect(s '("device" "drawing") '((0.0 0.0) (2.0 3.0)))
 dbCreateLabel(s '("device" "drawing") '(1.0 1.5) "6T SRAM" "centerCenter" "R0" "roman" .18)
 foreach(spec '(("WL" "input" -.25 2.25 0.0 2.25 .10 2.25 "centerLeft") ("BL" "inputOutput" -.25 1.0 0.0 1.0 .10 1.0 "centerLeft") ("BL_bar" "inputOutput" -.25 .5 0.0 .5 .10 .5 "centerLeft") ("Q" "inputOutput" 2.25 2.0 2.0 2.0 1.90 2.0 "centerRight") ("Q_bar" "inputOutput" 2.25 1.0 2.0 1.0 1.90 1.0 "centerRight") ("Vdd" "input" 1.0 3.25 1.0 3.0 1.0 2.80 "centerCenter") ("GND" "input" 1.0 -.25 1.0 0.0 1.0 .20 "centerCenter"))
  schCreateSymbolPin(s symMaster car(spec) cadr(spec) list(nth(2 spec) nth(3 spec)) "R0" t nil nil if(car(spec)=="Vdd" then "power" else if(car(spec)=="GND" then "ground" else "signal")))
  dbCreateLine(s '("device" "drawing") list(list(nth(2 spec) nth(3 spec)) list(nth(4 spec) nth(5 spec))))
  dbCreateLabel(s '("device" "drawing") list(nth(6 spec) nth(7 spec)) car(spec) nth(8 spec) "R0" "roman" .14)
 )
 dbFindTermByName(s "Vdd")~>sigType="power"
 dbFindTermByName(s "GND")~>sigType="ground"
 dbSave(s) dbClose(s)
 c=dbOpenCellViewByType("sram_cell" cellName "schematic" "" "a")
 printf("NATIVE_CHECK %s %L\n" cellName schCheck(c)) dbSave(c) dbClose(c)
)
exit()
