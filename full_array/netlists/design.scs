simulator lang=spectre
subckt inv (IN OUT VDD GND)
NM0 (OUT IN GND GND) g45n1svt w=(360n) l=45n nf=ceil(((360n) - 5p) / (10u))           as=(((360n) / (ceil(((360n) - 5p) / (10u)))) < 119.5n) ? ((((50n > (((60n) - 0) + 60n) ? 50n : (((60n) - 0) + 60n)) * 120n) + (((360n) / (ceil(((360n) - 5p) / (10u)))) * 50n)) + (floor(((ceil(((360n) - 5p) / (10u))) - 1) / 2.0) * (((((60n) - 0) + 60n) * 120n) + (((360n) / (ceil(((360n) - 5p) / (10u)))) * 100n))) + ((((ceil(((360n) - 5p) / (10u))) / 2) - floor((ceil(((360n) - 5p) / (10u))) / 2) == 0) ? (((50n > (((60n) - 0) + 60n) ? 50n : (((60n) - 0) + 60n)) * 120n) + (((360n) / (ceil(((360n) - 5p) / (10u)))) * 50n)) : 0)) / 1 : (((100n > (((60n) - 0) + 80n) ? 100n : (((60n) - 0) + 80n)) * ((360n) / (ceil(((360n) - 5p) / (10u))))) + (floor(((ceil(((360n) - 5p) / (10u))) - 1) / 2.0) * ((60n > (((60n) - 0) + 50n) ? 60n : (((60n) - 0) + 50n)) * ((360n) / (ceil(((360n) - 5p) / (10u)))))) + ((((ceil(((360n) - 5p) / (10u))) / 2) - floor((ceil(((360n) - 5p) / (10u))) / 2) == 0) ? ((100n > (((60n) - 0) + 80n) ? 100n : (((60n) - 0) + 80n)) * ((360n) / (ceil(((360n) - 5p) / (10u))))) : 0)) / 1           ad=(((360n) / (ceil(((360n) - 5p) / (10u)))) < 119.5n) ? ((floor((ceil(((360n) - 5p) / (10u))) / 2.0) * (((((60n) - 0) + 60n) * 120n) + (((360n) / (ceil(((360n) - 5p) / (10u)))) * 100n))) + ((((ceil(((360n) - 5p) / (10u))) / 2) - floor((ceil(((360n) - 5p) / (10u))) / 2) != 0) ? (((50n > (((60n) - 0) + 60n) ? 50n : (((60n) - 0) + 60n)) * 120n) + (((360n) / (ceil(((360n) - 5p) / (10u)))) * 50n)) : 0)) / 1 : ((floor((ceil(((360n) - 5p) / (10u))) / 2.0) * ((60n > (((60n) - 0) + 50n) ? 60n : (((60n) - 0) + 50n)) * ((360n) / (ceil(((360n) - 5p) / (10u)))))) + ((((ceil(((360n) - 5p) / (10u))) / 2) - floor((ceil(((360n) - 5p) / (10u))) / 2) != 0) ? ((100n > (((60n) - 0) + 80n) ? 100n : (((60n) - 0) + 80n)) * ((360n) / (ceil(((360n) - 5p) / (10u))))) : 0)) / 1           ps=(((360n) / (ceil(((360n) - 5p) / (10u)))) < 119.5n) ? (((2 * (50n > (((60n) - 0) + 60n) ? 50n : (((60n) - 0) + 60n))) + 340n) + (floor(((ceil(((360n) - 5p) / (10u))) - 1) / 2.0) * ((2 * (((60n) - 0) + 60n)) + 440n)) + ((((ceil(((360n) - 5p) / (10u))) / 2) - floor((ceil(((360n) - 5p) / (10u))) / 2) == 0) ? ((2 * (50n > (((60n) - 0) + 60n) ? 50n : (((60n) - 0) + 60n))) + 340n) : 0)) / 1 : (((2 * (100n > (((60n) - 0) + 80n) ? 100n : (((60n) - 0) + 80n))) + (2 * ((360n) / (ceil(((360n) - 5p) / (10u)))))) + (floor(((ceil(((360n) - 5p) / (10u))) - 1) / 2.0) * ((2 * (60n > (((60n) - 0) + 50n) ? 60n : (((60n) - 0) + 50n))) + (2 * ((360n) / (ceil(((360n) - 5p) / (10u))))))) + ((((ceil(((360n) - 5p) / (10u))) / 2) - floor((ceil(((360n) - 5p) / (10u))) / 2) == 0) ? ((2 * (100n > (((60n) - 0) + 80n) ? 100n : (((60n) - 0) + 80n))) + (2 * ((360n) / (ceil(((360n) - 5p) / (10u)))))) : 0)) / 1           pd=(((360n) / (ceil(((360n) - 5p) / (10u)))) < 119.5n) ? ((floor((ceil(((360n) - 5p) / (10u))) / 2.0) * ((2 * (((60n) - 0) + 60n)) + 440n)) + ((((ceil(((360n) - 5p) / (10u))) / 2) - floor((ceil(((360n) - 5p) / (10u))) / 2) != 0) ? ((2 * (50n > (((60n) - 0) + 60n) ? 50n : (((60n) - 0) + 60n))) + 340n) : 0)) / 1 : ((floor((ceil(((360n) - 5p) / (10u))) / 2.0) * ((2 * (60n > (((60n) - 0) + 50n) ? 60n : (((60n) - 0) + 50n))) + (2 * ((360n) / (ceil(((360n) - 5p) / (10u))))))) + ((((ceil(((360n) - 5p) / (10u))) / 2) - floor((ceil(((360n) - 5p) / (10u))) / 2) != 0) ? ((2 * (100n > (((60n) - 0) + 80n) ? 100n : (((60n) - 0) + 80n))) + (2 * ((360n) / (ceil(((360n) - 5p) / (10u)))))) : 0)) / 1           nrd=(((360n) / (ceil(((360n) - 5p) / (10u)))) < 119.5n) ? ((floor((ceil(((360n) - 5p) / (10u))) / 2.0) * (((((60n) - 0) + 60n) * 120n) + (((360n) / (ceil(((360n) - 5p) / (10u)))) * 100n))) + ((((ceil(((360n) - 5p) / (10u))) / 2) - floor((ceil(((360n) - 5p) / (10u))) / 2) != 0) ? (((50n > (((60n) - 0) + 60n) ? 50n : (((60n) - 0) + 60n)) * 120n) + (((360n) / (ceil(((360n) - 5p) / (10u)))) * 50n)) : 0)) / 1 : ((floor((ceil(((360n) - 5p) / (10u))) / 2.0) * ((60n > (((60n) - 0) + 50n) ? 60n : (((60n) - 0) + 50n)) * ((360n) / (ceil(((360n) - 5p) / (10u)))))) + ((((ceil(((360n) - 5p) / (10u))) / 2) - floor((ceil(((360n) - 5p) / (10u))) / 2) != 0) ? ((100n > (((60n) - 0) + 80n) ? 100n : (((60n) - 0) + 80n)) * ((360n) / (ceil(((360n) - 5p) / (10u))))) : 0)) / 1 / (((360n) / (ceil(((360n) - 5p) / (10u)))) * (ceil(((360n) - 5p) / (10u))) * ((360n) / (ceil(((360n) - 5p) / (10u)))) * (ceil(((360n) - 5p) / (10u))))           nrs=(((360n) / (ceil(((360n) - 5p) / (10u)))) < 119.5n) ? ((((50n > (((60n) - 0) + 60n) ? 50n : (((60n) - 0) + 60n)) * 120n) + (((360n) / (ceil(((360n) - 5p) / (10u)))) * 50n)) + (floor(((ceil(((360n) - 5p) / (10u))) - 1) / 2.0) * (((((60n) - 0) + 60n) * 120n) + (((360n) / (ceil(((360n) - 5p) / (10u)))) * 100n))) + ((((ceil(((360n) - 5p) / (10u))) / 2) - floor((ceil(((360n) - 5p) / (10u))) / 2) == 0) ? (((50n > (((60n) - 0) + 60n) ? 50n : (((60n) - 0) + 60n)) * 120n) + (((360n) / (ceil(((360n) - 5p) / (10u)))) * 50n)) : 0)) / 1 : (((100n > (((60n) - 0) + 80n) ? 100n : (((60n) - 0) + 80n)) * ((360n) / (ceil(((360n) - 5p) / (10u))))) + (floor(((ceil(((360n) - 5p) / (10u))) - 1) / 2.0) * ((60n > (((60n) - 0) + 50n) ? 60n : (((60n) - 0) + 50n)) * ((360n) / (ceil(((360n) - 5p) / (10u)))))) + ((((ceil(((360n) - 5p) / (10u))) / 2) - floor((ceil(((360n) - 5p) / (10u))) / 2) == 0) ? ((100n > (((60n) - 0) + 80n) ? 100n : (((60n) - 0) + 80n)) * ((360n) / (ceil(((360n) - 5p) / (10u))))) : 0)) / 1 / (((360n) / (ceil(((360n) - 5p) / (10u)))) * (ceil(((360n) - 5p) / (10u))) * ((360n) / (ceil(((360n) - 5p) / (10u)))) * (ceil(((360n) - 5p) / (10u))))           sa=(((360n) / (ceil(((360n) - 5p) / (10u)))) < 119.5n) ? (50n > (((60n) - 0) + 60n) ? 50n : (((60n) - 0) + 60n)) + 5e-08 : (100n > (((60n) - 0) + 80n) ? 100n : (((60n) - 0) + 80n))           sb=(((360n) / (ceil(((360n) - 5p) / (10u)))) < 119.5n) ? (50n > (((60n) - 0) + 60n) ? 50n : (((60n) - 0) + 60n)) + 5e-08 : (100n > (((60n) - 0) + 80n) ? 100n : (((60n) - 0) + 80n))           sd=(((360n) / (ceil(((360n) - 5p) / (10u)))) < 119.5n) ? (((60n) - 0) + 60n) + (2*5e-08) : (60n > (((60n) - 0) + 50n) ? 60n : (((60n) - 0) + 50n))           sca=(( ((360n) / (ceil(((360n) - 5p) / (10u)))) * ( (((1u) * (1u) / ((((360n) / (ceil(((360n) - 5p) / (10u)))) < 119.5n) ? (50n > (((60n) - 0) + 60n) ? 50n : (((60n) - 0) + 60n)) + 5e-08 : (100n > (((60n) - 0) + 80n) ? 100n : (((60n) - 0) + 80n))+60n)) - ((1u) * (1u) / (((((360n) / (ceil(((360n) - 5p) / (10u)))) < 119.5n) ? (50n > (((60n) - 0) + 60n) ? 50n : (((60n) - 0) + 60n)) + 5e-08 : (100n > (((60n) - 0) + 80n) ? 100n : (((60n) - 0) + 80n))+60n)+(45n)))) + ((1u) * (1u) / ((((360n) / (ceil(((360n) - 5p) / (10u)))) < 119.5n) ? (50n > (((60n) - 0) + 60n) ? 50n : (((60n) - 0) + 60n)) + 5e-08 : (100n > (((60n) - 0) + 80n) ? 100n : (((60n) - 0) + 80n))+60n)) - ((1u) * (1u)/ (((((360n) / (ceil(((360n) - 5p) / (10u)))) < 119.5n) ? (50n > (((60n) - 0) + 60n) ? 50n : (((60n) - 0) + 60n)) + 5e-08 : (100n > (((60n) - 0) + 80n) ? 100n : (((60n) - 0) + 80n))+60n)+(45n))))) + ( (45n) * ( (((1u) * (1u) / (60n)) - ((1u) * (1u) / ((60n)+((360n) / (ceil(((360n) - 5p) / (10u))))))) + ((1u) * (1u) / (60n)) - ((1u) * (1u)/ ((60n)+((360n) / (ceil(((360n) - 5p) / (10u))))))))) / (((360n) / (ceil(((360n) - 5p) / (10u)))) * (45n))           scb=((((360n) / (ceil(((360n) - 5p) / (10u)))) * ((((((360n) / (ceil(((360n) - 5p) / (10u)))) < 119.5n) ? (50n > (((60n) - 0) + 60n) ? 50n : (((60n) - 0) + 60n)) + 5e-08 : (100n > (((60n) - 0) + 80n) ? 100n : (((60n) - 0) + 80n))+60n)/10 + (1u)/100)*exp(-10 * ((((360n) / (ceil(((360n) - 5p) / (10u)))) < 119.5n) ? (50n > (((60n) - 0) + 60n) ? 50n : (((60n) - 0) + 60n)) + 5e-08 : (100n > (((60n) - 0) + 80n) ? 100n : (((60n) - 0) + 80n))+60n) / (1u)) - ((((((360n) / (ceil(((360n) - 5p) / (10u)))) < 119.5n) ? (50n > (((60n) - 0) + 60n) ? 50n : (((60n) - 0) + 60n)) + 5e-08 : (100n > (((60n) - 0) + 80n) ? 100n : (((60n) - 0) + 80n))+60n)+(45n))/10 + (1u)/100)*exp(-10 * (((((360n) / (ceil(((360n) - 5p) / (10u)))) < 119.5n) ? (50n > (((60n) - 0) + 60n) ? 50n : (((60n) - 0) + 60n)) + 5e-08 : (100n > (((60n) - 0) + 80n) ? 100n : (((60n) - 0) + 80n))+60n)+(45n)) / (1u)) + (((((360n) / (ceil(((360n) - 5p) / (10u)))) < 119.5n) ? (50n > (((60n) - 0) + 60n) ? 50n : (((60n) - 0) + 60n)) + 5e-08 : (100n > (((60n) - 0) + 80n) ? 100n : (((60n) - 0) + 80n))+60n)/10 + (1u)/100)*exp(-10 * ((((360n) / (ceil(((360n) - 5p) / (10u)))) < 119.5n) ? (50n > (((60n) - 0) + 60n) ? 50n : (((60n) - 0) + 60n)) + 5e-08 : (100n > (((60n) - 0) + 80n) ? 100n : (((60n) - 0) + 80n))+60n) / (1u)) - ((((((360n) / (ceil(((360n) - 5p) / (10u)))) < 119.5n) ? (50n > (((60n) - 0) + 60n) ? 50n : (((60n) - 0) + 60n)) + 5e-08 : (100n > (((60n) - 0) + 80n) ? 100n : (((60n) - 0) + 80n))+60n)+(45n))/10 + (1u)/100)*exp(-10 * (((((360n) / (ceil(((360n) - 5p) / (10u)))) < 119.5n) ? (50n > (((60n) - 0) + 60n) ? 50n : (((60n) - 0) + 60n)) + 5e-08 : (100n > (((60n) - 0) + 80n) ? 100n : (((60n) - 0) + 80n))+60n)+(45n)) / (1u)))) + ((45n) * (((60n)/10 + (1u)/100)*exp(-10 * (60n) / (1u)) - (((60n)+((360n) / (ceil(((360n) - 5p) / (10u)))))/10 + (1u)/100)*exp(-10 * ((60n)+((360n) / (ceil(((360n) - 5p) / (10u))))) / (1u)) + ((60n)/10 + (1u)/100)*exp(-10 * (60n) / (1u)) - (((60n)+((360n) / (ceil(((360n) - 5p) / (10u)))))/10 + (1u)/100)*exp(-10 * ((60n)+((360n) / (ceil(((360n) - 5p) / (10u))))) / (1u))))) / (((360n) / (ceil(((360n) - 5p) / (10u)))) * (45n))           scc=((((360n) / (ceil(((360n) - 5p) / (10u)))) * ((((((360n) / (ceil(((360n) - 5p) / (10u)))) < 119.5n) ? (50n > (((60n) - 0) + 60n) ? 50n : (((60n) - 0) + 60n)) + 5e-08 : (100n > (((60n) - 0) + 80n) ? 100n : (((60n) - 0) + 80n))+60n)/20 + (1u)/400)*exp(-20 * ((((360n) / (ceil(((360n) - 5p) / (10u)))) < 119.5n) ? (50n > (((60n) - 0) + 60n) ? 50n : (((60n) - 0) + 60n)) + 5e-08 : (100n > (((60n) - 0) + 80n) ? 100n : (((60n) - 0) + 80n))+60n) / (1u)) - ((((((360n) / (ceil(((360n) - 5p) / (10u)))) < 119.5n) ? (50n > (((60n) - 0) + 60n) ? 50n : (((60n) - 0) + 60n)) + 5e-08 : (100n > (((60n) - 0) + 80n) ? 100n : (((60n) - 0) + 80n))+60n)+(45n))/20 + (1u)/400)*exp(-20 * (((((360n) / (ceil(((360n) - 5p) / (10u)))) < 119.5n) ? (50n > (((60n) - 0) + 60n) ? 50n : (((60n) - 0) + 60n)) + 5e-08 : (100n > (((60n) - 0) + 80n) ? 100n : (((60n) - 0) + 80n))+60n)+(45n)) / (1u)) + (((((360n) / (ceil(((360n) - 5p) / (10u)))) < 119.5n) ? (50n > (((60n) - 0) + 60n) ? 50n : (((60n) - 0) + 60n)) + 5e-08 : (100n > (((60n) - 0) + 80n) ? 100n : (((60n) - 0) + 80n))+60n)/20 + (1u)/400)*exp(-20 * ((((360n) / (ceil(((360n) - 5p) / (10u)))) < 119.5n) ? (50n > (((60n) - 0) + 60n) ? 50n : (((60n) - 0) + 60n)) + 5e-08 : (100n > (((60n) - 0) + 80n) ? 100n : (((60n) - 0) + 80n))+60n) / (1u)) - ((((((360n) / (ceil(((360n) - 5p) / (10u)))) < 119.5n) ? (50n > (((60n) - 0) + 60n) ? 50n : (((60n) - 0) + 60n)) + 5e-08 : (100n > (((60n) - 0) + 80n) ? 100n : (((60n) - 0) + 80n))+60n)+(45n))/20 + (1u)/400)*exp(-20 * (((((360n) / (ceil(((360n) - 5p) / (10u)))) < 119.5n) ? (50n > (((60n) - 0) + 60n) ? 50n : (((60n) - 0) + 60n)) + 5e-08 : (100n > (((60n) - 0) + 80n) ? 100n : (((60n) - 0) + 80n))+60n)+(45n)) / (1u)))) + ((45n) * (((60n)/20 + (1u)/400)*exp(-20 * (60n) / (1u)) - (((60n)+((360n) / (ceil(((360n) - 5p) / (10u)))))/20 + (1u)/400)*exp(-20 * ((60n)+((360n) / (ceil(((360n) - 5p) / (10u))))) / (1u)) + ((60n)/20 + (1u)/400)*exp(-20 * (60n) / (1u)) - (((60n)+((360n) / (ceil(((360n) - 5p) / (10u)))))/20 + (1u)/400)*exp(-20 * ((60n)+((360n) / (ceil(((360n) - 5p) / (10u))))) / (1u))))) / (((360n) / (ceil(((360n) - 5p) / (10u)))) * (45n))           m=(1)
PM0 (OUT IN VDD VDD) g45p1svt w=(360n) l=45n nf=ceil(((360n) - 5p) / (10u))           as=(((360n) / (ceil(((360n) - 5p) / (10u)))) < 119.5n) ? ((((50n > (((60n) - 0) + 60n) ? 50n : (((60n) - 0) + 60n)) * 120n) + (((360n) / (ceil(((360n) - 5p) / (10u)))) * 50n)) + (floor(((ceil(((360n) - 5p) / (10u))) - 1) / 2.0) * (((((60n) - 0) + 60n) * 120n) + (((360n) / (ceil(((360n) - 5p) / (10u)))) * 100n))) + ((((ceil(((360n) - 5p) / (10u))) / 2) - floor((ceil(((360n) - 5p) / (10u))) / 2) == 0) ? (((50n > (((60n) - 0) + 60n) ? 50n : (((60n) - 0) + 60n)) * 120n) + (((360n) / (ceil(((360n) - 5p) / (10u)))) * 50n)) : 0)) / 1 : (((100n > (((60n) - 0) + 80n) ? 100n : (((60n) - 0) + 80n)) * ((360n) / (ceil(((360n) - 5p) / (10u))))) + (floor(((ceil(((360n) - 5p) / (10u))) - 1) / 2.0) * ((60n > (((60n) - 0) + 50n) ? 60n : (((60n) - 0) + 50n)) * ((360n) / (ceil(((360n) - 5p) / (10u)))))) + ((((ceil(((360n) - 5p) / (10u))) / 2) - floor((ceil(((360n) - 5p) / (10u))) / 2) == 0) ? ((100n > (((60n) - 0) + 80n) ? 100n : (((60n) - 0) + 80n)) * ((360n) / (ceil(((360n) - 5p) / (10u))))) : 0)) / 1           ad=(((360n) / (ceil(((360n) - 5p) / (10u)))) < 119.5n) ? ((floor((ceil(((360n) - 5p) / (10u))) / 2.0) * (((((60n) - 0) + 60n) * 120n) + (((360n) / (ceil(((360n) - 5p) / (10u)))) * 100n))) + ((((ceil(((360n) - 5p) / (10u))) / 2) - floor((ceil(((360n) - 5p) / (10u))) / 2) != 0) ? (((50n > (((60n) - 0) + 60n) ? 50n : (((60n) - 0) + 60n)) * 120n) + (((360n) / (ceil(((360n) - 5p) / (10u)))) * 50n)) : 0)) / 1 : ((floor((ceil(((360n) - 5p) / (10u))) / 2.0) * ((60n > (((60n) - 0) + 50n) ? 60n : (((60n) - 0) + 50n)) * ((360n) / (ceil(((360n) - 5p) / (10u)))))) + ((((ceil(((360n) - 5p) / (10u))) / 2) - floor((ceil(((360n) - 5p) / (10u))) / 2) != 0) ? ((100n > (((60n) - 0) + 80n) ? 100n : (((60n) - 0) + 80n)) * ((360n) / (ceil(((360n) - 5p) / (10u))))) : 0)) / 1           ps=(((360n) / (ceil(((360n) - 5p) / (10u)))) < 119.5n) ? (((2 * (50n > (((60n) - 0) + 60n) ? 50n : (((60n) - 0) + 60n))) + 340n) + (floor(((ceil(((360n) - 5p) / (10u))) - 1) / 2.0) * ((2 * (((60n) - 0) + 60n)) + 440n)) + ((((ceil(((360n) - 5p) / (10u))) / 2) - floor((ceil(((360n) - 5p) / (10u))) / 2) == 0) ? ((2 * (50n > (((60n) - 0) + 60n) ? 50n : (((60n) - 0) + 60n))) + 340n) : 0)) / 1 : (((2 * (100n > (((60n) - 0) + 80n) ? 100n : (((60n) - 0) + 80n))) + (2 * ((360n) / (ceil(((360n) - 5p) / (10u)))))) + (floor(((ceil(((360n) - 5p) / (10u))) - 1) / 2.0) * ((2 * (60n > (((60n) - 0) + 50n) ? 60n : (((60n) - 0) + 50n))) + (2 * ((360n) / (ceil(((360n) - 5p) / (10u))))))) + ((((ceil(((360n) - 5p) / (10u))) / 2) - floor((ceil(((360n) - 5p) / (10u))) / 2) == 0) ? ((2 * (100n > (((60n) - 0) + 80n) ? 100n : (((60n) - 0) + 80n))) + (2 * ((360n) / (ceil(((360n) - 5p) / (10u)))))) : 0)) / 1           pd=(((360n) / (ceil(((360n) - 5p) / (10u)))) < 119.5n) ? ((floor((ceil(((360n) - 5p) / (10u))) / 2.0) * ((2 * (((60n) - 0) + 60n)) + 440n)) + ((((ceil(((360n) - 5p) / (10u))) / 2) - floor((ceil(((360n) - 5p) / (10u))) / 2) != 0) ? ((2 * (50n > (((60n) - 0) + 60n) ? 50n : (((60n) - 0) + 60n))) + 340n) : 0)) / 1 : ((floor((ceil(((360n) - 5p) / (10u))) / 2.0) * ((2 * (60n > (((60n) - 0) + 50n) ? 60n : (((60n) - 0) + 50n))) + (2 * ((360n) / (ceil(((360n) - 5p) / (10u))))))) + ((((ceil(((360n) - 5p) / (10u))) / 2) - floor((ceil(((360n) - 5p) / (10u))) / 2) != 0) ? ((2 * (100n > (((60n) - 0) + 80n) ? 100n : (((60n) - 0) + 80n))) + (2 * ((360n) / (ceil(((360n) - 5p) / (10u)))))) : 0)) / 1           nrd=(((360n) / (ceil(((360n) - 5p) / (10u)))) < 119.5n) ? ((floor((ceil(((360n) - 5p) / (10u))) / 2.0) * (((((60n) - 0) + 60n) * 120n) + (((360n) / (ceil(((360n) - 5p) / (10u)))) * 100n))) + ((((ceil(((360n) - 5p) / (10u))) / 2) - floor((ceil(((360n) - 5p) / (10u))) / 2) != 0) ? (((50n > (((60n) - 0) + 60n) ? 50n : (((60n) - 0) + 60n)) * 120n) + (((360n) / (ceil(((360n) - 5p) / (10u)))) * 50n)) : 0)) / 1 : ((floor((ceil(((360n) - 5p) / (10u))) / 2.0) * ((60n > (((60n) - 0) + 50n) ? 60n : (((60n) - 0) + 50n)) * ((360n) / (ceil(((360n) - 5p) / (10u)))))) + ((((ceil(((360n) - 5p) / (10u))) / 2) - floor((ceil(((360n) - 5p) / (10u))) / 2) != 0) ? ((100n > (((60n) - 0) + 80n) ? 100n : (((60n) - 0) + 80n)) * ((360n) / (ceil(((360n) - 5p) / (10u))))) : 0)) / 1 / (((360n) / (ceil(((360n) - 5p) / (10u)))) * (ceil(((360n) - 5p) / (10u))) * ((360n) / (ceil(((360n) - 5p) / (10u)))) * (ceil(((360n) - 5p) / (10u))))           nrs=(((360n) / (ceil(((360n) - 5p) / (10u)))) < 119.5n) ? ((((50n > (((60n) - 0) + 60n) ? 50n : (((60n) - 0) + 60n)) * 120n) + (((360n) / (ceil(((360n) - 5p) / (10u)))) * 50n)) + (floor(((ceil(((360n) - 5p) / (10u))) - 1) / 2.0) * (((((60n) - 0) + 60n) * 120n) + (((360n) / (ceil(((360n) - 5p) / (10u)))) * 100n))) + ((((ceil(((360n) - 5p) / (10u))) / 2) - floor((ceil(((360n) - 5p) / (10u))) / 2) == 0) ? (((50n > (((60n) - 0) + 60n) ? 50n : (((60n) - 0) + 60n)) * 120n) + (((360n) / (ceil(((360n) - 5p) / (10u)))) * 50n)) : 0)) / 1 : (((100n > (((60n) - 0) + 80n) ? 100n : (((60n) - 0) + 80n)) * ((360n) / (ceil(((360n) - 5p) / (10u))))) + (floor(((ceil(((360n) - 5p) / (10u))) - 1) / 2.0) * ((60n > (((60n) - 0) + 50n) ? 60n : (((60n) - 0) + 50n)) * ((360n) / (ceil(((360n) - 5p) / (10u)))))) + ((((ceil(((360n) - 5p) / (10u))) / 2) - floor((ceil(((360n) - 5p) / (10u))) / 2) == 0) ? ((100n > (((60n) - 0) + 80n) ? 100n : (((60n) - 0) + 80n)) * ((360n) / (ceil(((360n) - 5p) / (10u))))) : 0)) / 1 / (((360n) / (ceil(((360n) - 5p) / (10u)))) * (ceil(((360n) - 5p) / (10u))) * ((360n) / (ceil(((360n) - 5p) / (10u)))) * (ceil(((360n) - 5p) / (10u))))           sa=(((360n) / (ceil(((360n) - 5p) / (10u)))) < 119.5n) ? (50n > (((60n) - 0) + 60n) ? 50n : (((60n) - 0) + 60n)) + 5e-08 : (100n > (((60n) - 0) + 80n) ? 100n : (((60n) - 0) + 80n))           sb=(((360n) / (ceil(((360n) - 5p) / (10u)))) < 119.5n) ? (50n > (((60n) - 0) + 60n) ? 50n : (((60n) - 0) + 60n)) + 5e-08 : (100n > (((60n) - 0) + 80n) ? 100n : (((60n) - 0) + 80n))           sd=(((360n) / (ceil(((360n) - 5p) / (10u)))) < 119.5n) ? (((60n) - 0) + 60n) + (2*5e-08) : (60n > (((60n) - 0) + 50n) ? 60n : (((60n) - 0) + 50n))           sca=(( ((360n) / (ceil(((360n) - 5p) / (10u)))) * ( (((1u) * (1u) / ((((360n) / (ceil(((360n) - 5p) / (10u)))) < 119.5n) ? (50n > (((60n) - 0) + 60n) ? 50n : (((60n) - 0) + 60n)) + 5e-08 : (100n > (((60n) - 0) + 80n) ? 100n : (((60n) - 0) + 80n))+60n)) - ((1u) * (1u) / (((((360n) / (ceil(((360n) - 5p) / (10u)))) < 119.5n) ? (50n > (((60n) - 0) + 60n) ? 50n : (((60n) - 0) + 60n)) + 5e-08 : (100n > (((60n) - 0) + 80n) ? 100n : (((60n) - 0) + 80n))+60n)+(45n)))) + ((1u) * (1u) / ((((360n) / (ceil(((360n) - 5p) / (10u)))) < 119.5n) ? (50n > (((60n) - 0) + 60n) ? 50n : (((60n) - 0) + 60n)) + 5e-08 : (100n > (((60n) - 0) + 80n) ? 100n : (((60n) - 0) + 80n))+60n)) - ((1u) * (1u)/ (((((360n) / (ceil(((360n) - 5p) / (10u)))) < 119.5n) ? (50n > (((60n) - 0) + 60n) ? 50n : (((60n) - 0) + 60n)) + 5e-08 : (100n > (((60n) - 0) + 80n) ? 100n : (((60n) - 0) + 80n))+60n)+(45n))))) + ( (45n) * ( (((1u) * (1u) / (60n)) - ((1u) * (1u) / ((60n)+((360n) / (ceil(((360n) - 5p) / (10u))))))) + ((1u) * (1u) / (60n)) - ((1u) * (1u)/ ((60n)+((360n) / (ceil(((360n) - 5p) / (10u))))))))) / (((360n) / (ceil(((360n) - 5p) / (10u)))) * (45n))           scb=((((360n) / (ceil(((360n) - 5p) / (10u)))) * ((((((360n) / (ceil(((360n) - 5p) / (10u)))) < 119.5n) ? (50n > (((60n) - 0) + 60n) ? 50n : (((60n) - 0) + 60n)) + 5e-08 : (100n > (((60n) - 0) + 80n) ? 100n : (((60n) - 0) + 80n))+60n)/10 + (1u)/100)*exp(-10 * ((((360n) / (ceil(((360n) - 5p) / (10u)))) < 119.5n) ? (50n > (((60n) - 0) + 60n) ? 50n : (((60n) - 0) + 60n)) + 5e-08 : (100n > (((60n) - 0) + 80n) ? 100n : (((60n) - 0) + 80n))+60n) / (1u)) - ((((((360n) / (ceil(((360n) - 5p) / (10u)))) < 119.5n) ? (50n > (((60n) - 0) + 60n) ? 50n : (((60n) - 0) + 60n)) + 5e-08 : (100n > (((60n) - 0) + 80n) ? 100n : (((60n) - 0) + 80n))+60n)+(45n))/10 + (1u)/100)*exp(-10 * (((((360n) / (ceil(((360n) - 5p) / (10u)))) < 119.5n) ? (50n > (((60n) - 0) + 60n) ? 50n : (((60n) - 0) + 60n)) + 5e-08 : (100n > (((60n) - 0) + 80n) ? 100n : (((60n) - 0) + 80n))+60n)+(45n)) / (1u)) + (((((360n) / (ceil(((360n) - 5p) / (10u)))) < 119.5n) ? (50n > (((60n) - 0) + 60n) ? 50n : (((60n) - 0) + 60n)) + 5e-08 : (100n > (((60n) - 0) + 80n) ? 100n : (((60n) - 0) + 80n))+60n)/10 + (1u)/100)*exp(-10 * ((((360n) / (ceil(((360n) - 5p) / (10u)))) < 119.5n) ? (50n > (((60n) - 0) + 60n) ? 50n : (((60n) - 0) + 60n)) + 5e-08 : (100n > (((60n) - 0) + 80n) ? 100n : (((60n) - 0) + 80n))+60n) / (1u)) - ((((((360n) / (ceil(((360n) - 5p) / (10u)))) < 119.5n) ? (50n > (((60n) - 0) + 60n) ? 50n : (((60n) - 0) + 60n)) + 5e-08 : (100n > (((60n) - 0) + 80n) ? 100n : (((60n) - 0) + 80n))+60n)+(45n))/10 + (1u)/100)*exp(-10 * (((((360n) / (ceil(((360n) - 5p) / (10u)))) < 119.5n) ? (50n > (((60n) - 0) + 60n) ? 50n : (((60n) - 0) + 60n)) + 5e-08 : (100n > (((60n) - 0) + 80n) ? 100n : (((60n) - 0) + 80n))+60n)+(45n)) / (1u)))) + ((45n) * (((60n)/10 + (1u)/100)*exp(-10 * (60n) / (1u)) - (((60n)+((360n) / (ceil(((360n) - 5p) / (10u)))))/10 + (1u)/100)*exp(-10 * ((60n)+((360n) / (ceil(((360n) - 5p) / (10u))))) / (1u)) + ((60n)/10 + (1u)/100)*exp(-10 * (60n) / (1u)) - (((60n)+((360n) / (ceil(((360n) - 5p) / (10u)))))/10 + (1u)/100)*exp(-10 * ((60n)+((360n) / (ceil(((360n) - 5p) / (10u))))) / (1u))))) / (((360n) / (ceil(((360n) - 5p) / (10u)))) * (45n))           scc=((((360n) / (ceil(((360n) - 5p) / (10u)))) * ((((((360n) / (ceil(((360n) - 5p) / (10u)))) < 119.5n) ? (50n > (((60n) - 0) + 60n) ? 50n : (((60n) - 0) + 60n)) + 5e-08 : (100n > (((60n) - 0) + 80n) ? 100n : (((60n) - 0) + 80n))+60n)/20 + (1u)/400)*exp(-20 * ((((360n) / (ceil(((360n) - 5p) / (10u)))) < 119.5n) ? (50n > (((60n) - 0) + 60n) ? 50n : (((60n) - 0) + 60n)) + 5e-08 : (100n > (((60n) - 0) + 80n) ? 100n : (((60n) - 0) + 80n))+60n) / (1u)) - ((((((360n) / (ceil(((360n) - 5p) / (10u)))) < 119.5n) ? (50n > (((60n) - 0) + 60n) ? 50n : (((60n) - 0) + 60n)) + 5e-08 : (100n > (((60n) - 0) + 80n) ? 100n : (((60n) - 0) + 80n))+60n)+(45n))/20 + (1u)/400)*exp(-20 * (((((360n) / (ceil(((360n) - 5p) / (10u)))) < 119.5n) ? (50n > (((60n) - 0) + 60n) ? 50n : (((60n) - 0) + 60n)) + 5e-08 : (100n > (((60n) - 0) + 80n) ? 100n : (((60n) - 0) + 80n))+60n)+(45n)) / (1u)) + (((((360n) / (ceil(((360n) - 5p) / (10u)))) < 119.5n) ? (50n > (((60n) - 0) + 60n) ? 50n : (((60n) - 0) + 60n)) + 5e-08 : (100n > (((60n) - 0) + 80n) ? 100n : (((60n) - 0) + 80n))+60n)/20 + (1u)/400)*exp(-20 * ((((360n) / (ceil(((360n) - 5p) / (10u)))) < 119.5n) ? (50n > (((60n) - 0) + 60n) ? 50n : (((60n) - 0) + 60n)) + 5e-08 : (100n > (((60n) - 0) + 80n) ? 100n : (((60n) - 0) + 80n))+60n) / (1u)) - ((((((360n) / (ceil(((360n) - 5p) / (10u)))) < 119.5n) ? (50n > (((60n) - 0) + 60n) ? 50n : (((60n) - 0) + 60n)) + 5e-08 : (100n > (((60n) - 0) + 80n) ? 100n : (((60n) - 0) + 80n))+60n)+(45n))/20 + (1u)/400)*exp(-20 * (((((360n) / (ceil(((360n) - 5p) / (10u)))) < 119.5n) ? (50n > (((60n) - 0) + 60n) ? 50n : (((60n) - 0) + 60n)) + 5e-08 : (100n > (((60n) - 0) + 80n) ? 100n : (((60n) - 0) + 80n))+60n)+(45n)) / (1u)))) + ((45n) * (((60n)/20 + (1u)/400)*exp(-20 * (60n) / (1u)) - (((60n)+((360n) / (ceil(((360n) - 5p) / (10u)))))/20 + (1u)/400)*exp(-20 * ((60n)+((360n) / (ceil(((360n) - 5p) / (10u))))) / (1u)) + ((60n)/20 + (1u)/400)*exp(-20 * (60n) / (1u)) - (((60n)+((360n) / (ceil(((360n) - 5p) / (10u)))))/20 + (1u)/400)*exp(-20 * ((60n)+((360n) / (ceil(((360n) - 5p) / (10u))))) / (1u))))) / (((360n) / (ceil(((360n) - 5p) / (10u)))) * (45n))           m=(1)
ends
subckt nand3 (A B E Y VDD GND)
NM0 (Y A n1 GND) g45n1svt w=(1080n) l=45n nf=ceil(((1080n) - 5p) / (10u))           as=(((1080n) / (ceil(((1080n) - 5p) / (10u)))) < 119.5n) ? ((((50n > (((60n) - 0) + 60n) ? 50n : (((60n) - 0) + 60n)) * 120n) + (((1080n) / (ceil(((1080n) - 5p) / (10u)))) * 50n)) + (floor(((ceil(((1080n) - 5p) / (10u))) - 1) / 2.0) * (((((60n) - 0) + 60n) * 120n) + (((1080n) / (ceil(((1080n) - 5p) / (10u)))) * 100n))) + ((((ceil(((1080n) - 5p) / (10u))) / 2) - floor((ceil(((1080n) - 5p) / (10u))) / 2) == 0) ? (((50n > (((60n) - 0) + 60n) ? 50n : (((60n) - 0) + 60n)) * 120n) + (((1080n) / (ceil(((1080n) - 5p) / (10u)))) * 50n)) : 0)) / 1 : (((100n > (((60n) - 0) + 80n) ? 100n : (((60n) - 0) + 80n)) * ((1080n) / (ceil(((1080n) - 5p) / (10u))))) + (floor(((ceil(((1080n) - 5p) / (10u))) - 1) / 2.0) * ((60n > (((60n) - 0) + 50n) ? 60n : (((60n) - 0) + 50n)) * ((1080n) / (ceil(((1080n) - 5p) / (10u)))))) + ((((ceil(((1080n) - 5p) / (10u))) / 2) - floor((ceil(((1080n) - 5p) / (10u))) / 2) == 0) ? ((100n > (((60n) - 0) + 80n) ? 100n : (((60n) - 0) + 80n)) * ((1080n) / (ceil(((1080n) - 5p) / (10u))))) : 0)) / 1           ad=(((1080n) / (ceil(((1080n) - 5p) / (10u)))) < 119.5n) ? ((floor((ceil(((1080n) - 5p) / (10u))) / 2.0) * (((((60n) - 0) + 60n) * 120n) + (((1080n) / (ceil(((1080n) - 5p) / (10u)))) * 100n))) + ((((ceil(((1080n) - 5p) / (10u))) / 2) - floor((ceil(((1080n) - 5p) / (10u))) / 2) != 0) ? (((50n > (((60n) - 0) + 60n) ? 50n : (((60n) - 0) + 60n)) * 120n) + (((1080n) / (ceil(((1080n) - 5p) / (10u)))) * 50n)) : 0)) / 1 : ((floor((ceil(((1080n) - 5p) / (10u))) / 2.0) * ((60n > (((60n) - 0) + 50n) ? 60n : (((60n) - 0) + 50n)) * ((1080n) / (ceil(((1080n) - 5p) / (10u)))))) + ((((ceil(((1080n) - 5p) / (10u))) / 2) - floor((ceil(((1080n) - 5p) / (10u))) / 2) != 0) ? ((100n > (((60n) - 0) + 80n) ? 100n : (((60n) - 0) + 80n)) * ((1080n) / (ceil(((1080n) - 5p) / (10u))))) : 0)) / 1           ps=(((1080n) / (ceil(((1080n) - 5p) / (10u)))) < 119.5n) ? (((2 * (50n > (((60n) - 0) + 60n) ? 50n : (((60n) - 0) + 60n))) + 340n) + (floor(((ceil(((1080n) - 5p) / (10u))) - 1) / 2.0) * ((2 * (((60n) - 0) + 60n)) + 440n)) + ((((ceil(((1080n) - 5p) / (10u))) / 2) - floor((ceil(((1080n) - 5p) / (10u))) / 2) == 0) ? ((2 * (50n > (((60n) - 0) + 60n) ? 50n : (((60n) - 0) + 60n))) + 340n) : 0)) / 1 : (((2 * (100n > (((60n) - 0) + 80n) ? 100n : (((60n) - 0) + 80n))) + (2 * ((1080n) / (ceil(((1080n) - 5p) / (10u)))))) + (floor(((ceil(((1080n) - 5p) / (10u))) - 1) / 2.0) * ((2 * (60n > (((60n) - 0) + 50n) ? 60n : (((60n) - 0) + 50n))) + (2 * ((1080n) / (ceil(((1080n) - 5p) / (10u))))))) + ((((ceil(((1080n) - 5p) / (10u))) / 2) - floor((ceil(((1080n) - 5p) / (10u))) / 2) == 0) ? ((2 * (100n > (((60n) - 0) + 80n) ? 100n : (((60n) - 0) + 80n))) + (2 * ((1080n) / (ceil(((1080n) - 5p) / (10u)))))) : 0)) / 1           pd=(((1080n) / (ceil(((1080n) - 5p) / (10u)))) < 119.5n) ? ((floor((ceil(((1080n) - 5p) / (10u))) / 2.0) * ((2 * (((60n) - 0) + 60n)) + 440n)) + ((((ceil(((1080n) - 5p) / (10u))) / 2) - floor((ceil(((1080n) - 5p) / (10u))) / 2) != 0) ? ((2 * (50n > (((60n) - 0) + 60n) ? 50n : (((60n) - 0) + 60n))) + 340n) : 0)) / 1 : ((floor((ceil(((1080n) - 5p) / (10u))) / 2.0) * ((2 * (60n > (((60n) - 0) + 50n) ? 60n : (((60n) - 0) + 50n))) + (2 * ((1080n) / (ceil(((1080n) - 5p) / (10u))))))) + ((((ceil(((1080n) - 5p) / (10u))) / 2) - floor((ceil(((1080n) - 5p) / (10u))) / 2) != 0) ? ((2 * (100n > (((60n) - 0) + 80n) ? 100n : (((60n) - 0) + 80n))) + (2 * ((1080n) / (ceil(((1080n) - 5p) / (10u)))))) : 0)) / 1           nrd=(((1080n) / (ceil(((1080n) - 5p) / (10u)))) < 119.5n) ? ((floor((ceil(((1080n) - 5p) / (10u))) / 2.0) * (((((60n) - 0) + 60n) * 120n) + (((1080n) / (ceil(((1080n) - 5p) / (10u)))) * 100n))) + ((((ceil(((1080n) - 5p) / (10u))) / 2) - floor((ceil(((1080n) - 5p) / (10u))) / 2) != 0) ? (((50n > (((60n) - 0) + 60n) ? 50n : (((60n) - 0) + 60n)) * 120n) + (((1080n) / (ceil(((1080n) - 5p) / (10u)))) * 50n)) : 0)) / 1 : ((floor((ceil(((1080n) - 5p) / (10u))) / 2.0) * ((60n > (((60n) - 0) + 50n) ? 60n : (((60n) - 0) + 50n)) * ((1080n) / (ceil(((1080n) - 5p) / (10u)))))) + ((((ceil(((1080n) - 5p) / (10u))) / 2) - floor((ceil(((1080n) - 5p) / (10u))) / 2) != 0) ? ((100n > (((60n) - 0) + 80n) ? 100n : (((60n) - 0) + 80n)) * ((1080n) / (ceil(((1080n) - 5p) / (10u))))) : 0)) / 1 / (((1080n) / (ceil(((1080n) - 5p) / (10u)))) * (ceil(((1080n) - 5p) / (10u))) * ((1080n) / (ceil(((1080n) - 5p) / (10u)))) * (ceil(((1080n) - 5p) / (10u))))           nrs=(((1080n) / (ceil(((1080n) - 5p) / (10u)))) < 119.5n) ? ((((50n > (((60n) - 0) + 60n) ? 50n : (((60n) - 0) + 60n)) * 120n) + (((1080n) / (ceil(((1080n) - 5p) / (10u)))) * 50n)) + (floor(((ceil(((1080n) - 5p) / (10u))) - 1) / 2.0) * (((((60n) - 0) + 60n) * 120n) + (((1080n) / (ceil(((1080n) - 5p) / (10u)))) * 100n))) + ((((ceil(((1080n) - 5p) / (10u))) / 2) - floor((ceil(((1080n) - 5p) / (10u))) / 2) == 0) ? (((50n > (((60n) - 0) + 60n) ? 50n : (((60n) - 0) + 60n)) * 120n) + (((1080n) / (ceil(((1080n) - 5p) / (10u)))) * 50n)) : 0)) / 1 : (((100n > (((60n) - 0) + 80n) ? 100n : (((60n) - 0) + 80n)) * ((1080n) / (ceil(((1080n) - 5p) / (10u))))) + (floor(((ceil(((1080n) - 5p) / (10u))) - 1) / 2.0) * ((60n > (((60n) - 0) + 50n) ? 60n : (((60n) - 0) + 50n)) * ((1080n) / (ceil(((1080n) - 5p) / (10u)))))) + ((((ceil(((1080n) - 5p) / (10u))) / 2) - floor((ceil(((1080n) - 5p) / (10u))) / 2) == 0) ? ((100n > (((60n) - 0) + 80n) ? 100n : (((60n) - 0) + 80n)) * ((1080n) / (ceil(((1080n) - 5p) / (10u))))) : 0)) / 1 / (((1080n) / (ceil(((1080n) - 5p) / (10u)))) * (ceil(((1080n) - 5p) / (10u))) * ((1080n) / (ceil(((1080n) - 5p) / (10u)))) * (ceil(((1080n) - 5p) / (10u))))           sa=(((1080n) / (ceil(((1080n) - 5p) / (10u)))) < 119.5n) ? (50n > (((60n) - 0) + 60n) ? 50n : (((60n) - 0) + 60n)) + 5e-08 : (100n > (((60n) - 0) + 80n) ? 100n : (((60n) - 0) + 80n))           sb=(((1080n) / (ceil(((1080n) - 5p) / (10u)))) < 119.5n) ? (50n > (((60n) - 0) + 60n) ? 50n : (((60n) - 0) + 60n)) + 5e-08 : (100n > (((60n) - 0) + 80n) ? 100n : (((60n) - 0) + 80n))           sd=(((1080n) / (ceil(((1080n) - 5p) / (10u)))) < 119.5n) ? (((60n) - 0) + 60n) + (2*5e-08) : (60n > (((60n) - 0) + 50n) ? 60n : (((60n) - 0) + 50n))           sca=(( ((1080n) / (ceil(((1080n) - 5p) / (10u)))) * ( (((1u) * (1u) / ((((1080n) / (ceil(((1080n) - 5p) / (10u)))) < 119.5n) ? (50n > (((60n) - 0) + 60n) ? 50n : (((60n) - 0) + 60n)) + 5e-08 : (100n > (((60n) - 0) + 80n) ? 100n : (((60n) - 0) + 80n))+60n)) - ((1u) * (1u) / (((((1080n) / (ceil(((1080n) - 5p) / (10u)))) < 119.5n) ? (50n > (((60n) - 0) + 60n) ? 50n : (((60n) - 0) + 60n)) + 5e-08 : (100n > (((60n) - 0) + 80n) ? 100n : (((60n) - 0) + 80n))+60n)+(45n)))) + ((1u) * (1u) / ((((1080n) / (ceil(((1080n) - 5p) / (10u)))) < 119.5n) ? (50n > (((60n) - 0) + 60n) ? 50n : (((60n) - 0) + 60n)) + 5e-08 : (100n > (((60n) - 0) + 80n) ? 100n : (((60n) - 0) + 80n))+60n)) - ((1u) * (1u)/ (((((1080n) / (ceil(((1080n) - 5p) / (10u)))) < 119.5n) ? (50n > (((60n) - 0) + 60n) ? 50n : (((60n) - 0) + 60n)) + 5e-08 : (100n > (((60n) - 0) + 80n) ? 100n : (((60n) - 0) + 80n))+60n)+(45n))))) + ( (45n) * ( (((1u) * (1u) / (60n)) - ((1u) * (1u) / ((60n)+((1080n) / (ceil(((1080n) - 5p) / (10u))))))) + ((1u) * (1u) / (60n)) - ((1u) * (1u)/ ((60n)+((1080n) / (ceil(((1080n) - 5p) / (10u))))))))) / (((1080n) / (ceil(((1080n) - 5p) / (10u)))) * (45n))           scb=((((1080n) / (ceil(((1080n) - 5p) / (10u)))) * ((((((1080n) / (ceil(((1080n) - 5p) / (10u)))) < 119.5n) ? (50n > (((60n) - 0) + 60n) ? 50n : (((60n) - 0) + 60n)) + 5e-08 : (100n > (((60n) - 0) + 80n) ? 100n : (((60n) - 0) + 80n))+60n)/10 + (1u)/100)*exp(-10 * ((((1080n) / (ceil(((1080n) - 5p) / (10u)))) < 119.5n) ? (50n > (((60n) - 0) + 60n) ? 50n : (((60n) - 0) + 60n)) + 5e-08 : (100n > (((60n) - 0) + 80n) ? 100n : (((60n) - 0) + 80n))+60n) / (1u)) - ((((((1080n) / (ceil(((1080n) - 5p) / (10u)))) < 119.5n) ? (50n > (((60n) - 0) + 60n) ? 50n : (((60n) - 0) + 60n)) + 5e-08 : (100n > (((60n) - 0) + 80n) ? 100n : (((60n) - 0) + 80n))+60n)+(45n))/10 + (1u)/100)*exp(-10 * (((((1080n) / (ceil(((1080n) - 5p) / (10u)))) < 119.5n) ? (50n > (((60n) - 0) + 60n) ? 50n : (((60n) - 0) + 60n)) + 5e-08 : (100n > (((60n) - 0) + 80n) ? 100n : (((60n) - 0) + 80n))+60n)+(45n)) / (1u)) + (((((1080n) / (ceil(((1080n) - 5p) / (10u)))) < 119.5n) ? (50n > (((60n) - 0) + 60n) ? 50n : (((60n) - 0) + 60n)) + 5e-08 : (100n > (((60n) - 0) + 80n) ? 100n : (((60n) - 0) + 80n))+60n)/10 + (1u)/100)*exp(-10 * ((((1080n) / (ceil(((1080n) - 5p) / (10u)))) < 119.5n) ? (50n > (((60n) - 0) + 60n) ? 50n : (((60n) - 0) + 60n)) + 5e-08 : (100n > (((60n) - 0) + 80n) ? 100n : (((60n) - 0) + 80n))+60n) / (1u)) - ((((((1080n) / (ceil(((1080n) - 5p) / (10u)))) < 119.5n) ? (50n > (((60n) - 0) + 60n) ? 50n : (((60n) - 0) + 60n)) + 5e-08 : (100n > (((60n) - 0) + 80n) ? 100n : (((60n) - 0) + 80n))+60n)+(45n))/10 + (1u)/100)*exp(-10 * (((((1080n) / (ceil(((1080n) - 5p) / (10u)))) < 119.5n) ? (50n > (((60n) - 0) + 60n) ? 50n : (((60n) - 0) + 60n)) + 5e-08 : (100n > (((60n) - 0) + 80n) ? 100n : (((60n) - 0) + 80n))+60n)+(45n)) / (1u)))) + ((45n) * (((60n)/10 + (1u)/100)*exp(-10 * (60n) / (1u)) - (((60n)+((1080n) / (ceil(((1080n) - 5p) / (10u)))))/10 + (1u)/100)*exp(-10 * ((60n)+((1080n) / (ceil(((1080n) - 5p) / (10u))))) / (1u)) + ((60n)/10 + (1u)/100)*exp(-10 * (60n) / (1u)) - (((60n)+((1080n) / (ceil(((1080n) - 5p) / (10u)))))/10 + (1u)/100)*exp(-10 * ((60n)+((1080n) / (ceil(((1080n) - 5p) / (10u))))) / (1u))))) / (((1080n) / (ceil(((1080n) - 5p) / (10u)))) * (45n))           scc=((((1080n) / (ceil(((1080n) - 5p) / (10u)))) * ((((((1080n) / (ceil(((1080n) - 5p) / (10u)))) < 119.5n) ? (50n > (((60n) - 0) + 60n) ? 50n : (((60n) - 0) + 60n)) + 5e-08 : (100n > (((60n) - 0) + 80n) ? 100n : (((60n) - 0) + 80n))+60n)/20 + (1u)/400)*exp(-20 * ((((1080n) / (ceil(((1080n) - 5p) / (10u)))) < 119.5n) ? (50n > (((60n) - 0) + 60n) ? 50n : (((60n) - 0) + 60n)) + 5e-08 : (100n > (((60n) - 0) + 80n) ? 100n : (((60n) - 0) + 80n))+60n) / (1u)) - ((((((1080n) / (ceil(((1080n) - 5p) / (10u)))) < 119.5n) ? (50n > (((60n) - 0) + 60n) ? 50n : (((60n) - 0) + 60n)) + 5e-08 : (100n > (((60n) - 0) + 80n) ? 100n : (((60n) - 0) + 80n))+60n)+(45n))/20 + (1u)/400)*exp(-20 * (((((1080n) / (ceil(((1080n) - 5p) / (10u)))) < 119.5n) ? (50n > (((60n) - 0) + 60n) ? 50n : (((60n) - 0) + 60n)) + 5e-08 : (100n > (((60n) - 0) + 80n) ? 100n : (((60n) - 0) + 80n))+60n)+(45n)) / (1u)) + (((((1080n) / (ceil(((1080n) - 5p) / (10u)))) < 119.5n) ? (50n > (((60n) - 0) + 60n) ? 50n : (((60n) - 0) + 60n)) + 5e-08 : (100n > (((60n) - 0) + 80n) ? 100n : (((60n) - 0) + 80n))+60n)/20 + (1u)/400)*exp(-20 * ((((1080n) / (ceil(((1080n) - 5p) / (10u)))) < 119.5n) ? (50n > (((60n) - 0) + 60n) ? 50n : (((60n) - 0) + 60n)) + 5e-08 : (100n > (((60n) - 0) + 80n) ? 100n : (((60n) - 0) + 80n))+60n) / (1u)) - ((((((1080n) / (ceil(((1080n) - 5p) / (10u)))) < 119.5n) ? (50n > (((60n) - 0) + 60n) ? 50n : (((60n) - 0) + 60n)) + 5e-08 : (100n > (((60n) - 0) + 80n) ? 100n : (((60n) - 0) + 80n))+60n)+(45n))/20 + (1u)/400)*exp(-20 * (((((1080n) / (ceil(((1080n) - 5p) / (10u)))) < 119.5n) ? (50n > (((60n) - 0) + 60n) ? 50n : (((60n) - 0) + 60n)) + 5e-08 : (100n > (((60n) - 0) + 80n) ? 100n : (((60n) - 0) + 80n))+60n)+(45n)) / (1u)))) + ((45n) * (((60n)/20 + (1u)/400)*exp(-20 * (60n) / (1u)) - (((60n)+((1080n) / (ceil(((1080n) - 5p) / (10u)))))/20 + (1u)/400)*exp(-20 * ((60n)+((1080n) / (ceil(((1080n) - 5p) / (10u))))) / (1u)) + ((60n)/20 + (1u)/400)*exp(-20 * (60n) / (1u)) - (((60n)+((1080n) / (ceil(((1080n) - 5p) / (10u)))))/20 + (1u)/400)*exp(-20 * ((60n)+((1080n) / (ceil(((1080n) - 5p) / (10u))))) / (1u))))) / (((1080n) / (ceil(((1080n) - 5p) / (10u)))) * (45n))           m=(1)
NM1 (n1 B n2 GND) g45n1svt w=(1080n) l=45n nf=ceil(((1080n) - 5p) / (10u))           as=(((1080n) / (ceil(((1080n) - 5p) / (10u)))) < 119.5n) ? ((((50n > (((60n) - 0) + 60n) ? 50n : (((60n) - 0) + 60n)) * 120n) + (((1080n) / (ceil(((1080n) - 5p) / (10u)))) * 50n)) + (floor(((ceil(((1080n) - 5p) / (10u))) - 1) / 2.0) * (((((60n) - 0) + 60n) * 120n) + (((1080n) / (ceil(((1080n) - 5p) / (10u)))) * 100n))) + ((((ceil(((1080n) - 5p) / (10u))) / 2) - floor((ceil(((1080n) - 5p) / (10u))) / 2) == 0) ? (((50n > (((60n) - 0) + 60n) ? 50n : (((60n) - 0) + 60n)) * 120n) + (((1080n) / (ceil(((1080n) - 5p) / (10u)))) * 50n)) : 0)) / 1 : (((100n > (((60n) - 0) + 80n) ? 100n : (((60n) - 0) + 80n)) * ((1080n) / (ceil(((1080n) - 5p) / (10u))))) + (floor(((ceil(((1080n) - 5p) / (10u))) - 1) / 2.0) * ((60n > (((60n) - 0) + 50n) ? 60n : (((60n) - 0) + 50n)) * ((1080n) / (ceil(((1080n) - 5p) / (10u)))))) + ((((ceil(((1080n) - 5p) / (10u))) / 2) - floor((ceil(((1080n) - 5p) / (10u))) / 2) == 0) ? ((100n > (((60n) - 0) + 80n) ? 100n : (((60n) - 0) + 80n)) * ((1080n) / (ceil(((1080n) - 5p) / (10u))))) : 0)) / 1           ad=(((1080n) / (ceil(((1080n) - 5p) / (10u)))) < 119.5n) ? ((floor((ceil(((1080n) - 5p) / (10u))) / 2.0) * (((((60n) - 0) + 60n) * 120n) + (((1080n) / (ceil(((1080n) - 5p) / (10u)))) * 100n))) + ((((ceil(((1080n) - 5p) / (10u))) / 2) - floor((ceil(((1080n) - 5p) / (10u))) / 2) != 0) ? (((50n > (((60n) - 0) + 60n) ? 50n : (((60n) - 0) + 60n)) * 120n) + (((1080n) / (ceil(((1080n) - 5p) / (10u)))) * 50n)) : 0)) / 1 : ((floor((ceil(((1080n) - 5p) / (10u))) / 2.0) * ((60n > (((60n) - 0) + 50n) ? 60n : (((60n) - 0) + 50n)) * ((1080n) / (ceil(((1080n) - 5p) / (10u)))))) + ((((ceil(((1080n) - 5p) / (10u))) / 2) - floor((ceil(((1080n) - 5p) / (10u))) / 2) != 0) ? ((100n > (((60n) - 0) + 80n) ? 100n : (((60n) - 0) + 80n)) * ((1080n) / (ceil(((1080n) - 5p) / (10u))))) : 0)) / 1           ps=(((1080n) / (ceil(((1080n) - 5p) / (10u)))) < 119.5n) ? (((2 * (50n > (((60n) - 0) + 60n) ? 50n : (((60n) - 0) + 60n))) + 340n) + (floor(((ceil(((1080n) - 5p) / (10u))) - 1) / 2.0) * ((2 * (((60n) - 0) + 60n)) + 440n)) + ((((ceil(((1080n) - 5p) / (10u))) / 2) - floor((ceil(((1080n) - 5p) / (10u))) / 2) == 0) ? ((2 * (50n > (((60n) - 0) + 60n) ? 50n : (((60n) - 0) + 60n))) + 340n) : 0)) / 1 : (((2 * (100n > (((60n) - 0) + 80n) ? 100n : (((60n) - 0) + 80n))) + (2 * ((1080n) / (ceil(((1080n) - 5p) / (10u)))))) + (floor(((ceil(((1080n) - 5p) / (10u))) - 1) / 2.0) * ((2 * (60n > (((60n) - 0) + 50n) ? 60n : (((60n) - 0) + 50n))) + (2 * ((1080n) / (ceil(((1080n) - 5p) / (10u))))))) + ((((ceil(((1080n) - 5p) / (10u))) / 2) - floor((ceil(((1080n) - 5p) / (10u))) / 2) == 0) ? ((2 * (100n > (((60n) - 0) + 80n) ? 100n : (((60n) - 0) + 80n))) + (2 * ((1080n) / (ceil(((1080n) - 5p) / (10u)))))) : 0)) / 1           pd=(((1080n) / (ceil(((1080n) - 5p) / (10u)))) < 119.5n) ? ((floor((ceil(((1080n) - 5p) / (10u))) / 2.0) * ((2 * (((60n) - 0) + 60n)) + 440n)) + ((((ceil(((1080n) - 5p) / (10u))) / 2) - floor((ceil(((1080n) - 5p) / (10u))) / 2) != 0) ? ((2 * (50n > (((60n) - 0) + 60n) ? 50n : (((60n) - 0) + 60n))) + 340n) : 0)) / 1 : ((floor((ceil(((1080n) - 5p) / (10u))) / 2.0) * ((2 * (60n > (((60n) - 0) + 50n) ? 60n : (((60n) - 0) + 50n))) + (2 * ((1080n) / (ceil(((1080n) - 5p) / (10u))))))) + ((((ceil(((1080n) - 5p) / (10u))) / 2) - floor((ceil(((1080n) - 5p) / (10u))) / 2) != 0) ? ((2 * (100n > (((60n) - 0) + 80n) ? 100n : (((60n) - 0) + 80n))) + (2 * ((1080n) / (ceil(((1080n) - 5p) / (10u)))))) : 0)) / 1           nrd=(((1080n) / (ceil(((1080n) - 5p) / (10u)))) < 119.5n) ? ((floor((ceil(((1080n) - 5p) / (10u))) / 2.0) * (((((60n) - 0) + 60n) * 120n) + (((1080n) / (ceil(((1080n) - 5p) / (10u)))) * 100n))) + ((((ceil(((1080n) - 5p) / (10u))) / 2) - floor((ceil(((1080n) - 5p) / (10u))) / 2) != 0) ? (((50n > (((60n) - 0) + 60n) ? 50n : (((60n) - 0) + 60n)) * 120n) + (((1080n) / (ceil(((1080n) - 5p) / (10u)))) * 50n)) : 0)) / 1 : ((floor((ceil(((1080n) - 5p) / (10u))) / 2.0) * ((60n > (((60n) - 0) + 50n) ? 60n : (((60n) - 0) + 50n)) * ((1080n) / (ceil(((1080n) - 5p) / (10u)))))) + ((((ceil(((1080n) - 5p) / (10u))) / 2) - floor((ceil(((1080n) - 5p) / (10u))) / 2) != 0) ? ((100n > (((60n) - 0) + 80n) ? 100n : (((60n) - 0) + 80n)) * ((1080n) / (ceil(((1080n) - 5p) / (10u))))) : 0)) / 1 / (((1080n) / (ceil(((1080n) - 5p) / (10u)))) * (ceil(((1080n) - 5p) / (10u))) * ((1080n) / (ceil(((1080n) - 5p) / (10u)))) * (ceil(((1080n) - 5p) / (10u))))           nrs=(((1080n) / (ceil(((1080n) - 5p) / (10u)))) < 119.5n) ? ((((50n > (((60n) - 0) + 60n) ? 50n : (((60n) - 0) + 60n)) * 120n) + (((1080n) / (ceil(((1080n) - 5p) / (10u)))) * 50n)) + (floor(((ceil(((1080n) - 5p) / (10u))) - 1) / 2.0) * (((((60n) - 0) + 60n) * 120n) + (((1080n) / (ceil(((1080n) - 5p) / (10u)))) * 100n))) + ((((ceil(((1080n) - 5p) / (10u))) / 2) - floor((ceil(((1080n) - 5p) / (10u))) / 2) == 0) ? (((50n > (((60n) - 0) + 60n) ? 50n : (((60n) - 0) + 60n)) * 120n) + (((1080n) / (ceil(((1080n) - 5p) / (10u)))) * 50n)) : 0)) / 1 : (((100n > (((60n) - 0) + 80n) ? 100n : (((60n) - 0) + 80n)) * ((1080n) / (ceil(((1080n) - 5p) / (10u))))) + (floor(((ceil(((1080n) - 5p) / (10u))) - 1) / 2.0) * ((60n > (((60n) - 0) + 50n) ? 60n : (((60n) - 0) + 50n)) * ((1080n) / (ceil(((1080n) - 5p) / (10u)))))) + ((((ceil(((1080n) - 5p) / (10u))) / 2) - floor((ceil(((1080n) - 5p) / (10u))) / 2) == 0) ? ((100n > (((60n) - 0) + 80n) ? 100n : (((60n) - 0) + 80n)) * ((1080n) / (ceil(((1080n) - 5p) / (10u))))) : 0)) / 1 / (((1080n) / (ceil(((1080n) - 5p) / (10u)))) * (ceil(((1080n) - 5p) / (10u))) * ((1080n) / (ceil(((1080n) - 5p) / (10u)))) * (ceil(((1080n) - 5p) / (10u))))           sa=(((1080n) / (ceil(((1080n) - 5p) / (10u)))) < 119.5n) ? (50n > (((60n) - 0) + 60n) ? 50n : (((60n) - 0) + 60n)) + 5e-08 : (100n > (((60n) - 0) + 80n) ? 100n : (((60n) - 0) + 80n))           sb=(((1080n) / (ceil(((1080n) - 5p) / (10u)))) < 119.5n) ? (50n > (((60n) - 0) + 60n) ? 50n : (((60n) - 0) + 60n)) + 5e-08 : (100n > (((60n) - 0) + 80n) ? 100n : (((60n) - 0) + 80n))           sd=(((1080n) / (ceil(((1080n) - 5p) / (10u)))) < 119.5n) ? (((60n) - 0) + 60n) + (2*5e-08) : (60n > (((60n) - 0) + 50n) ? 60n : (((60n) - 0) + 50n))           sca=(( ((1080n) / (ceil(((1080n) - 5p) / (10u)))) * ( (((1u) * (1u) / ((((1080n) / (ceil(((1080n) - 5p) / (10u)))) < 119.5n) ? (50n > (((60n) - 0) + 60n) ? 50n : (((60n) - 0) + 60n)) + 5e-08 : (100n > (((60n) - 0) + 80n) ? 100n : (((60n) - 0) + 80n))+60n)) - ((1u) * (1u) / (((((1080n) / (ceil(((1080n) - 5p) / (10u)))) < 119.5n) ? (50n > (((60n) - 0) + 60n) ? 50n : (((60n) - 0) + 60n)) + 5e-08 : (100n > (((60n) - 0) + 80n) ? 100n : (((60n) - 0) + 80n))+60n)+(45n)))) + ((1u) * (1u) / ((((1080n) / (ceil(((1080n) - 5p) / (10u)))) < 119.5n) ? (50n > (((60n) - 0) + 60n) ? 50n : (((60n) - 0) + 60n)) + 5e-08 : (100n > (((60n) - 0) + 80n) ? 100n : (((60n) - 0) + 80n))+60n)) - ((1u) * (1u)/ (((((1080n) / (ceil(((1080n) - 5p) / (10u)))) < 119.5n) ? (50n > (((60n) - 0) + 60n) ? 50n : (((60n) - 0) + 60n)) + 5e-08 : (100n > (((60n) - 0) + 80n) ? 100n : (((60n) - 0) + 80n))+60n)+(45n))))) + ( (45n) * ( (((1u) * (1u) / (60n)) - ((1u) * (1u) / ((60n)+((1080n) / (ceil(((1080n) - 5p) / (10u))))))) + ((1u) * (1u) / (60n)) - ((1u) * (1u)/ ((60n)+((1080n) / (ceil(((1080n) - 5p) / (10u))))))))) / (((1080n) / (ceil(((1080n) - 5p) / (10u)))) * (45n))           scb=((((1080n) / (ceil(((1080n) - 5p) / (10u)))) * ((((((1080n) / (ceil(((1080n) - 5p) / (10u)))) < 119.5n) ? (50n > (((60n) - 0) + 60n) ? 50n : (((60n) - 0) + 60n)) + 5e-08 : (100n > (((60n) - 0) + 80n) ? 100n : (((60n) - 0) + 80n))+60n)/10 + (1u)/100)*exp(-10 * ((((1080n) / (ceil(((1080n) - 5p) / (10u)))) < 119.5n) ? (50n > (((60n) - 0) + 60n) ? 50n : (((60n) - 0) + 60n)) + 5e-08 : (100n > (((60n) - 0) + 80n) ? 100n : (((60n) - 0) + 80n))+60n) / (1u)) - ((((((1080n) / (ceil(((1080n) - 5p) / (10u)))) < 119.5n) ? (50n > (((60n) - 0) + 60n) ? 50n : (((60n) - 0) + 60n)) + 5e-08 : (100n > (((60n) - 0) + 80n) ? 100n : (((60n) - 0) + 80n))+60n)+(45n))/10 + (1u)/100)*exp(-10 * (((((1080n) / (ceil(((1080n) - 5p) / (10u)))) < 119.5n) ? (50n > (((60n) - 0) + 60n) ? 50n : (((60n) - 0) + 60n)) + 5e-08 : (100n > (((60n) - 0) + 80n) ? 100n : (((60n) - 0) + 80n))+60n)+(45n)) / (1u)) + (((((1080n) / (ceil(((1080n) - 5p) / (10u)))) < 119.5n) ? (50n > (((60n) - 0) + 60n) ? 50n : (((60n) - 0) + 60n)) + 5e-08 : (100n > (((60n) - 0) + 80n) ? 100n : (((60n) - 0) + 80n))+60n)/10 + (1u)/100)*exp(-10 * ((((1080n) / (ceil(((1080n) - 5p) / (10u)))) < 119.5n) ? (50n > (((60n) - 0) + 60n) ? 50n : (((60n) - 0) + 60n)) + 5e-08 : (100n > (((60n) - 0) + 80n) ? 100n : (((60n) - 0) + 80n))+60n) / (1u)) - ((((((1080n) / (ceil(((1080n) - 5p) / (10u)))) < 119.5n) ? (50n > (((60n) - 0) + 60n) ? 50n : (((60n) - 0) + 60n)) + 5e-08 : (100n > (((60n) - 0) + 80n) ? 100n : (((60n) - 0) + 80n))+60n)+(45n))/10 + (1u)/100)*exp(-10 * (((((1080n) / (ceil(((1080n) - 5p) / (10u)))) < 119.5n) ? (50n > (((60n) - 0) + 60n) ? 50n : (((60n) - 0) + 60n)) + 5e-08 : (100n > (((60n) - 0) + 80n) ? 100n : (((60n) - 0) + 80n))+60n)+(45n)) / (1u)))) + ((45n) * (((60n)/10 + (1u)/100)*exp(-10 * (60n) / (1u)) - (((60n)+((1080n) / (ceil(((1080n) - 5p) / (10u)))))/10 + (1u)/100)*exp(-10 * ((60n)+((1080n) / (ceil(((1080n) - 5p) / (10u))))) / (1u)) + ((60n)/10 + (1u)/100)*exp(-10 * (60n) / (1u)) - (((60n)+((1080n) / (ceil(((1080n) - 5p) / (10u)))))/10 + (1u)/100)*exp(-10 * ((60n)+((1080n) / (ceil(((1080n) - 5p) / (10u))))) / (1u))))) / (((1080n) / (ceil(((1080n) - 5p) / (10u)))) * (45n))           scc=((((1080n) / (ceil(((1080n) - 5p) / (10u)))) * ((((((1080n) / (ceil(((1080n) - 5p) / (10u)))) < 119.5n) ? (50n > (((60n) - 0) + 60n) ? 50n : (((60n) - 0) + 60n)) + 5e-08 : (100n > (((60n) - 0) + 80n) ? 100n : (((60n) - 0) + 80n))+60n)/20 + (1u)/400)*exp(-20 * ((((1080n) / (ceil(((1080n) - 5p) / (10u)))) < 119.5n) ? (50n > (((60n) - 0) + 60n) ? 50n : (((60n) - 0) + 60n)) + 5e-08 : (100n > (((60n) - 0) + 80n) ? 100n : (((60n) - 0) + 80n))+60n) / (1u)) - ((((((1080n) / (ceil(((1080n) - 5p) / (10u)))) < 119.5n) ? (50n > (((60n) - 0) + 60n) ? 50n : (((60n) - 0) + 60n)) + 5e-08 : (100n > (((60n) - 0) + 80n) ? 100n : (((60n) - 0) + 80n))+60n)+(45n))/20 + (1u)/400)*exp(-20 * (((((1080n) / (ceil(((1080n) - 5p) / (10u)))) < 119.5n) ? (50n > (((60n) - 0) + 60n) ? 50n : (((60n) - 0) + 60n)) + 5e-08 : (100n > (((60n) - 0) + 80n) ? 100n : (((60n) - 0) + 80n))+60n)+(45n)) / (1u)) + (((((1080n) / (ceil(((1080n) - 5p) / (10u)))) < 119.5n) ? (50n > (((60n) - 0) + 60n) ? 50n : (((60n) - 0) + 60n)) + 5e-08 : (100n > (((60n) - 0) + 80n) ? 100n : (((60n) - 0) + 80n))+60n)/20 + (1u)/400)*exp(-20 * ((((1080n) / (ceil(((1080n) - 5p) / (10u)))) < 119.5n) ? (50n > (((60n) - 0) + 60n) ? 50n : (((60n) - 0) + 60n)) + 5e-08 : (100n > (((60n) - 0) + 80n) ? 100n : (((60n) - 0) + 80n))+60n) / (1u)) - ((((((1080n) / (ceil(((1080n) - 5p) / (10u)))) < 119.5n) ? (50n > (((60n) - 0) + 60n) ? 50n : (((60n) - 0) + 60n)) + 5e-08 : (100n > (((60n) - 0) + 80n) ? 100n : (((60n) - 0) + 80n))+60n)+(45n))/20 + (1u)/400)*exp(-20 * (((((1080n) / (ceil(((1080n) - 5p) / (10u)))) < 119.5n) ? (50n > (((60n) - 0) + 60n) ? 50n : (((60n) - 0) + 60n)) + 5e-08 : (100n > (((60n) - 0) + 80n) ? 100n : (((60n) - 0) + 80n))+60n)+(45n)) / (1u)))) + ((45n) * (((60n)/20 + (1u)/400)*exp(-20 * (60n) / (1u)) - (((60n)+((1080n) / (ceil(((1080n) - 5p) / (10u)))))/20 + (1u)/400)*exp(-20 * ((60n)+((1080n) / (ceil(((1080n) - 5p) / (10u))))) / (1u)) + ((60n)/20 + (1u)/400)*exp(-20 * (60n) / (1u)) - (((60n)+((1080n) / (ceil(((1080n) - 5p) / (10u)))))/20 + (1u)/400)*exp(-20 * ((60n)+((1080n) / (ceil(((1080n) - 5p) / (10u))))) / (1u))))) / (((1080n) / (ceil(((1080n) - 5p) / (10u)))) * (45n))           m=(1)
NM2 (n2 E GND GND) g45n1svt w=(1080n) l=45n nf=ceil(((1080n) - 5p) / (10u))           as=(((1080n) / (ceil(((1080n) - 5p) / (10u)))) < 119.5n) ? ((((50n > (((60n) - 0) + 60n) ? 50n : (((60n) - 0) + 60n)) * 120n) + (((1080n) / (ceil(((1080n) - 5p) / (10u)))) * 50n)) + (floor(((ceil(((1080n) - 5p) / (10u))) - 1) / 2.0) * (((((60n) - 0) + 60n) * 120n) + (((1080n) / (ceil(((1080n) - 5p) / (10u)))) * 100n))) + ((((ceil(((1080n) - 5p) / (10u))) / 2) - floor((ceil(((1080n) - 5p) / (10u))) / 2) == 0) ? (((50n > (((60n) - 0) + 60n) ? 50n : (((60n) - 0) + 60n)) * 120n) + (((1080n) / (ceil(((1080n) - 5p) / (10u)))) * 50n)) : 0)) / 1 : (((100n > (((60n) - 0) + 80n) ? 100n : (((60n) - 0) + 80n)) * ((1080n) / (ceil(((1080n) - 5p) / (10u))))) + (floor(((ceil(((1080n) - 5p) / (10u))) - 1) / 2.0) * ((60n > (((60n) - 0) + 50n) ? 60n : (((60n) - 0) + 50n)) * ((1080n) / (ceil(((1080n) - 5p) / (10u)))))) + ((((ceil(((1080n) - 5p) / (10u))) / 2) - floor((ceil(((1080n) - 5p) / (10u))) / 2) == 0) ? ((100n > (((60n) - 0) + 80n) ? 100n : (((60n) - 0) + 80n)) * ((1080n) / (ceil(((1080n) - 5p) / (10u))))) : 0)) / 1           ad=(((1080n) / (ceil(((1080n) - 5p) / (10u)))) < 119.5n) ? ((floor((ceil(((1080n) - 5p) / (10u))) / 2.0) * (((((60n) - 0) + 60n) * 120n) + (((1080n) / (ceil(((1080n) - 5p) / (10u)))) * 100n))) + ((((ceil(((1080n) - 5p) / (10u))) / 2) - floor((ceil(((1080n) - 5p) / (10u))) / 2) != 0) ? (((50n > (((60n) - 0) + 60n) ? 50n : (((60n) - 0) + 60n)) * 120n) + (((1080n) / (ceil(((1080n) - 5p) / (10u)))) * 50n)) : 0)) / 1 : ((floor((ceil(((1080n) - 5p) / (10u))) / 2.0) * ((60n > (((60n) - 0) + 50n) ? 60n : (((60n) - 0) + 50n)) * ((1080n) / (ceil(((1080n) - 5p) / (10u)))))) + ((((ceil(((1080n) - 5p) / (10u))) / 2) - floor((ceil(((1080n) - 5p) / (10u))) / 2) != 0) ? ((100n > (((60n) - 0) + 80n) ? 100n : (((60n) - 0) + 80n)) * ((1080n) / (ceil(((1080n) - 5p) / (10u))))) : 0)) / 1           ps=(((1080n) / (ceil(((1080n) - 5p) / (10u)))) < 119.5n) ? (((2 * (50n > (((60n) - 0) + 60n) ? 50n : (((60n) - 0) + 60n))) + 340n) + (floor(((ceil(((1080n) - 5p) / (10u))) - 1) / 2.0) * ((2 * (((60n) - 0) + 60n)) + 440n)) + ((((ceil(((1080n) - 5p) / (10u))) / 2) - floor((ceil(((1080n) - 5p) / (10u))) / 2) == 0) ? ((2 * (50n > (((60n) - 0) + 60n) ? 50n : (((60n) - 0) + 60n))) + 340n) : 0)) / 1 : (((2 * (100n > (((60n) - 0) + 80n) ? 100n : (((60n) - 0) + 80n))) + (2 * ((1080n) / (ceil(((1080n) - 5p) / (10u)))))) + (floor(((ceil(((1080n) - 5p) / (10u))) - 1) / 2.0) * ((2 * (60n > (((60n) - 0) + 50n) ? 60n : (((60n) - 0) + 50n))) + (2 * ((1080n) / (ceil(((1080n) - 5p) / (10u))))))) + ((((ceil(((1080n) - 5p) / (10u))) / 2) - floor((ceil(((1080n) - 5p) / (10u))) / 2) == 0) ? ((2 * (100n > (((60n) - 0) + 80n) ? 100n : (((60n) - 0) + 80n))) + (2 * ((1080n) / (ceil(((1080n) - 5p) / (10u)))))) : 0)) / 1           pd=(((1080n) / (ceil(((1080n) - 5p) / (10u)))) < 119.5n) ? ((floor((ceil(((1080n) - 5p) / (10u))) / 2.0) * ((2 * (((60n) - 0) + 60n)) + 440n)) + ((((ceil(((1080n) - 5p) / (10u))) / 2) - floor((ceil(((1080n) - 5p) / (10u))) / 2) != 0) ? ((2 * (50n > (((60n) - 0) + 60n) ? 50n : (((60n) - 0) + 60n))) + 340n) : 0)) / 1 : ((floor((ceil(((1080n) - 5p) / (10u))) / 2.0) * ((2 * (60n > (((60n) - 0) + 50n) ? 60n : (((60n) - 0) + 50n))) + (2 * ((1080n) / (ceil(((1080n) - 5p) / (10u))))))) + ((((ceil(((1080n) - 5p) / (10u))) / 2) - floor((ceil(((1080n) - 5p) / (10u))) / 2) != 0) ? ((2 * (100n > (((60n) - 0) + 80n) ? 100n : (((60n) - 0) + 80n))) + (2 * ((1080n) / (ceil(((1080n) - 5p) / (10u)))))) : 0)) / 1           nrd=(((1080n) / (ceil(((1080n) - 5p) / (10u)))) < 119.5n) ? ((floor((ceil(((1080n) - 5p) / (10u))) / 2.0) * (((((60n) - 0) + 60n) * 120n) + (((1080n) / (ceil(((1080n) - 5p) / (10u)))) * 100n))) + ((((ceil(((1080n) - 5p) / (10u))) / 2) - floor((ceil(((1080n) - 5p) / (10u))) / 2) != 0) ? (((50n > (((60n) - 0) + 60n) ? 50n : (((60n) - 0) + 60n)) * 120n) + (((1080n) / (ceil(((1080n) - 5p) / (10u)))) * 50n)) : 0)) / 1 : ((floor((ceil(((1080n) - 5p) / (10u))) / 2.0) * ((60n > (((60n) - 0) + 50n) ? 60n : (((60n) - 0) + 50n)) * ((1080n) / (ceil(((1080n) - 5p) / (10u)))))) + ((((ceil(((1080n) - 5p) / (10u))) / 2) - floor((ceil(((1080n) - 5p) / (10u))) / 2) != 0) ? ((100n > (((60n) - 0) + 80n) ? 100n : (((60n) - 0) + 80n)) * ((1080n) / (ceil(((1080n) - 5p) / (10u))))) : 0)) / 1 / (((1080n) / (ceil(((1080n) - 5p) / (10u)))) * (ceil(((1080n) - 5p) / (10u))) * ((1080n) / (ceil(((1080n) - 5p) / (10u)))) * (ceil(((1080n) - 5p) / (10u))))           nrs=(((1080n) / (ceil(((1080n) - 5p) / (10u)))) < 119.5n) ? ((((50n > (((60n) - 0) + 60n) ? 50n : (((60n) - 0) + 60n)) * 120n) + (((1080n) / (ceil(((1080n) - 5p) / (10u)))) * 50n)) + (floor(((ceil(((1080n) - 5p) / (10u))) - 1) / 2.0) * (((((60n) - 0) + 60n) * 120n) + (((1080n) / (ceil(((1080n) - 5p) / (10u)))) * 100n))) + ((((ceil(((1080n) - 5p) / (10u))) / 2) - floor((ceil(((1080n) - 5p) / (10u))) / 2) == 0) ? (((50n > (((60n) - 0) + 60n) ? 50n : (((60n) - 0) + 60n)) * 120n) + (((1080n) / (ceil(((1080n) - 5p) / (10u)))) * 50n)) : 0)) / 1 : (((100n > (((60n) - 0) + 80n) ? 100n : (((60n) - 0) + 80n)) * ((1080n) / (ceil(((1080n) - 5p) / (10u))))) + (floor(((ceil(((1080n) - 5p) / (10u))) - 1) / 2.0) * ((60n > (((60n) - 0) + 50n) ? 60n : (((60n) - 0) + 50n)) * ((1080n) / (ceil(((1080n) - 5p) / (10u)))))) + ((((ceil(((1080n) - 5p) / (10u))) / 2) - floor((ceil(((1080n) - 5p) / (10u))) / 2) == 0) ? ((100n > (((60n) - 0) + 80n) ? 100n : (((60n) - 0) + 80n)) * ((1080n) / (ceil(((1080n) - 5p) / (10u))))) : 0)) / 1 / (((1080n) / (ceil(((1080n) - 5p) / (10u)))) * (ceil(((1080n) - 5p) / (10u))) * ((1080n) / (ceil(((1080n) - 5p) / (10u)))) * (ceil(((1080n) - 5p) / (10u))))           sa=(((1080n) / (ceil(((1080n) - 5p) / (10u)))) < 119.5n) ? (50n > (((60n) - 0) + 60n) ? 50n : (((60n) - 0) + 60n)) + 5e-08 : (100n > (((60n) - 0) + 80n) ? 100n : (((60n) - 0) + 80n))           sb=(((1080n) / (ceil(((1080n) - 5p) / (10u)))) < 119.5n) ? (50n > (((60n) - 0) + 60n) ? 50n : (((60n) - 0) + 60n)) + 5e-08 : (100n > (((60n) - 0) + 80n) ? 100n : (((60n) - 0) + 80n))           sd=(((1080n) / (ceil(((1080n) - 5p) / (10u)))) < 119.5n) ? (((60n) - 0) + 60n) + (2*5e-08) : (60n > (((60n) - 0) + 50n) ? 60n : (((60n) - 0) + 50n))           sca=(( ((1080n) / (ceil(((1080n) - 5p) / (10u)))) * ( (((1u) * (1u) / ((((1080n) / (ceil(((1080n) - 5p) / (10u)))) < 119.5n) ? (50n > (((60n) - 0) + 60n) ? 50n : (((60n) - 0) + 60n)) + 5e-08 : (100n > (((60n) - 0) + 80n) ? 100n : (((60n) - 0) + 80n))+60n)) - ((1u) * (1u) / (((((1080n) / (ceil(((1080n) - 5p) / (10u)))) < 119.5n) ? (50n > (((60n) - 0) + 60n) ? 50n : (((60n) - 0) + 60n)) + 5e-08 : (100n > (((60n) - 0) + 80n) ? 100n : (((60n) - 0) + 80n))+60n)+(45n)))) + ((1u) * (1u) / ((((1080n) / (ceil(((1080n) - 5p) / (10u)))) < 119.5n) ? (50n > (((60n) - 0) + 60n) ? 50n : (((60n) - 0) + 60n)) + 5e-08 : (100n > (((60n) - 0) + 80n) ? 100n : (((60n) - 0) + 80n))+60n)) - ((1u) * (1u)/ (((((1080n) / (ceil(((1080n) - 5p) / (10u)))) < 119.5n) ? (50n > (((60n) - 0) + 60n) ? 50n : (((60n) - 0) + 60n)) + 5e-08 : (100n > (((60n) - 0) + 80n) ? 100n : (((60n) - 0) + 80n))+60n)+(45n))))) + ( (45n) * ( (((1u) * (1u) / (60n)) - ((1u) * (1u) / ((60n)+((1080n) / (ceil(((1080n) - 5p) / (10u))))))) + ((1u) * (1u) / (60n)) - ((1u) * (1u)/ ((60n)+((1080n) / (ceil(((1080n) - 5p) / (10u))))))))) / (((1080n) / (ceil(((1080n) - 5p) / (10u)))) * (45n))           scb=((((1080n) / (ceil(((1080n) - 5p) / (10u)))) * ((((((1080n) / (ceil(((1080n) - 5p) / (10u)))) < 119.5n) ? (50n > (((60n) - 0) + 60n) ? 50n : (((60n) - 0) + 60n)) + 5e-08 : (100n > (((60n) - 0) + 80n) ? 100n : (((60n) - 0) + 80n))+60n)/10 + (1u)/100)*exp(-10 * ((((1080n) / (ceil(((1080n) - 5p) / (10u)))) < 119.5n) ? (50n > (((60n) - 0) + 60n) ? 50n : (((60n) - 0) + 60n)) + 5e-08 : (100n > (((60n) - 0) + 80n) ? 100n : (((60n) - 0) + 80n))+60n) / (1u)) - ((((((1080n) / (ceil(((1080n) - 5p) / (10u)))) < 119.5n) ? (50n > (((60n) - 0) + 60n) ? 50n : (((60n) - 0) + 60n)) + 5e-08 : (100n > (((60n) - 0) + 80n) ? 100n : (((60n) - 0) + 80n))+60n)+(45n))/10 + (1u)/100)*exp(-10 * (((((1080n) / (ceil(((1080n) - 5p) / (10u)))) < 119.5n) ? (50n > (((60n) - 0) + 60n) ? 50n : (((60n) - 0) + 60n)) + 5e-08 : (100n > (((60n) - 0) + 80n) ? 100n : (((60n) - 0) + 80n))+60n)+(45n)) / (1u)) + (((((1080n) / (ceil(((1080n) - 5p) / (10u)))) < 119.5n) ? (50n > (((60n) - 0) + 60n) ? 50n : (((60n) - 0) + 60n)) + 5e-08 : (100n > (((60n) - 0) + 80n) ? 100n : (((60n) - 0) + 80n))+60n)/10 + (1u)/100)*exp(-10 * ((((1080n) / (ceil(((1080n) - 5p) / (10u)))) < 119.5n) ? (50n > (((60n) - 0) + 60n) ? 50n : (((60n) - 0) + 60n)) + 5e-08 : (100n > (((60n) - 0) + 80n) ? 100n : (((60n) - 0) + 80n))+60n) / (1u)) - ((((((1080n) / (ceil(((1080n) - 5p) / (10u)))) < 119.5n) ? (50n > (((60n) - 0) + 60n) ? 50n : (((60n) - 0) + 60n)) + 5e-08 : (100n > (((60n) - 0) + 80n) ? 100n : (((60n) - 0) + 80n))+60n)+(45n))/10 + (1u)/100)*exp(-10 * (((((1080n) / (ceil(((1080n) - 5p) / (10u)))) < 119.5n) ? (50n > (((60n) - 0) + 60n) ? 50n : (((60n) - 0) + 60n)) + 5e-08 : (100n > (((60n) - 0) + 80n) ? 100n : (((60n) - 0) + 80n))+60n)+(45n)) / (1u)))) + ((45n) * (((60n)/10 + (1u)/100)*exp(-10 * (60n) / (1u)) - (((60n)+((1080n) / (ceil(((1080n) - 5p) / (10u)))))/10 + (1u)/100)*exp(-10 * ((60n)+((1080n) / (ceil(((1080n) - 5p) / (10u))))) / (1u)) + ((60n)/10 + (1u)/100)*exp(-10 * (60n) / (1u)) - (((60n)+((1080n) / (ceil(((1080n) - 5p) / (10u)))))/10 + (1u)/100)*exp(-10 * ((60n)+((1080n) / (ceil(((1080n) - 5p) / (10u))))) / (1u))))) / (((1080n) / (ceil(((1080n) - 5p) / (10u)))) * (45n))           scc=((((1080n) / (ceil(((1080n) - 5p) / (10u)))) * ((((((1080n) / (ceil(((1080n) - 5p) / (10u)))) < 119.5n) ? (50n > (((60n) - 0) + 60n) ? 50n : (((60n) - 0) + 60n)) + 5e-08 : (100n > (((60n) - 0) + 80n) ? 100n : (((60n) - 0) + 80n))+60n)/20 + (1u)/400)*exp(-20 * ((((1080n) / (ceil(((1080n) - 5p) / (10u)))) < 119.5n) ? (50n > (((60n) - 0) + 60n) ? 50n : (((60n) - 0) + 60n)) + 5e-08 : (100n > (((60n) - 0) + 80n) ? 100n : (((60n) - 0) + 80n))+60n) / (1u)) - ((((((1080n) / (ceil(((1080n) - 5p) / (10u)))) < 119.5n) ? (50n > (((60n) - 0) + 60n) ? 50n : (((60n) - 0) + 60n)) + 5e-08 : (100n > (((60n) - 0) + 80n) ? 100n : (((60n) - 0) + 80n))+60n)+(45n))/20 + (1u)/400)*exp(-20 * (((((1080n) / (ceil(((1080n) - 5p) / (10u)))) < 119.5n) ? (50n > (((60n) - 0) + 60n) ? 50n : (((60n) - 0) + 60n)) + 5e-08 : (100n > (((60n) - 0) + 80n) ? 100n : (((60n) - 0) + 80n))+60n)+(45n)) / (1u)) + (((((1080n) / (ceil(((1080n) - 5p) / (10u)))) < 119.5n) ? (50n > (((60n) - 0) + 60n) ? 50n : (((60n) - 0) + 60n)) + 5e-08 : (100n > (((60n) - 0) + 80n) ? 100n : (((60n) - 0) + 80n))+60n)/20 + (1u)/400)*exp(-20 * ((((1080n) / (ceil(((1080n) - 5p) / (10u)))) < 119.5n) ? (50n > (((60n) - 0) + 60n) ? 50n : (((60n) - 0) + 60n)) + 5e-08 : (100n > (((60n) - 0) + 80n) ? 100n : (((60n) - 0) + 80n))+60n) / (1u)) - ((((((1080n) / (ceil(((1080n) - 5p) / (10u)))) < 119.5n) ? (50n > (((60n) - 0) + 60n) ? 50n : (((60n) - 0) + 60n)) + 5e-08 : (100n > (((60n) - 0) + 80n) ? 100n : (((60n) - 0) + 80n))+60n)+(45n))/20 + (1u)/400)*exp(-20 * (((((1080n) / (ceil(((1080n) - 5p) / (10u)))) < 119.5n) ? (50n > (((60n) - 0) + 60n) ? 50n : (((60n) - 0) + 60n)) + 5e-08 : (100n > (((60n) - 0) + 80n) ? 100n : (((60n) - 0) + 80n))+60n)+(45n)) / (1u)))) + ((45n) * (((60n)/20 + (1u)/400)*exp(-20 * (60n) / (1u)) - (((60n)+((1080n) / (ceil(((1080n) - 5p) / (10u)))))/20 + (1u)/400)*exp(-20 * ((60n)+((1080n) / (ceil(((1080n) - 5p) / (10u))))) / (1u)) + ((60n)/20 + (1u)/400)*exp(-20 * (60n) / (1u)) - (((60n)+((1080n) / (ceil(((1080n) - 5p) / (10u)))))/20 + (1u)/400)*exp(-20 * ((60n)+((1080n) / (ceil(((1080n) - 5p) / (10u))))) / (1u))))) / (((1080n) / (ceil(((1080n) - 5p) / (10u)))) * (45n))           m=(1)
PM0 (Y A VDD VDD) g45p1svt w=(360n) l=45n nf=ceil(((360n) - 5p) / (10u))           as=(((360n) / (ceil(((360n) - 5p) / (10u)))) < 119.5n) ? ((((50n > (((60n) - 0) + 60n) ? 50n : (((60n) - 0) + 60n)) * 120n) + (((360n) / (ceil(((360n) - 5p) / (10u)))) * 50n)) + (floor(((ceil(((360n) - 5p) / (10u))) - 1) / 2.0) * (((((60n) - 0) + 60n) * 120n) + (((360n) / (ceil(((360n) - 5p) / (10u)))) * 100n))) + ((((ceil(((360n) - 5p) / (10u))) / 2) - floor((ceil(((360n) - 5p) / (10u))) / 2) == 0) ? (((50n > (((60n) - 0) + 60n) ? 50n : (((60n) - 0) + 60n)) * 120n) + (((360n) / (ceil(((360n) - 5p) / (10u)))) * 50n)) : 0)) / 1 : (((100n > (((60n) - 0) + 80n) ? 100n : (((60n) - 0) + 80n)) * ((360n) / (ceil(((360n) - 5p) / (10u))))) + (floor(((ceil(((360n) - 5p) / (10u))) - 1) / 2.0) * ((60n > (((60n) - 0) + 50n) ? 60n : (((60n) - 0) + 50n)) * ((360n) / (ceil(((360n) - 5p) / (10u)))))) + ((((ceil(((360n) - 5p) / (10u))) / 2) - floor((ceil(((360n) - 5p) / (10u))) / 2) == 0) ? ((100n > (((60n) - 0) + 80n) ? 100n : (((60n) - 0) + 80n)) * ((360n) / (ceil(((360n) - 5p) / (10u))))) : 0)) / 1           ad=(((360n) / (ceil(((360n) - 5p) / (10u)))) < 119.5n) ? ((floor((ceil(((360n) - 5p) / (10u))) / 2.0) * (((((60n) - 0) + 60n) * 120n) + (((360n) / (ceil(((360n) - 5p) / (10u)))) * 100n))) + ((((ceil(((360n) - 5p) / (10u))) / 2) - floor((ceil(((360n) - 5p) / (10u))) / 2) != 0) ? (((50n > (((60n) - 0) + 60n) ? 50n : (((60n) - 0) + 60n)) * 120n) + (((360n) / (ceil(((360n) - 5p) / (10u)))) * 50n)) : 0)) / 1 : ((floor((ceil(((360n) - 5p) / (10u))) / 2.0) * ((60n > (((60n) - 0) + 50n) ? 60n : (((60n) - 0) + 50n)) * ((360n) / (ceil(((360n) - 5p) / (10u)))))) + ((((ceil(((360n) - 5p) / (10u))) / 2) - floor((ceil(((360n) - 5p) / (10u))) / 2) != 0) ? ((100n > (((60n) - 0) + 80n) ? 100n : (((60n) - 0) + 80n)) * ((360n) / (ceil(((360n) - 5p) / (10u))))) : 0)) / 1           ps=(((360n) / (ceil(((360n) - 5p) / (10u)))) < 119.5n) ? (((2 * (50n > (((60n) - 0) + 60n) ? 50n : (((60n) - 0) + 60n))) + 340n) + (floor(((ceil(((360n) - 5p) / (10u))) - 1) / 2.0) * ((2 * (((60n) - 0) + 60n)) + 440n)) + ((((ceil(((360n) - 5p) / (10u))) / 2) - floor((ceil(((360n) - 5p) / (10u))) / 2) == 0) ? ((2 * (50n > (((60n) - 0) + 60n) ? 50n : (((60n) - 0) + 60n))) + 340n) : 0)) / 1 : (((2 * (100n > (((60n) - 0) + 80n) ? 100n : (((60n) - 0) + 80n))) + (2 * ((360n) / (ceil(((360n) - 5p) / (10u)))))) + (floor(((ceil(((360n) - 5p) / (10u))) - 1) / 2.0) * ((2 * (60n > (((60n) - 0) + 50n) ? 60n : (((60n) - 0) + 50n))) + (2 * ((360n) / (ceil(((360n) - 5p) / (10u))))))) + ((((ceil(((360n) - 5p) / (10u))) / 2) - floor((ceil(((360n) - 5p) / (10u))) / 2) == 0) ? ((2 * (100n > (((60n) - 0) + 80n) ? 100n : (((60n) - 0) + 80n))) + (2 * ((360n) / (ceil(((360n) - 5p) / (10u)))))) : 0)) / 1           pd=(((360n) / (ceil(((360n) - 5p) / (10u)))) < 119.5n) ? ((floor((ceil(((360n) - 5p) / (10u))) / 2.0) * ((2 * (((60n) - 0) + 60n)) + 440n)) + ((((ceil(((360n) - 5p) / (10u))) / 2) - floor((ceil(((360n) - 5p) / (10u))) / 2) != 0) ? ((2 * (50n > (((60n) - 0) + 60n) ? 50n : (((60n) - 0) + 60n))) + 340n) : 0)) / 1 : ((floor((ceil(((360n) - 5p) / (10u))) / 2.0) * ((2 * (60n > (((60n) - 0) + 50n) ? 60n : (((60n) - 0) + 50n))) + (2 * ((360n) / (ceil(((360n) - 5p) / (10u))))))) + ((((ceil(((360n) - 5p) / (10u))) / 2) - floor((ceil(((360n) - 5p) / (10u))) / 2) != 0) ? ((2 * (100n > (((60n) - 0) + 80n) ? 100n : (((60n) - 0) + 80n))) + (2 * ((360n) / (ceil(((360n) - 5p) / (10u)))))) : 0)) / 1           nrd=(((360n) / (ceil(((360n) - 5p) / (10u)))) < 119.5n) ? ((floor((ceil(((360n) - 5p) / (10u))) / 2.0) * (((((60n) - 0) + 60n) * 120n) + (((360n) / (ceil(((360n) - 5p) / (10u)))) * 100n))) + ((((ceil(((360n) - 5p) / (10u))) / 2) - floor((ceil(((360n) - 5p) / (10u))) / 2) != 0) ? (((50n > (((60n) - 0) + 60n) ? 50n : (((60n) - 0) + 60n)) * 120n) + (((360n) / (ceil(((360n) - 5p) / (10u)))) * 50n)) : 0)) / 1 : ((floor((ceil(((360n) - 5p) / (10u))) / 2.0) * ((60n > (((60n) - 0) + 50n) ? 60n : (((60n) - 0) + 50n)) * ((360n) / (ceil(((360n) - 5p) / (10u)))))) + ((((ceil(((360n) - 5p) / (10u))) / 2) - floor((ceil(((360n) - 5p) / (10u))) / 2) != 0) ? ((100n > (((60n) - 0) + 80n) ? 100n : (((60n) - 0) + 80n)) * ((360n) / (ceil(((360n) - 5p) / (10u))))) : 0)) / 1 / (((360n) / (ceil(((360n) - 5p) / (10u)))) * (ceil(((360n) - 5p) / (10u))) * ((360n) / (ceil(((360n) - 5p) / (10u)))) * (ceil(((360n) - 5p) / (10u))))           nrs=(((360n) / (ceil(((360n) - 5p) / (10u)))) < 119.5n) ? ((((50n > (((60n) - 0) + 60n) ? 50n : (((60n) - 0) + 60n)) * 120n) + (((360n) / (ceil(((360n) - 5p) / (10u)))) * 50n)) + (floor(((ceil(((360n) - 5p) / (10u))) - 1) / 2.0) * (((((60n) - 0) + 60n) * 120n) + (((360n) / (ceil(((360n) - 5p) / (10u)))) * 100n))) + ((((ceil(((360n) - 5p) / (10u))) / 2) - floor((ceil(((360n) - 5p) / (10u))) / 2) == 0) ? (((50n > (((60n) - 0) + 60n) ? 50n : (((60n) - 0) + 60n)) * 120n) + (((360n) / (ceil(((360n) - 5p) / (10u)))) * 50n)) : 0)) / 1 : (((100n > (((60n) - 0) + 80n) ? 100n : (((60n) - 0) + 80n)) * ((360n) / (ceil(((360n) - 5p) / (10u))))) + (floor(((ceil(((360n) - 5p) / (10u))) - 1) / 2.0) * ((60n > (((60n) - 0) + 50n) ? 60n : (((60n) - 0) + 50n)) * ((360n) / (ceil(((360n) - 5p) / (10u)))))) + ((((ceil(((360n) - 5p) / (10u))) / 2) - floor((ceil(((360n) - 5p) / (10u))) / 2) == 0) ? ((100n > (((60n) - 0) + 80n) ? 100n : (((60n) - 0) + 80n)) * ((360n) / (ceil(((360n) - 5p) / (10u))))) : 0)) / 1 / (((360n) / (ceil(((360n) - 5p) / (10u)))) * (ceil(((360n) - 5p) / (10u))) * ((360n) / (ceil(((360n) - 5p) / (10u)))) * (ceil(((360n) - 5p) / (10u))))           sa=(((360n) / (ceil(((360n) - 5p) / (10u)))) < 119.5n) ? (50n > (((60n) - 0) + 60n) ? 50n : (((60n) - 0) + 60n)) + 5e-08 : (100n > (((60n) - 0) + 80n) ? 100n : (((60n) - 0) + 80n))           sb=(((360n) / (ceil(((360n) - 5p) / (10u)))) < 119.5n) ? (50n > (((60n) - 0) + 60n) ? 50n : (((60n) - 0) + 60n)) + 5e-08 : (100n > (((60n) - 0) + 80n) ? 100n : (((60n) - 0) + 80n))           sd=(((360n) / (ceil(((360n) - 5p) / (10u)))) < 119.5n) ? (((60n) - 0) + 60n) + (2*5e-08) : (60n > (((60n) - 0) + 50n) ? 60n : (((60n) - 0) + 50n))           sca=(( ((360n) / (ceil(((360n) - 5p) / (10u)))) * ( (((1u) * (1u) / ((((360n) / (ceil(((360n) - 5p) / (10u)))) < 119.5n) ? (50n > (((60n) - 0) + 60n) ? 50n : (((60n) - 0) + 60n)) + 5e-08 : (100n > (((60n) - 0) + 80n) ? 100n : (((60n) - 0) + 80n))+60n)) - ((1u) * (1u) / (((((360n) / (ceil(((360n) - 5p) / (10u)))) < 119.5n) ? (50n > (((60n) - 0) + 60n) ? 50n : (((60n) - 0) + 60n)) + 5e-08 : (100n > (((60n) - 0) + 80n) ? 100n : (((60n) - 0) + 80n))+60n)+(45n)))) + ((1u) * (1u) / ((((360n) / (ceil(((360n) - 5p) / (10u)))) < 119.5n) ? (50n > (((60n) - 0) + 60n) ? 50n : (((60n) - 0) + 60n)) + 5e-08 : (100n > (((60n) - 0) + 80n) ? 100n : (((60n) - 0) + 80n))+60n)) - ((1u) * (1u)/ (((((360n) / (ceil(((360n) - 5p) / (10u)))) < 119.5n) ? (50n > (((60n) - 0) + 60n) ? 50n : (((60n) - 0) + 60n)) + 5e-08 : (100n > (((60n) - 0) + 80n) ? 100n : (((60n) - 0) + 80n))+60n)+(45n))))) + ( (45n) * ( (((1u) * (1u) / (60n)) - ((1u) * (1u) / ((60n)+((360n) / (ceil(((360n) - 5p) / (10u))))))) + ((1u) * (1u) / (60n)) - ((1u) * (1u)/ ((60n)+((360n) / (ceil(((360n) - 5p) / (10u))))))))) / (((360n) / (ceil(((360n) - 5p) / (10u)))) * (45n))           scb=((((360n) / (ceil(((360n) - 5p) / (10u)))) * ((((((360n) / (ceil(((360n) - 5p) / (10u)))) < 119.5n) ? (50n > (((60n) - 0) + 60n) ? 50n : (((60n) - 0) + 60n)) + 5e-08 : (100n > (((60n) - 0) + 80n) ? 100n : (((60n) - 0) + 80n))+60n)/10 + (1u)/100)*exp(-10 * ((((360n) / (ceil(((360n) - 5p) / (10u)))) < 119.5n) ? (50n > (((60n) - 0) + 60n) ? 50n : (((60n) - 0) + 60n)) + 5e-08 : (100n > (((60n) - 0) + 80n) ? 100n : (((60n) - 0) + 80n))+60n) / (1u)) - ((((((360n) / (ceil(((360n) - 5p) / (10u)))) < 119.5n) ? (50n > (((60n) - 0) + 60n) ? 50n : (((60n) - 0) + 60n)) + 5e-08 : (100n > (((60n) - 0) + 80n) ? 100n : (((60n) - 0) + 80n))+60n)+(45n))/10 + (1u)/100)*exp(-10 * (((((360n) / (ceil(((360n) - 5p) / (10u)))) < 119.5n) ? (50n > (((60n) - 0) + 60n) ? 50n : (((60n) - 0) + 60n)) + 5e-08 : (100n > (((60n) - 0) + 80n) ? 100n : (((60n) - 0) + 80n))+60n)+(45n)) / (1u)) + (((((360n) / (ceil(((360n) - 5p) / (10u)))) < 119.5n) ? (50n > (((60n) - 0) + 60n) ? 50n : (((60n) - 0) + 60n)) + 5e-08 : (100n > (((60n) - 0) + 80n) ? 100n : (((60n) - 0) + 80n))+60n)/10 + (1u)/100)*exp(-10 * ((((360n) / (ceil(((360n) - 5p) / (10u)))) < 119.5n) ? (50n > (((60n) - 0) + 60n) ? 50n : (((60n) - 0) + 60n)) + 5e-08 : (100n > (((60n) - 0) + 80n) ? 100n : (((60n) - 0) + 80n))+60n) / (1u)) - ((((((360n) / (ceil(((360n) - 5p) / (10u)))) < 119.5n) ? (50n > (((60n) - 0) + 60n) ? 50n : (((60n) - 0) + 60n)) + 5e-08 : (100n > (((60n) - 0) + 80n) ? 100n : (((60n) - 0) + 80n))+60n)+(45n))/10 + (1u)/100)*exp(-10 * (((((360n) / (ceil(((360n) - 5p) / (10u)))) < 119.5n) ? (50n > (((60n) - 0) + 60n) ? 50n : (((60n) - 0) + 60n)) + 5e-08 : (100n > (((60n) - 0) + 80n) ? 100n : (((60n) - 0) + 80n))+60n)+(45n)) / (1u)))) + ((45n) * (((60n)/10 + (1u)/100)*exp(-10 * (60n) / (1u)) - (((60n)+((360n) / (ceil(((360n) - 5p) / (10u)))))/10 + (1u)/100)*exp(-10 * ((60n)+((360n) / (ceil(((360n) - 5p) / (10u))))) / (1u)) + ((60n)/10 + (1u)/100)*exp(-10 * (60n) / (1u)) - (((60n)+((360n) / (ceil(((360n) - 5p) / (10u)))))/10 + (1u)/100)*exp(-10 * ((60n)+((360n) / (ceil(((360n) - 5p) / (10u))))) / (1u))))) / (((360n) / (ceil(((360n) - 5p) / (10u)))) * (45n))           scc=((((360n) / (ceil(((360n) - 5p) / (10u)))) * ((((((360n) / (ceil(((360n) - 5p) / (10u)))) < 119.5n) ? (50n > (((60n) - 0) + 60n) ? 50n : (((60n) - 0) + 60n)) + 5e-08 : (100n > (((60n) - 0) + 80n) ? 100n : (((60n) - 0) + 80n))+60n)/20 + (1u)/400)*exp(-20 * ((((360n) / (ceil(((360n) - 5p) / (10u)))) < 119.5n) ? (50n > (((60n) - 0) + 60n) ? 50n : (((60n) - 0) + 60n)) + 5e-08 : (100n > (((60n) - 0) + 80n) ? 100n : (((60n) - 0) + 80n))+60n) / (1u)) - ((((((360n) / (ceil(((360n) - 5p) / (10u)))) < 119.5n) ? (50n > (((60n) - 0) + 60n) ? 50n : (((60n) - 0) + 60n)) + 5e-08 : (100n > (((60n) - 0) + 80n) ? 100n : (((60n) - 0) + 80n))+60n)+(45n))/20 + (1u)/400)*exp(-20 * (((((360n) / (ceil(((360n) - 5p) / (10u)))) < 119.5n) ? (50n > (((60n) - 0) + 60n) ? 50n : (((60n) - 0) + 60n)) + 5e-08 : (100n > (((60n) - 0) + 80n) ? 100n : (((60n) - 0) + 80n))+60n)+(45n)) / (1u)) + (((((360n) / (ceil(((360n) - 5p) / (10u)))) < 119.5n) ? (50n > (((60n) - 0) + 60n) ? 50n : (((60n) - 0) + 60n)) + 5e-08 : (100n > (((60n) - 0) + 80n) ? 100n : (((60n) - 0) + 80n))+60n)/20 + (1u)/400)*exp(-20 * ((((360n) / (ceil(((360n) - 5p) / (10u)))) < 119.5n) ? (50n > (((60n) - 0) + 60n) ? 50n : (((60n) - 0) + 60n)) + 5e-08 : (100n > (((60n) - 0) + 80n) ? 100n : (((60n) - 0) + 80n))+60n) / (1u)) - ((((((360n) / (ceil(((360n) - 5p) / (10u)))) < 119.5n) ? (50n > (((60n) - 0) + 60n) ? 50n : (((60n) - 0) + 60n)) + 5e-08 : (100n > (((60n) - 0) + 80n) ? 100n : (((60n) - 0) + 80n))+60n)+(45n))/20 + (1u)/400)*exp(-20 * (((((360n) / (ceil(((360n) - 5p) / (10u)))) < 119.5n) ? (50n > (((60n) - 0) + 60n) ? 50n : (((60n) - 0) + 60n)) + 5e-08 : (100n > (((60n) - 0) + 80n) ? 100n : (((60n) - 0) + 80n))+60n)+(45n)) / (1u)))) + ((45n) * (((60n)/20 + (1u)/400)*exp(-20 * (60n) / (1u)) - (((60n)+((360n) / (ceil(((360n) - 5p) / (10u)))))/20 + (1u)/400)*exp(-20 * ((60n)+((360n) / (ceil(((360n) - 5p) / (10u))))) / (1u)) + ((60n)/20 + (1u)/400)*exp(-20 * (60n) / (1u)) - (((60n)+((360n) / (ceil(((360n) - 5p) / (10u)))))/20 + (1u)/400)*exp(-20 * ((60n)+((360n) / (ceil(((360n) - 5p) / (10u))))) / (1u))))) / (((360n) / (ceil(((360n) - 5p) / (10u)))) * (45n))           m=(1)
PM1 (Y B VDD VDD) g45p1svt w=(360n) l=45n nf=ceil(((360n) - 5p) / (10u))           as=(((360n) / (ceil(((360n) - 5p) / (10u)))) < 119.5n) ? ((((50n > (((60n) - 0) + 60n) ? 50n : (((60n) - 0) + 60n)) * 120n) + (((360n) / (ceil(((360n) - 5p) / (10u)))) * 50n)) + (floor(((ceil(((360n) - 5p) / (10u))) - 1) / 2.0) * (((((60n) - 0) + 60n) * 120n) + (((360n) / (ceil(((360n) - 5p) / (10u)))) * 100n))) + ((((ceil(((360n) - 5p) / (10u))) / 2) - floor((ceil(((360n) - 5p) / (10u))) / 2) == 0) ? (((50n > (((60n) - 0) + 60n) ? 50n : (((60n) - 0) + 60n)) * 120n) + (((360n) / (ceil(((360n) - 5p) / (10u)))) * 50n)) : 0)) / 1 : (((100n > (((60n) - 0) + 80n) ? 100n : (((60n) - 0) + 80n)) * ((360n) / (ceil(((360n) - 5p) / (10u))))) + (floor(((ceil(((360n) - 5p) / (10u))) - 1) / 2.0) * ((60n > (((60n) - 0) + 50n) ? 60n : (((60n) - 0) + 50n)) * ((360n) / (ceil(((360n) - 5p) / (10u)))))) + ((((ceil(((360n) - 5p) / (10u))) / 2) - floor((ceil(((360n) - 5p) / (10u))) / 2) == 0) ? ((100n > (((60n) - 0) + 80n) ? 100n : (((60n) - 0) + 80n)) * ((360n) / (ceil(((360n) - 5p) / (10u))))) : 0)) / 1           ad=(((360n) / (ceil(((360n) - 5p) / (10u)))) < 119.5n) ? ((floor((ceil(((360n) - 5p) / (10u))) / 2.0) * (((((60n) - 0) + 60n) * 120n) + (((360n) / (ceil(((360n) - 5p) / (10u)))) * 100n))) + ((((ceil(((360n) - 5p) / (10u))) / 2) - floor((ceil(((360n) - 5p) / (10u))) / 2) != 0) ? (((50n > (((60n) - 0) + 60n) ? 50n : (((60n) - 0) + 60n)) * 120n) + (((360n) / (ceil(((360n) - 5p) / (10u)))) * 50n)) : 0)) / 1 : ((floor((ceil(((360n) - 5p) / (10u))) / 2.0) * ((60n > (((60n) - 0) + 50n) ? 60n : (((60n) - 0) + 50n)) * ((360n) / (ceil(((360n) - 5p) / (10u)))))) + ((((ceil(((360n) - 5p) / (10u))) / 2) - floor((ceil(((360n) - 5p) / (10u))) / 2) != 0) ? ((100n > (((60n) - 0) + 80n) ? 100n : (((60n) - 0) + 80n)) * ((360n) / (ceil(((360n) - 5p) / (10u))))) : 0)) / 1           ps=(((360n) / (ceil(((360n) - 5p) / (10u)))) < 119.5n) ? (((2 * (50n > (((60n) - 0) + 60n) ? 50n : (((60n) - 0) + 60n))) + 340n) + (floor(((ceil(((360n) - 5p) / (10u))) - 1) / 2.0) * ((2 * (((60n) - 0) + 60n)) + 440n)) + ((((ceil(((360n) - 5p) / (10u))) / 2) - floor((ceil(((360n) - 5p) / (10u))) / 2) == 0) ? ((2 * (50n > (((60n) - 0) + 60n) ? 50n : (((60n) - 0) + 60n))) + 340n) : 0)) / 1 : (((2 * (100n > (((60n) - 0) + 80n) ? 100n : (((60n) - 0) + 80n))) + (2 * ((360n) / (ceil(((360n) - 5p) / (10u)))))) + (floor(((ceil(((360n) - 5p) / (10u))) - 1) / 2.0) * ((2 * (60n > (((60n) - 0) + 50n) ? 60n : (((60n) - 0) + 50n))) + (2 * ((360n) / (ceil(((360n) - 5p) / (10u))))))) + ((((ceil(((360n) - 5p) / (10u))) / 2) - floor((ceil(((360n) - 5p) / (10u))) / 2) == 0) ? ((2 * (100n > (((60n) - 0) + 80n) ? 100n : (((60n) - 0) + 80n))) + (2 * ((360n) / (ceil(((360n) - 5p) / (10u)))))) : 0)) / 1           pd=(((360n) / (ceil(((360n) - 5p) / (10u)))) < 119.5n) ? ((floor((ceil(((360n) - 5p) / (10u))) / 2.0) * ((2 * (((60n) - 0) + 60n)) + 440n)) + ((((ceil(((360n) - 5p) / (10u))) / 2) - floor((ceil(((360n) - 5p) / (10u))) / 2) != 0) ? ((2 * (50n > (((60n) - 0) + 60n) ? 50n : (((60n) - 0) + 60n))) + 340n) : 0)) / 1 : ((floor((ceil(((360n) - 5p) / (10u))) / 2.0) * ((2 * (60n > (((60n) - 0) + 50n) ? 60n : (((60n) - 0) + 50n))) + (2 * ((360n) / (ceil(((360n) - 5p) / (10u))))))) + ((((ceil(((360n) - 5p) / (10u))) / 2) - floor((ceil(((360n) - 5p) / (10u))) / 2) != 0) ? ((2 * (100n > (((60n) - 0) + 80n) ? 100n : (((60n) - 0) + 80n))) + (2 * ((360n) / (ceil(((360n) - 5p) / (10u)))))) : 0)) / 1           nrd=(((360n) / (ceil(((360n) - 5p) / (10u)))) < 119.5n) ? ((floor((ceil(((360n) - 5p) / (10u))) / 2.0) * (((((60n) - 0) + 60n) * 120n) + (((360n) / (ceil(((360n) - 5p) / (10u)))) * 100n))) + ((((ceil(((360n) - 5p) / (10u))) / 2) - floor((ceil(((360n) - 5p) / (10u))) / 2) != 0) ? (((50n > (((60n) - 0) + 60n) ? 50n : (((60n) - 0) + 60n)) * 120n) + (((360n) / (ceil(((360n) - 5p) / (10u)))) * 50n)) : 0)) / 1 : ((floor((ceil(((360n) - 5p) / (10u))) / 2.0) * ((60n > (((60n) - 0) + 50n) ? 60n : (((60n) - 0) + 50n)) * ((360n) / (ceil(((360n) - 5p) / (10u)))))) + ((((ceil(((360n) - 5p) / (10u))) / 2) - floor((ceil(((360n) - 5p) / (10u))) / 2) != 0) ? ((100n > (((60n) - 0) + 80n) ? 100n : (((60n) - 0) + 80n)) * ((360n) / (ceil(((360n) - 5p) / (10u))))) : 0)) / 1 / (((360n) / (ceil(((360n) - 5p) / (10u)))) * (ceil(((360n) - 5p) / (10u))) * ((360n) / (ceil(((360n) - 5p) / (10u)))) * (ceil(((360n) - 5p) / (10u))))           nrs=(((360n) / (ceil(((360n) - 5p) / (10u)))) < 119.5n) ? ((((50n > (((60n) - 0) + 60n) ? 50n : (((60n) - 0) + 60n)) * 120n) + (((360n) / (ceil(((360n) - 5p) / (10u)))) * 50n)) + (floor(((ceil(((360n) - 5p) / (10u))) - 1) / 2.0) * (((((60n) - 0) + 60n) * 120n) + (((360n) / (ceil(((360n) - 5p) / (10u)))) * 100n))) + ((((ceil(((360n) - 5p) / (10u))) / 2) - floor((ceil(((360n) - 5p) / (10u))) / 2) == 0) ? (((50n > (((60n) - 0) + 60n) ? 50n : (((60n) - 0) + 60n)) * 120n) + (((360n) / (ceil(((360n) - 5p) / (10u)))) * 50n)) : 0)) / 1 : (((100n > (((60n) - 0) + 80n) ? 100n : (((60n) - 0) + 80n)) * ((360n) / (ceil(((360n) - 5p) / (10u))))) + (floor(((ceil(((360n) - 5p) / (10u))) - 1) / 2.0) * ((60n > (((60n) - 0) + 50n) ? 60n : (((60n) - 0) + 50n)) * ((360n) / (ceil(((360n) - 5p) / (10u)))))) + ((((ceil(((360n) - 5p) / (10u))) / 2) - floor((ceil(((360n) - 5p) / (10u))) / 2) == 0) ? ((100n > (((60n) - 0) + 80n) ? 100n : (((60n) - 0) + 80n)) * ((360n) / (ceil(((360n) - 5p) / (10u))))) : 0)) / 1 / (((360n) / (ceil(((360n) - 5p) / (10u)))) * (ceil(((360n) - 5p) / (10u))) * ((360n) / (ceil(((360n) - 5p) / (10u)))) * (ceil(((360n) - 5p) / (10u))))           sa=(((360n) / (ceil(((360n) - 5p) / (10u)))) < 119.5n) ? (50n > (((60n) - 0) + 60n) ? 50n : (((60n) - 0) + 60n)) + 5e-08 : (100n > (((60n) - 0) + 80n) ? 100n : (((60n) - 0) + 80n))           sb=(((360n) / (ceil(((360n) - 5p) / (10u)))) < 119.5n) ? (50n > (((60n) - 0) + 60n) ? 50n : (((60n) - 0) + 60n)) + 5e-08 : (100n > (((60n) - 0) + 80n) ? 100n : (((60n) - 0) + 80n))           sd=(((360n) / (ceil(((360n) - 5p) / (10u)))) < 119.5n) ? (((60n) - 0) + 60n) + (2*5e-08) : (60n > (((60n) - 0) + 50n) ? 60n : (((60n) - 0) + 50n))           sca=(( ((360n) / (ceil(((360n) - 5p) / (10u)))) * ( (((1u) * (1u) / ((((360n) / (ceil(((360n) - 5p) / (10u)))) < 119.5n) ? (50n > (((60n) - 0) + 60n) ? 50n : (((60n) - 0) + 60n)) + 5e-08 : (100n > (((60n) - 0) + 80n) ? 100n : (((60n) - 0) + 80n))+60n)) - ((1u) * (1u) / (((((360n) / (ceil(((360n) - 5p) / (10u)))) < 119.5n) ? (50n > (((60n) - 0) + 60n) ? 50n : (((60n) - 0) + 60n)) + 5e-08 : (100n > (((60n) - 0) + 80n) ? 100n : (((60n) - 0) + 80n))+60n)+(45n)))) + ((1u) * (1u) / ((((360n) / (ceil(((360n) - 5p) / (10u)))) < 119.5n) ? (50n > (((60n) - 0) + 60n) ? 50n : (((60n) - 0) + 60n)) + 5e-08 : (100n > (((60n) - 0) + 80n) ? 100n : (((60n) - 0) + 80n))+60n)) - ((1u) * (1u)/ (((((360n) / (ceil(((360n) - 5p) / (10u)))) < 119.5n) ? (50n > (((60n) - 0) + 60n) ? 50n : (((60n) - 0) + 60n)) + 5e-08 : (100n > (((60n) - 0) + 80n) ? 100n : (((60n) - 0) + 80n))+60n)+(45n))))) + ( (45n) * ( (((1u) * (1u) / (60n)) - ((1u) * (1u) / ((60n)+((360n) / (ceil(((360n) - 5p) / (10u))))))) + ((1u) * (1u) / (60n)) - ((1u) * (1u)/ ((60n)+((360n) / (ceil(((360n) - 5p) / (10u))))))))) / (((360n) / (ceil(((360n) - 5p) / (10u)))) * (45n))           scb=((((360n) / (ceil(((360n) - 5p) / (10u)))) * ((((((360n) / (ceil(((360n) - 5p) / (10u)))) < 119.5n) ? (50n > (((60n) - 0) + 60n) ? 50n : (((60n) - 0) + 60n)) + 5e-08 : (100n > (((60n) - 0) + 80n) ? 100n : (((60n) - 0) + 80n))+60n)/10 + (1u)/100)*exp(-10 * ((((360n) / (ceil(((360n) - 5p) / (10u)))) < 119.5n) ? (50n > (((60n) - 0) + 60n) ? 50n : (((60n) - 0) + 60n)) + 5e-08 : (100n > (((60n) - 0) + 80n) ? 100n : (((60n) - 0) + 80n))+60n) / (1u)) - ((((((360n) / (ceil(((360n) - 5p) / (10u)))) < 119.5n) ? (50n > (((60n) - 0) + 60n) ? 50n : (((60n) - 0) + 60n)) + 5e-08 : (100n > (((60n) - 0) + 80n) ? 100n : (((60n) - 0) + 80n))+60n)+(45n))/10 + (1u)/100)*exp(-10 * (((((360n) / (ceil(((360n) - 5p) / (10u)))) < 119.5n) ? (50n > (((60n) - 0) + 60n) ? 50n : (((60n) - 0) + 60n)) + 5e-08 : (100n > (((60n) - 0) + 80n) ? 100n : (((60n) - 0) + 80n))+60n)+(45n)) / (1u)) + (((((360n) / (ceil(((360n) - 5p) / (10u)))) < 119.5n) ? (50n > (((60n) - 0) + 60n) ? 50n : (((60n) - 0) + 60n)) + 5e-08 : (100n > (((60n) - 0) + 80n) ? 100n : (((60n) - 0) + 80n))+60n)/10 + (1u)/100)*exp(-10 * ((((360n) / (ceil(((360n) - 5p) / (10u)))) < 119.5n) ? (50n > (((60n) - 0) + 60n) ? 50n : (((60n) - 0) + 60n)) + 5e-08 : (100n > (((60n) - 0) + 80n) ? 100n : (((60n) - 0) + 80n))+60n) / (1u)) - ((((((360n) / (ceil(((360n) - 5p) / (10u)))) < 119.5n) ? (50n > (((60n) - 0) + 60n) ? 50n : (((60n) - 0) + 60n)) + 5e-08 : (100n > (((60n) - 0) + 80n) ? 100n : (((60n) - 0) + 80n))+60n)+(45n))/10 + (1u)/100)*exp(-10 * (((((360n) / (ceil(((360n) - 5p) / (10u)))) < 119.5n) ? (50n > (((60n) - 0) + 60n) ? 50n : (((60n) - 0) + 60n)) + 5e-08 : (100n > (((60n) - 0) + 80n) ? 100n : (((60n) - 0) + 80n))+60n)+(45n)) / (1u)))) + ((45n) * (((60n)/10 + (1u)/100)*exp(-10 * (60n) / (1u)) - (((60n)+((360n) / (ceil(((360n) - 5p) / (10u)))))/10 + (1u)/100)*exp(-10 * ((60n)+((360n) / (ceil(((360n) - 5p) / (10u))))) / (1u)) + ((60n)/10 + (1u)/100)*exp(-10 * (60n) / (1u)) - (((60n)+((360n) / (ceil(((360n) - 5p) / (10u)))))/10 + (1u)/100)*exp(-10 * ((60n)+((360n) / (ceil(((360n) - 5p) / (10u))))) / (1u))))) / (((360n) / (ceil(((360n) - 5p) / (10u)))) * (45n))           scc=((((360n) / (ceil(((360n) - 5p) / (10u)))) * ((((((360n) / (ceil(((360n) - 5p) / (10u)))) < 119.5n) ? (50n > (((60n) - 0) + 60n) ? 50n : (((60n) - 0) + 60n)) + 5e-08 : (100n > (((60n) - 0) + 80n) ? 100n : (((60n) - 0) + 80n))+60n)/20 + (1u)/400)*exp(-20 * ((((360n) / (ceil(((360n) - 5p) / (10u)))) < 119.5n) ? (50n > (((60n) - 0) + 60n) ? 50n : (((60n) - 0) + 60n)) + 5e-08 : (100n > (((60n) - 0) + 80n) ? 100n : (((60n) - 0) + 80n))+60n) / (1u)) - ((((((360n) / (ceil(((360n) - 5p) / (10u)))) < 119.5n) ? (50n > (((60n) - 0) + 60n) ? 50n : (((60n) - 0) + 60n)) + 5e-08 : (100n > (((60n) - 0) + 80n) ? 100n : (((60n) - 0) + 80n))+60n)+(45n))/20 + (1u)/400)*exp(-20 * (((((360n) / (ceil(((360n) - 5p) / (10u)))) < 119.5n) ? (50n > (((60n) - 0) + 60n) ? 50n : (((60n) - 0) + 60n)) + 5e-08 : (100n > (((60n) - 0) + 80n) ? 100n : (((60n) - 0) + 80n))+60n)+(45n)) / (1u)) + (((((360n) / (ceil(((360n) - 5p) / (10u)))) < 119.5n) ? (50n > (((60n) - 0) + 60n) ? 50n : (((60n) - 0) + 60n)) + 5e-08 : (100n > (((60n) - 0) + 80n) ? 100n : (((60n) - 0) + 80n))+60n)/20 + (1u)/400)*exp(-20 * ((((360n) / (ceil(((360n) - 5p) / (10u)))) < 119.5n) ? (50n > (((60n) - 0) + 60n) ? 50n : (((60n) - 0) + 60n)) + 5e-08 : (100n > (((60n) - 0) + 80n) ? 100n : (((60n) - 0) + 80n))+60n) / (1u)) - ((((((360n) / (ceil(((360n) - 5p) / (10u)))) < 119.5n) ? (50n > (((60n) - 0) + 60n) ? 50n : (((60n) - 0) + 60n)) + 5e-08 : (100n > (((60n) - 0) + 80n) ? 100n : (((60n) - 0) + 80n))+60n)+(45n))/20 + (1u)/400)*exp(-20 * (((((360n) / (ceil(((360n) - 5p) / (10u)))) < 119.5n) ? (50n > (((60n) - 0) + 60n) ? 50n : (((60n) - 0) + 60n)) + 5e-08 : (100n > (((60n) - 0) + 80n) ? 100n : (((60n) - 0) + 80n))+60n)+(45n)) / (1u)))) + ((45n) * (((60n)/20 + (1u)/400)*exp(-20 * (60n) / (1u)) - (((60n)+((360n) / (ceil(((360n) - 5p) / (10u)))))/20 + (1u)/400)*exp(-20 * ((60n)+((360n) / (ceil(((360n) - 5p) / (10u))))) / (1u)) + ((60n)/20 + (1u)/400)*exp(-20 * (60n) / (1u)) - (((60n)+((360n) / (ceil(((360n) - 5p) / (10u)))))/20 + (1u)/400)*exp(-20 * ((60n)+((360n) / (ceil(((360n) - 5p) / (10u))))) / (1u))))) / (((360n) / (ceil(((360n) - 5p) / (10u)))) * (45n))           m=(1)
PM2 (Y E VDD VDD) g45p1svt w=(360n) l=45n nf=ceil(((360n) - 5p) / (10u))           as=(((360n) / (ceil(((360n) - 5p) / (10u)))) < 119.5n) ? ((((50n > (((60n) - 0) + 60n) ? 50n : (((60n) - 0) + 60n)) * 120n) + (((360n) / (ceil(((360n) - 5p) / (10u)))) * 50n)) + (floor(((ceil(((360n) - 5p) / (10u))) - 1) / 2.0) * (((((60n) - 0) + 60n) * 120n) + (((360n) / (ceil(((360n) - 5p) / (10u)))) * 100n))) + ((((ceil(((360n) - 5p) / (10u))) / 2) - floor((ceil(((360n) - 5p) / (10u))) / 2) == 0) ? (((50n > (((60n) - 0) + 60n) ? 50n : (((60n) - 0) + 60n)) * 120n) + (((360n) / (ceil(((360n) - 5p) / (10u)))) * 50n)) : 0)) / 1 : (((100n > (((60n) - 0) + 80n) ? 100n : (((60n) - 0) + 80n)) * ((360n) / (ceil(((360n) - 5p) / (10u))))) + (floor(((ceil(((360n) - 5p) / (10u))) - 1) / 2.0) * ((60n > (((60n) - 0) + 50n) ? 60n : (((60n) - 0) + 50n)) * ((360n) / (ceil(((360n) - 5p) / (10u)))))) + ((((ceil(((360n) - 5p) / (10u))) / 2) - floor((ceil(((360n) - 5p) / (10u))) / 2) == 0) ? ((100n > (((60n) - 0) + 80n) ? 100n : (((60n) - 0) + 80n)) * ((360n) / (ceil(((360n) - 5p) / (10u))))) : 0)) / 1           ad=(((360n) / (ceil(((360n) - 5p) / (10u)))) < 119.5n) ? ((floor((ceil(((360n) - 5p) / (10u))) / 2.0) * (((((60n) - 0) + 60n) * 120n) + (((360n) / (ceil(((360n) - 5p) / (10u)))) * 100n))) + ((((ceil(((360n) - 5p) / (10u))) / 2) - floor((ceil(((360n) - 5p) / (10u))) / 2) != 0) ? (((50n > (((60n) - 0) + 60n) ? 50n : (((60n) - 0) + 60n)) * 120n) + (((360n) / (ceil(((360n) - 5p) / (10u)))) * 50n)) : 0)) / 1 : ((floor((ceil(((360n) - 5p) / (10u))) / 2.0) * ((60n > (((60n) - 0) + 50n) ? 60n : (((60n) - 0) + 50n)) * ((360n) / (ceil(((360n) - 5p) / (10u)))))) + ((((ceil(((360n) - 5p) / (10u))) / 2) - floor((ceil(((360n) - 5p) / (10u))) / 2) != 0) ? ((100n > (((60n) - 0) + 80n) ? 100n : (((60n) - 0) + 80n)) * ((360n) / (ceil(((360n) - 5p) / (10u))))) : 0)) / 1           ps=(((360n) / (ceil(((360n) - 5p) / (10u)))) < 119.5n) ? (((2 * (50n > (((60n) - 0) + 60n) ? 50n : (((60n) - 0) + 60n))) + 340n) + (floor(((ceil(((360n) - 5p) / (10u))) - 1) / 2.0) * ((2 * (((60n) - 0) + 60n)) + 440n)) + ((((ceil(((360n) - 5p) / (10u))) / 2) - floor((ceil(((360n) - 5p) / (10u))) / 2) == 0) ? ((2 * (50n > (((60n) - 0) + 60n) ? 50n : (((60n) - 0) + 60n))) + 340n) : 0)) / 1 : (((2 * (100n > (((60n) - 0) + 80n) ? 100n : (((60n) - 0) + 80n))) + (2 * ((360n) / (ceil(((360n) - 5p) / (10u)))))) + (floor(((ceil(((360n) - 5p) / (10u))) - 1) / 2.0) * ((2 * (60n > (((60n) - 0) + 50n) ? 60n : (((60n) - 0) + 50n))) + (2 * ((360n) / (ceil(((360n) - 5p) / (10u))))))) + ((((ceil(((360n) - 5p) / (10u))) / 2) - floor((ceil(((360n) - 5p) / (10u))) / 2) == 0) ? ((2 * (100n > (((60n) - 0) + 80n) ? 100n : (((60n) - 0) + 80n))) + (2 * ((360n) / (ceil(((360n) - 5p) / (10u)))))) : 0)) / 1           pd=(((360n) / (ceil(((360n) - 5p) / (10u)))) < 119.5n) ? ((floor((ceil(((360n) - 5p) / (10u))) / 2.0) * ((2 * (((60n) - 0) + 60n)) + 440n)) + ((((ceil(((360n) - 5p) / (10u))) / 2) - floor((ceil(((360n) - 5p) / (10u))) / 2) != 0) ? ((2 * (50n > (((60n) - 0) + 60n) ? 50n : (((60n) - 0) + 60n))) + 340n) : 0)) / 1 : ((floor((ceil(((360n) - 5p) / (10u))) / 2.0) * ((2 * (60n > (((60n) - 0) + 50n) ? 60n : (((60n) - 0) + 50n))) + (2 * ((360n) / (ceil(((360n) - 5p) / (10u))))))) + ((((ceil(((360n) - 5p) / (10u))) / 2) - floor((ceil(((360n) - 5p) / (10u))) / 2) != 0) ? ((2 * (100n > (((60n) - 0) + 80n) ? 100n : (((60n) - 0) + 80n))) + (2 * ((360n) / (ceil(((360n) - 5p) / (10u)))))) : 0)) / 1           nrd=(((360n) / (ceil(((360n) - 5p) / (10u)))) < 119.5n) ? ((floor((ceil(((360n) - 5p) / (10u))) / 2.0) * (((((60n) - 0) + 60n) * 120n) + (((360n) / (ceil(((360n) - 5p) / (10u)))) * 100n))) + ((((ceil(((360n) - 5p) / (10u))) / 2) - floor((ceil(((360n) - 5p) / (10u))) / 2) != 0) ? (((50n > (((60n) - 0) + 60n) ? 50n : (((60n) - 0) + 60n)) * 120n) + (((360n) / (ceil(((360n) - 5p) / (10u)))) * 50n)) : 0)) / 1 : ((floor((ceil(((360n) - 5p) / (10u))) / 2.0) * ((60n > (((60n) - 0) + 50n) ? 60n : (((60n) - 0) + 50n)) * ((360n) / (ceil(((360n) - 5p) / (10u)))))) + ((((ceil(((360n) - 5p) / (10u))) / 2) - floor((ceil(((360n) - 5p) / (10u))) / 2) != 0) ? ((100n > (((60n) - 0) + 80n) ? 100n : (((60n) - 0) + 80n)) * ((360n) / (ceil(((360n) - 5p) / (10u))))) : 0)) / 1 / (((360n) / (ceil(((360n) - 5p) / (10u)))) * (ceil(((360n) - 5p) / (10u))) * ((360n) / (ceil(((360n) - 5p) / (10u)))) * (ceil(((360n) - 5p) / (10u))))           nrs=(((360n) / (ceil(((360n) - 5p) / (10u)))) < 119.5n) ? ((((50n > (((60n) - 0) + 60n) ? 50n : (((60n) - 0) + 60n)) * 120n) + (((360n) / (ceil(((360n) - 5p) / (10u)))) * 50n)) + (floor(((ceil(((360n) - 5p) / (10u))) - 1) / 2.0) * (((((60n) - 0) + 60n) * 120n) + (((360n) / (ceil(((360n) - 5p) / (10u)))) * 100n))) + ((((ceil(((360n) - 5p) / (10u))) / 2) - floor((ceil(((360n) - 5p) / (10u))) / 2) == 0) ? (((50n > (((60n) - 0) + 60n) ? 50n : (((60n) - 0) + 60n)) * 120n) + (((360n) / (ceil(((360n) - 5p) / (10u)))) * 50n)) : 0)) / 1 : (((100n > (((60n) - 0) + 80n) ? 100n : (((60n) - 0) + 80n)) * ((360n) / (ceil(((360n) - 5p) / (10u))))) + (floor(((ceil(((360n) - 5p) / (10u))) - 1) / 2.0) * ((60n > (((60n) - 0) + 50n) ? 60n : (((60n) - 0) + 50n)) * ((360n) / (ceil(((360n) - 5p) / (10u)))))) + ((((ceil(((360n) - 5p) / (10u))) / 2) - floor((ceil(((360n) - 5p) / (10u))) / 2) == 0) ? ((100n > (((60n) - 0) + 80n) ? 100n : (((60n) - 0) + 80n)) * ((360n) / (ceil(((360n) - 5p) / (10u))))) : 0)) / 1 / (((360n) / (ceil(((360n) - 5p) / (10u)))) * (ceil(((360n) - 5p) / (10u))) * ((360n) / (ceil(((360n) - 5p) / (10u)))) * (ceil(((360n) - 5p) / (10u))))           sa=(((360n) / (ceil(((360n) - 5p) / (10u)))) < 119.5n) ? (50n > (((60n) - 0) + 60n) ? 50n : (((60n) - 0) + 60n)) + 5e-08 : (100n > (((60n) - 0) + 80n) ? 100n : (((60n) - 0) + 80n))           sb=(((360n) / (ceil(((360n) - 5p) / (10u)))) < 119.5n) ? (50n > (((60n) - 0) + 60n) ? 50n : (((60n) - 0) + 60n)) + 5e-08 : (100n > (((60n) - 0) + 80n) ? 100n : (((60n) - 0) + 80n))           sd=(((360n) / (ceil(((360n) - 5p) / (10u)))) < 119.5n) ? (((60n) - 0) + 60n) + (2*5e-08) : (60n > (((60n) - 0) + 50n) ? 60n : (((60n) - 0) + 50n))           sca=(( ((360n) / (ceil(((360n) - 5p) / (10u)))) * ( (((1u) * (1u) / ((((360n) / (ceil(((360n) - 5p) / (10u)))) < 119.5n) ? (50n > (((60n) - 0) + 60n) ? 50n : (((60n) - 0) + 60n)) + 5e-08 : (100n > (((60n) - 0) + 80n) ? 100n : (((60n) - 0) + 80n))+60n)) - ((1u) * (1u) / (((((360n) / (ceil(((360n) - 5p) / (10u)))) < 119.5n) ? (50n > (((60n) - 0) + 60n) ? 50n : (((60n) - 0) + 60n)) + 5e-08 : (100n > (((60n) - 0) + 80n) ? 100n : (((60n) - 0) + 80n))+60n)+(45n)))) + ((1u) * (1u) / ((((360n) / (ceil(((360n) - 5p) / (10u)))) < 119.5n) ? (50n > (((60n) - 0) + 60n) ? 50n : (((60n) - 0) + 60n)) + 5e-08 : (100n > (((60n) - 0) + 80n) ? 100n : (((60n) - 0) + 80n))+60n)) - ((1u) * (1u)/ (((((360n) / (ceil(((360n) - 5p) / (10u)))) < 119.5n) ? (50n > (((60n) - 0) + 60n) ? 50n : (((60n) - 0) + 60n)) + 5e-08 : (100n > (((60n) - 0) + 80n) ? 100n : (((60n) - 0) + 80n))+60n)+(45n))))) + ( (45n) * ( (((1u) * (1u) / (60n)) - ((1u) * (1u) / ((60n)+((360n) / (ceil(((360n) - 5p) / (10u))))))) + ((1u) * (1u) / (60n)) - ((1u) * (1u)/ ((60n)+((360n) / (ceil(((360n) - 5p) / (10u))))))))) / (((360n) / (ceil(((360n) - 5p) / (10u)))) * (45n))           scb=((((360n) / (ceil(((360n) - 5p) / (10u)))) * ((((((360n) / (ceil(((360n) - 5p) / (10u)))) < 119.5n) ? (50n > (((60n) - 0) + 60n) ? 50n : (((60n) - 0) + 60n)) + 5e-08 : (100n > (((60n) - 0) + 80n) ? 100n : (((60n) - 0) + 80n))+60n)/10 + (1u)/100)*exp(-10 * ((((360n) / (ceil(((360n) - 5p) / (10u)))) < 119.5n) ? (50n > (((60n) - 0) + 60n) ? 50n : (((60n) - 0) + 60n)) + 5e-08 : (100n > (((60n) - 0) + 80n) ? 100n : (((60n) - 0) + 80n))+60n) / (1u)) - ((((((360n) / (ceil(((360n) - 5p) / (10u)))) < 119.5n) ? (50n > (((60n) - 0) + 60n) ? 50n : (((60n) - 0) + 60n)) + 5e-08 : (100n > (((60n) - 0) + 80n) ? 100n : (((60n) - 0) + 80n))+60n)+(45n))/10 + (1u)/100)*exp(-10 * (((((360n) / (ceil(((360n) - 5p) / (10u)))) < 119.5n) ? (50n > (((60n) - 0) + 60n) ? 50n : (((60n) - 0) + 60n)) + 5e-08 : (100n > (((60n) - 0) + 80n) ? 100n : (((60n) - 0) + 80n))+60n)+(45n)) / (1u)) + (((((360n) / (ceil(((360n) - 5p) / (10u)))) < 119.5n) ? (50n > (((60n) - 0) + 60n) ? 50n : (((60n) - 0) + 60n)) + 5e-08 : (100n > (((60n) - 0) + 80n) ? 100n : (((60n) - 0) + 80n))+60n)/10 + (1u)/100)*exp(-10 * ((((360n) / (ceil(((360n) - 5p) / (10u)))) < 119.5n) ? (50n > (((60n) - 0) + 60n) ? 50n : (((60n) - 0) + 60n)) + 5e-08 : (100n > (((60n) - 0) + 80n) ? 100n : (((60n) - 0) + 80n))+60n) / (1u)) - ((((((360n) / (ceil(((360n) - 5p) / (10u)))) < 119.5n) ? (50n > (((60n) - 0) + 60n) ? 50n : (((60n) - 0) + 60n)) + 5e-08 : (100n > (((60n) - 0) + 80n) ? 100n : (((60n) - 0) + 80n))+60n)+(45n))/10 + (1u)/100)*exp(-10 * (((((360n) / (ceil(((360n) - 5p) / (10u)))) < 119.5n) ? (50n > (((60n) - 0) + 60n) ? 50n : (((60n) - 0) + 60n)) + 5e-08 : (100n > (((60n) - 0) + 80n) ? 100n : (((60n) - 0) + 80n))+60n)+(45n)) / (1u)))) + ((45n) * (((60n)/10 + (1u)/100)*exp(-10 * (60n) / (1u)) - (((60n)+((360n) / (ceil(((360n) - 5p) / (10u)))))/10 + (1u)/100)*exp(-10 * ((60n)+((360n) / (ceil(((360n) - 5p) / (10u))))) / (1u)) + ((60n)/10 + (1u)/100)*exp(-10 * (60n) / (1u)) - (((60n)+((360n) / (ceil(((360n) - 5p) / (10u)))))/10 + (1u)/100)*exp(-10 * ((60n)+((360n) / (ceil(((360n) - 5p) / (10u))))) / (1u))))) / (((360n) / (ceil(((360n) - 5p) / (10u)))) * (45n))           scc=((((360n) / (ceil(((360n) - 5p) / (10u)))) * ((((((360n) / (ceil(((360n) - 5p) / (10u)))) < 119.5n) ? (50n > (((60n) - 0) + 60n) ? 50n : (((60n) - 0) + 60n)) + 5e-08 : (100n > (((60n) - 0) + 80n) ? 100n : (((60n) - 0) + 80n))+60n)/20 + (1u)/400)*exp(-20 * ((((360n) / (ceil(((360n) - 5p) / (10u)))) < 119.5n) ? (50n > (((60n) - 0) + 60n) ? 50n : (((60n) - 0) + 60n)) + 5e-08 : (100n > (((60n) - 0) + 80n) ? 100n : (((60n) - 0) + 80n))+60n) / (1u)) - ((((((360n) / (ceil(((360n) - 5p) / (10u)))) < 119.5n) ? (50n > (((60n) - 0) + 60n) ? 50n : (((60n) - 0) + 60n)) + 5e-08 : (100n > (((60n) - 0) + 80n) ? 100n : (((60n) - 0) + 80n))+60n)+(45n))/20 + (1u)/400)*exp(-20 * (((((360n) / (ceil(((360n) - 5p) / (10u)))) < 119.5n) ? (50n > (((60n) - 0) + 60n) ? 50n : (((60n) - 0) + 60n)) + 5e-08 : (100n > (((60n) - 0) + 80n) ? 100n : (((60n) - 0) + 80n))+60n)+(45n)) / (1u)) + (((((360n) / (ceil(((360n) - 5p) / (10u)))) < 119.5n) ? (50n > (((60n) - 0) + 60n) ? 50n : (((60n) - 0) + 60n)) + 5e-08 : (100n > (((60n) - 0) + 80n) ? 100n : (((60n) - 0) + 80n))+60n)/20 + (1u)/400)*exp(-20 * ((((360n) / (ceil(((360n) - 5p) / (10u)))) < 119.5n) ? (50n > (((60n) - 0) + 60n) ? 50n : (((60n) - 0) + 60n)) + 5e-08 : (100n > (((60n) - 0) + 80n) ? 100n : (((60n) - 0) + 80n))+60n) / (1u)) - ((((((360n) / (ceil(((360n) - 5p) / (10u)))) < 119.5n) ? (50n > (((60n) - 0) + 60n) ? 50n : (((60n) - 0) + 60n)) + 5e-08 : (100n > (((60n) - 0) + 80n) ? 100n : (((60n) - 0) + 80n))+60n)+(45n))/20 + (1u)/400)*exp(-20 * (((((360n) / (ceil(((360n) - 5p) / (10u)))) < 119.5n) ? (50n > (((60n) - 0) + 60n) ? 50n : (((60n) - 0) + 60n)) + 5e-08 : (100n > (((60n) - 0) + 80n) ? 100n : (((60n) - 0) + 80n))+60n)+(45n)) / (1u)))) + ((45n) * (((60n)/20 + (1u)/400)*exp(-20 * (60n) / (1u)) - (((60n)+((360n) / (ceil(((360n) - 5p) / (10u)))))/20 + (1u)/400)*exp(-20 * ((60n)+((360n) / (ceil(((360n) - 5p) / (10u))))) / (1u)) + ((60n)/20 + (1u)/400)*exp(-20 * (60n) / (1u)) - (((60n)+((360n) / (ceil(((360n) - 5p) / (10u)))))/20 + (1u)/400)*exp(-20 * ((60n)+((360n) / (ceil(((360n) - 5p) / (10u))))) / (1u))))) / (((360n) / (ceil(((360n) - 5p) / (10u)))) * (45n))           m=(1)
ends
subckt and3 (A B E Y VDD GND)
XNAND (A B E nb VDD GND) nand3
XBUF (nb Y VDD GND) inv
ends
subckt nand2 (A B Y VDD GND)
N0 (Y A n0 GND) g45n1svt w=(720n) l=45n nf=ceil(((720n) - 5p) / (10u))           as=(((720n) / (ceil(((720n) - 5p) / (10u)))) < 119.5n) ? ((((50n > (((60n) - 0) + 60n) ? 50n : (((60n) - 0) + 60n)) * 120n) + (((720n) / (ceil(((720n) - 5p) / (10u)))) * 50n)) + (floor(((ceil(((720n) - 5p) / (10u))) - 1) / 2.0) * (((((60n) - 0) + 60n) * 120n) + (((720n) / (ceil(((720n) - 5p) / (10u)))) * 100n))) + ((((ceil(((720n) - 5p) / (10u))) / 2) - floor((ceil(((720n) - 5p) / (10u))) / 2) == 0) ? (((50n > (((60n) - 0) + 60n) ? 50n : (((60n) - 0) + 60n)) * 120n) + (((720n) / (ceil(((720n) - 5p) / (10u)))) * 50n)) : 0)) / 1 : (((100n > (((60n) - 0) + 80n) ? 100n : (((60n) - 0) + 80n)) * ((720n) / (ceil(((720n) - 5p) / (10u))))) + (floor(((ceil(((720n) - 5p) / (10u))) - 1) / 2.0) * ((60n > (((60n) - 0) + 50n) ? 60n : (((60n) - 0) + 50n)) * ((720n) / (ceil(((720n) - 5p) / (10u)))))) + ((((ceil(((720n) - 5p) / (10u))) / 2) - floor((ceil(((720n) - 5p) / (10u))) / 2) == 0) ? ((100n > (((60n) - 0) + 80n) ? 100n : (((60n) - 0) + 80n)) * ((720n) / (ceil(((720n) - 5p) / (10u))))) : 0)) / 1           ad=(((720n) / (ceil(((720n) - 5p) / (10u)))) < 119.5n) ? ((floor((ceil(((720n) - 5p) / (10u))) / 2.0) * (((((60n) - 0) + 60n) * 120n) + (((720n) / (ceil(((720n) - 5p) / (10u)))) * 100n))) + ((((ceil(((720n) - 5p) / (10u))) / 2) - floor((ceil(((720n) - 5p) / (10u))) / 2) != 0) ? (((50n > (((60n) - 0) + 60n) ? 50n : (((60n) - 0) + 60n)) * 120n) + (((720n) / (ceil(((720n) - 5p) / (10u)))) * 50n)) : 0)) / 1 : ((floor((ceil(((720n) - 5p) / (10u))) / 2.0) * ((60n > (((60n) - 0) + 50n) ? 60n : (((60n) - 0) + 50n)) * ((720n) / (ceil(((720n) - 5p) / (10u)))))) + ((((ceil(((720n) - 5p) / (10u))) / 2) - floor((ceil(((720n) - 5p) / (10u))) / 2) != 0) ? ((100n > (((60n) - 0) + 80n) ? 100n : (((60n) - 0) + 80n)) * ((720n) / (ceil(((720n) - 5p) / (10u))))) : 0)) / 1           ps=(((720n) / (ceil(((720n) - 5p) / (10u)))) < 119.5n) ? (((2 * (50n > (((60n) - 0) + 60n) ? 50n : (((60n) - 0) + 60n))) + 340n) + (floor(((ceil(((720n) - 5p) / (10u))) - 1) / 2.0) * ((2 * (((60n) - 0) + 60n)) + 440n)) + ((((ceil(((720n) - 5p) / (10u))) / 2) - floor((ceil(((720n) - 5p) / (10u))) / 2) == 0) ? ((2 * (50n > (((60n) - 0) + 60n) ? 50n : (((60n) - 0) + 60n))) + 340n) : 0)) / 1 : (((2 * (100n > (((60n) - 0) + 80n) ? 100n : (((60n) - 0) + 80n))) + (2 * ((720n) / (ceil(((720n) - 5p) / (10u)))))) + (floor(((ceil(((720n) - 5p) / (10u))) - 1) / 2.0) * ((2 * (60n > (((60n) - 0) + 50n) ? 60n : (((60n) - 0) + 50n))) + (2 * ((720n) / (ceil(((720n) - 5p) / (10u))))))) + ((((ceil(((720n) - 5p) / (10u))) / 2) - floor((ceil(((720n) - 5p) / (10u))) / 2) == 0) ? ((2 * (100n > (((60n) - 0) + 80n) ? 100n : (((60n) - 0) + 80n))) + (2 * ((720n) / (ceil(((720n) - 5p) / (10u)))))) : 0)) / 1           pd=(((720n) / (ceil(((720n) - 5p) / (10u)))) < 119.5n) ? ((floor((ceil(((720n) - 5p) / (10u))) / 2.0) * ((2 * (((60n) - 0) + 60n)) + 440n)) + ((((ceil(((720n) - 5p) / (10u))) / 2) - floor((ceil(((720n) - 5p) / (10u))) / 2) != 0) ? ((2 * (50n > (((60n) - 0) + 60n) ? 50n : (((60n) - 0) + 60n))) + 340n) : 0)) / 1 : ((floor((ceil(((720n) - 5p) / (10u))) / 2.0) * ((2 * (60n > (((60n) - 0) + 50n) ? 60n : (((60n) - 0) + 50n))) + (2 * ((720n) / (ceil(((720n) - 5p) / (10u))))))) + ((((ceil(((720n) - 5p) / (10u))) / 2) - floor((ceil(((720n) - 5p) / (10u))) / 2) != 0) ? ((2 * (100n > (((60n) - 0) + 80n) ? 100n : (((60n) - 0) + 80n))) + (2 * ((720n) / (ceil(((720n) - 5p) / (10u)))))) : 0)) / 1           nrd=(((720n) / (ceil(((720n) - 5p) / (10u)))) < 119.5n) ? ((floor((ceil(((720n) - 5p) / (10u))) / 2.0) * (((((60n) - 0) + 60n) * 120n) + (((720n) / (ceil(((720n) - 5p) / (10u)))) * 100n))) + ((((ceil(((720n) - 5p) / (10u))) / 2) - floor((ceil(((720n) - 5p) / (10u))) / 2) != 0) ? (((50n > (((60n) - 0) + 60n) ? 50n : (((60n) - 0) + 60n)) * 120n) + (((720n) / (ceil(((720n) - 5p) / (10u)))) * 50n)) : 0)) / 1 : ((floor((ceil(((720n) - 5p) / (10u))) / 2.0) * ((60n > (((60n) - 0) + 50n) ? 60n : (((60n) - 0) + 50n)) * ((720n) / (ceil(((720n) - 5p) / (10u)))))) + ((((ceil(((720n) - 5p) / (10u))) / 2) - floor((ceil(((720n) - 5p) / (10u))) / 2) != 0) ? ((100n > (((60n) - 0) + 80n) ? 100n : (((60n) - 0) + 80n)) * ((720n) / (ceil(((720n) - 5p) / (10u))))) : 0)) / 1 / (((720n) / (ceil(((720n) - 5p) / (10u)))) * (ceil(((720n) - 5p) / (10u))) * ((720n) / (ceil(((720n) - 5p) / (10u)))) * (ceil(((720n) - 5p) / (10u))))           nrs=(((720n) / (ceil(((720n) - 5p) / (10u)))) < 119.5n) ? ((((50n > (((60n) - 0) + 60n) ? 50n : (((60n) - 0) + 60n)) * 120n) + (((720n) / (ceil(((720n) - 5p) / (10u)))) * 50n)) + (floor(((ceil(((720n) - 5p) / (10u))) - 1) / 2.0) * (((((60n) - 0) + 60n) * 120n) + (((720n) / (ceil(((720n) - 5p) / (10u)))) * 100n))) + ((((ceil(((720n) - 5p) / (10u))) / 2) - floor((ceil(((720n) - 5p) / (10u))) / 2) == 0) ? (((50n > (((60n) - 0) + 60n) ? 50n : (((60n) - 0) + 60n)) * 120n) + (((720n) / (ceil(((720n) - 5p) / (10u)))) * 50n)) : 0)) / 1 : (((100n > (((60n) - 0) + 80n) ? 100n : (((60n) - 0) + 80n)) * ((720n) / (ceil(((720n) - 5p) / (10u))))) + (floor(((ceil(((720n) - 5p) / (10u))) - 1) / 2.0) * ((60n > (((60n) - 0) + 50n) ? 60n : (((60n) - 0) + 50n)) * ((720n) / (ceil(((720n) - 5p) / (10u)))))) + ((((ceil(((720n) - 5p) / (10u))) / 2) - floor((ceil(((720n) - 5p) / (10u))) / 2) == 0) ? ((100n > (((60n) - 0) + 80n) ? 100n : (((60n) - 0) + 80n)) * ((720n) / (ceil(((720n) - 5p) / (10u))))) : 0)) / 1 / (((720n) / (ceil(((720n) - 5p) / (10u)))) * (ceil(((720n) - 5p) / (10u))) * ((720n) / (ceil(((720n) - 5p) / (10u)))) * (ceil(((720n) - 5p) / (10u))))           sa=(((720n) / (ceil(((720n) - 5p) / (10u)))) < 119.5n) ? (50n > (((60n) - 0) + 60n) ? 50n : (((60n) - 0) + 60n)) + 5e-08 : (100n > (((60n) - 0) + 80n) ? 100n : (((60n) - 0) + 80n))           sb=(((720n) / (ceil(((720n) - 5p) / (10u)))) < 119.5n) ? (50n > (((60n) - 0) + 60n) ? 50n : (((60n) - 0) + 60n)) + 5e-08 : (100n > (((60n) - 0) + 80n) ? 100n : (((60n) - 0) + 80n))           sd=(((720n) / (ceil(((720n) - 5p) / (10u)))) < 119.5n) ? (((60n) - 0) + 60n) + (2*5e-08) : (60n > (((60n) - 0) + 50n) ? 60n : (((60n) - 0) + 50n))           sca=(( ((720n) / (ceil(((720n) - 5p) / (10u)))) * ( (((1u) * (1u) / ((((720n) / (ceil(((720n) - 5p) / (10u)))) < 119.5n) ? (50n > (((60n) - 0) + 60n) ? 50n : (((60n) - 0) + 60n)) + 5e-08 : (100n > (((60n) - 0) + 80n) ? 100n : (((60n) - 0) + 80n))+60n)) - ((1u) * (1u) / (((((720n) / (ceil(((720n) - 5p) / (10u)))) < 119.5n) ? (50n > (((60n) - 0) + 60n) ? 50n : (((60n) - 0) + 60n)) + 5e-08 : (100n > (((60n) - 0) + 80n) ? 100n : (((60n) - 0) + 80n))+60n)+(45n)))) + ((1u) * (1u) / ((((720n) / (ceil(((720n) - 5p) / (10u)))) < 119.5n) ? (50n > (((60n) - 0) + 60n) ? 50n : (((60n) - 0) + 60n)) + 5e-08 : (100n > (((60n) - 0) + 80n) ? 100n : (((60n) - 0) + 80n))+60n)) - ((1u) * (1u)/ (((((720n) / (ceil(((720n) - 5p) / (10u)))) < 119.5n) ? (50n > (((60n) - 0) + 60n) ? 50n : (((60n) - 0) + 60n)) + 5e-08 : (100n > (((60n) - 0) + 80n) ? 100n : (((60n) - 0) + 80n))+60n)+(45n))))) + ( (45n) * ( (((1u) * (1u) / (60n)) - ((1u) * (1u) / ((60n)+((720n) / (ceil(((720n) - 5p) / (10u))))))) + ((1u) * (1u) / (60n)) - ((1u) * (1u)/ ((60n)+((720n) / (ceil(((720n) - 5p) / (10u))))))))) / (((720n) / (ceil(((720n) - 5p) / (10u)))) * (45n))           scb=((((720n) / (ceil(((720n) - 5p) / (10u)))) * ((((((720n) / (ceil(((720n) - 5p) / (10u)))) < 119.5n) ? (50n > (((60n) - 0) + 60n) ? 50n : (((60n) - 0) + 60n)) + 5e-08 : (100n > (((60n) - 0) + 80n) ? 100n : (((60n) - 0) + 80n))+60n)/10 + (1u)/100)*exp(-10 * ((((720n) / (ceil(((720n) - 5p) / (10u)))) < 119.5n) ? (50n > (((60n) - 0) + 60n) ? 50n : (((60n) - 0) + 60n)) + 5e-08 : (100n > (((60n) - 0) + 80n) ? 100n : (((60n) - 0) + 80n))+60n) / (1u)) - ((((((720n) / (ceil(((720n) - 5p) / (10u)))) < 119.5n) ? (50n > (((60n) - 0) + 60n) ? 50n : (((60n) - 0) + 60n)) + 5e-08 : (100n > (((60n) - 0) + 80n) ? 100n : (((60n) - 0) + 80n))+60n)+(45n))/10 + (1u)/100)*exp(-10 * (((((720n) / (ceil(((720n) - 5p) / (10u)))) < 119.5n) ? (50n > (((60n) - 0) + 60n) ? 50n : (((60n) - 0) + 60n)) + 5e-08 : (100n > (((60n) - 0) + 80n) ? 100n : (((60n) - 0) + 80n))+60n)+(45n)) / (1u)) + (((((720n) / (ceil(((720n) - 5p) / (10u)))) < 119.5n) ? (50n > (((60n) - 0) + 60n) ? 50n : (((60n) - 0) + 60n)) + 5e-08 : (100n > (((60n) - 0) + 80n) ? 100n : (((60n) - 0) + 80n))+60n)/10 + (1u)/100)*exp(-10 * ((((720n) / (ceil(((720n) - 5p) / (10u)))) < 119.5n) ? (50n > (((60n) - 0) + 60n) ? 50n : (((60n) - 0) + 60n)) + 5e-08 : (100n > (((60n) - 0) + 80n) ? 100n : (((60n) - 0) + 80n))+60n) / (1u)) - ((((((720n) / (ceil(((720n) - 5p) / (10u)))) < 119.5n) ? (50n > (((60n) - 0) + 60n) ? 50n : (((60n) - 0) + 60n)) + 5e-08 : (100n > (((60n) - 0) + 80n) ? 100n : (((60n) - 0) + 80n))+60n)+(45n))/10 + (1u)/100)*exp(-10 * (((((720n) / (ceil(((720n) - 5p) / (10u)))) < 119.5n) ? (50n > (((60n) - 0) + 60n) ? 50n : (((60n) - 0) + 60n)) + 5e-08 : (100n > (((60n) - 0) + 80n) ? 100n : (((60n) - 0) + 80n))+60n)+(45n)) / (1u)))) + ((45n) * (((60n)/10 + (1u)/100)*exp(-10 * (60n) / (1u)) - (((60n)+((720n) / (ceil(((720n) - 5p) / (10u)))))/10 + (1u)/100)*exp(-10 * ((60n)+((720n) / (ceil(((720n) - 5p) / (10u))))) / (1u)) + ((60n)/10 + (1u)/100)*exp(-10 * (60n) / (1u)) - (((60n)+((720n) / (ceil(((720n) - 5p) / (10u)))))/10 + (1u)/100)*exp(-10 * ((60n)+((720n) / (ceil(((720n) - 5p) / (10u))))) / (1u))))) / (((720n) / (ceil(((720n) - 5p) / (10u)))) * (45n))           scc=((((720n) / (ceil(((720n) - 5p) / (10u)))) * ((((((720n) / (ceil(((720n) - 5p) / (10u)))) < 119.5n) ? (50n > (((60n) - 0) + 60n) ? 50n : (((60n) - 0) + 60n)) + 5e-08 : (100n > (((60n) - 0) + 80n) ? 100n : (((60n) - 0) + 80n))+60n)/20 + (1u)/400)*exp(-20 * ((((720n) / (ceil(((720n) - 5p) / (10u)))) < 119.5n) ? (50n > (((60n) - 0) + 60n) ? 50n : (((60n) - 0) + 60n)) + 5e-08 : (100n > (((60n) - 0) + 80n) ? 100n : (((60n) - 0) + 80n))+60n) / (1u)) - ((((((720n) / (ceil(((720n) - 5p) / (10u)))) < 119.5n) ? (50n > (((60n) - 0) + 60n) ? 50n : (((60n) - 0) + 60n)) + 5e-08 : (100n > (((60n) - 0) + 80n) ? 100n : (((60n) - 0) + 80n))+60n)+(45n))/20 + (1u)/400)*exp(-20 * (((((720n) / (ceil(((720n) - 5p) / (10u)))) < 119.5n) ? (50n > (((60n) - 0) + 60n) ? 50n : (((60n) - 0) + 60n)) + 5e-08 : (100n > (((60n) - 0) + 80n) ? 100n : (((60n) - 0) + 80n))+60n)+(45n)) / (1u)) + (((((720n) / (ceil(((720n) - 5p) / (10u)))) < 119.5n) ? (50n > (((60n) - 0) + 60n) ? 50n : (((60n) - 0) + 60n)) + 5e-08 : (100n > (((60n) - 0) + 80n) ? 100n : (((60n) - 0) + 80n))+60n)/20 + (1u)/400)*exp(-20 * ((((720n) / (ceil(((720n) - 5p) / (10u)))) < 119.5n) ? (50n > (((60n) - 0) + 60n) ? 50n : (((60n) - 0) + 60n)) + 5e-08 : (100n > (((60n) - 0) + 80n) ? 100n : (((60n) - 0) + 80n))+60n) / (1u)) - ((((((720n) / (ceil(((720n) - 5p) / (10u)))) < 119.5n) ? (50n > (((60n) - 0) + 60n) ? 50n : (((60n) - 0) + 60n)) + 5e-08 : (100n > (((60n) - 0) + 80n) ? 100n : (((60n) - 0) + 80n))+60n)+(45n))/20 + (1u)/400)*exp(-20 * (((((720n) / (ceil(((720n) - 5p) / (10u)))) < 119.5n) ? (50n > (((60n) - 0) + 60n) ? 50n : (((60n) - 0) + 60n)) + 5e-08 : (100n > (((60n) - 0) + 80n) ? 100n : (((60n) - 0) + 80n))+60n)+(45n)) / (1u)))) + ((45n) * (((60n)/20 + (1u)/400)*exp(-20 * (60n) / (1u)) - (((60n)+((720n) / (ceil(((720n) - 5p) / (10u)))))/20 + (1u)/400)*exp(-20 * ((60n)+((720n) / (ceil(((720n) - 5p) / (10u))))) / (1u)) + ((60n)/20 + (1u)/400)*exp(-20 * (60n) / (1u)) - (((60n)+((720n) / (ceil(((720n) - 5p) / (10u)))))/20 + (1u)/400)*exp(-20 * ((60n)+((720n) / (ceil(((720n) - 5p) / (10u))))) / (1u))))) / (((720n) / (ceil(((720n) - 5p) / (10u)))) * (45n))           m=(1)
N1 (n0 B GND GND) g45n1svt w=(720n) l=45n nf=ceil(((720n) - 5p) / (10u))           as=(((720n) / (ceil(((720n) - 5p) / (10u)))) < 119.5n) ? ((((50n > (((60n) - 0) + 60n) ? 50n : (((60n) - 0) + 60n)) * 120n) + (((720n) / (ceil(((720n) - 5p) / (10u)))) * 50n)) + (floor(((ceil(((720n) - 5p) / (10u))) - 1) / 2.0) * (((((60n) - 0) + 60n) * 120n) + (((720n) / (ceil(((720n) - 5p) / (10u)))) * 100n))) + ((((ceil(((720n) - 5p) / (10u))) / 2) - floor((ceil(((720n) - 5p) / (10u))) / 2) == 0) ? (((50n > (((60n) - 0) + 60n) ? 50n : (((60n) - 0) + 60n)) * 120n) + (((720n) / (ceil(((720n) - 5p) / (10u)))) * 50n)) : 0)) / 1 : (((100n > (((60n) - 0) + 80n) ? 100n : (((60n) - 0) + 80n)) * ((720n) / (ceil(((720n) - 5p) / (10u))))) + (floor(((ceil(((720n) - 5p) / (10u))) - 1) / 2.0) * ((60n > (((60n) - 0) + 50n) ? 60n : (((60n) - 0) + 50n)) * ((720n) / (ceil(((720n) - 5p) / (10u)))))) + ((((ceil(((720n) - 5p) / (10u))) / 2) - floor((ceil(((720n) - 5p) / (10u))) / 2) == 0) ? ((100n > (((60n) - 0) + 80n) ? 100n : (((60n) - 0) + 80n)) * ((720n) / (ceil(((720n) - 5p) / (10u))))) : 0)) / 1           ad=(((720n) / (ceil(((720n) - 5p) / (10u)))) < 119.5n) ? ((floor((ceil(((720n) - 5p) / (10u))) / 2.0) * (((((60n) - 0) + 60n) * 120n) + (((720n) / (ceil(((720n) - 5p) / (10u)))) * 100n))) + ((((ceil(((720n) - 5p) / (10u))) / 2) - floor((ceil(((720n) - 5p) / (10u))) / 2) != 0) ? (((50n > (((60n) - 0) + 60n) ? 50n : (((60n) - 0) + 60n)) * 120n) + (((720n) / (ceil(((720n) - 5p) / (10u)))) * 50n)) : 0)) / 1 : ((floor((ceil(((720n) - 5p) / (10u))) / 2.0) * ((60n > (((60n) - 0) + 50n) ? 60n : (((60n) - 0) + 50n)) * ((720n) / (ceil(((720n) - 5p) / (10u)))))) + ((((ceil(((720n) - 5p) / (10u))) / 2) - floor((ceil(((720n) - 5p) / (10u))) / 2) != 0) ? ((100n > (((60n) - 0) + 80n) ? 100n : (((60n) - 0) + 80n)) * ((720n) / (ceil(((720n) - 5p) / (10u))))) : 0)) / 1           ps=(((720n) / (ceil(((720n) - 5p) / (10u)))) < 119.5n) ? (((2 * (50n > (((60n) - 0) + 60n) ? 50n : (((60n) - 0) + 60n))) + 340n) + (floor(((ceil(((720n) - 5p) / (10u))) - 1) / 2.0) * ((2 * (((60n) - 0) + 60n)) + 440n)) + ((((ceil(((720n) - 5p) / (10u))) / 2) - floor((ceil(((720n) - 5p) / (10u))) / 2) == 0) ? ((2 * (50n > (((60n) - 0) + 60n) ? 50n : (((60n) - 0) + 60n))) + 340n) : 0)) / 1 : (((2 * (100n > (((60n) - 0) + 80n) ? 100n : (((60n) - 0) + 80n))) + (2 * ((720n) / (ceil(((720n) - 5p) / (10u)))))) + (floor(((ceil(((720n) - 5p) / (10u))) - 1) / 2.0) * ((2 * (60n > (((60n) - 0) + 50n) ? 60n : (((60n) - 0) + 50n))) + (2 * ((720n) / (ceil(((720n) - 5p) / (10u))))))) + ((((ceil(((720n) - 5p) / (10u))) / 2) - floor((ceil(((720n) - 5p) / (10u))) / 2) == 0) ? ((2 * (100n > (((60n) - 0) + 80n) ? 100n : (((60n) - 0) + 80n))) + (2 * ((720n) / (ceil(((720n) - 5p) / (10u)))))) : 0)) / 1           pd=(((720n) / (ceil(((720n) - 5p) / (10u)))) < 119.5n) ? ((floor((ceil(((720n) - 5p) / (10u))) / 2.0) * ((2 * (((60n) - 0) + 60n)) + 440n)) + ((((ceil(((720n) - 5p) / (10u))) / 2) - floor((ceil(((720n) - 5p) / (10u))) / 2) != 0) ? ((2 * (50n > (((60n) - 0) + 60n) ? 50n : (((60n) - 0) + 60n))) + 340n) : 0)) / 1 : ((floor((ceil(((720n) - 5p) / (10u))) / 2.0) * ((2 * (60n > (((60n) - 0) + 50n) ? 60n : (((60n) - 0) + 50n))) + (2 * ((720n) / (ceil(((720n) - 5p) / (10u))))))) + ((((ceil(((720n) - 5p) / (10u))) / 2) - floor((ceil(((720n) - 5p) / (10u))) / 2) != 0) ? ((2 * (100n > (((60n) - 0) + 80n) ? 100n : (((60n) - 0) + 80n))) + (2 * ((720n) / (ceil(((720n) - 5p) / (10u)))))) : 0)) / 1           nrd=(((720n) / (ceil(((720n) - 5p) / (10u)))) < 119.5n) ? ((floor((ceil(((720n) - 5p) / (10u))) / 2.0) * (((((60n) - 0) + 60n) * 120n) + (((720n) / (ceil(((720n) - 5p) / (10u)))) * 100n))) + ((((ceil(((720n) - 5p) / (10u))) / 2) - floor((ceil(((720n) - 5p) / (10u))) / 2) != 0) ? (((50n > (((60n) - 0) + 60n) ? 50n : (((60n) - 0) + 60n)) * 120n) + (((720n) / (ceil(((720n) - 5p) / (10u)))) * 50n)) : 0)) / 1 : ((floor((ceil(((720n) - 5p) / (10u))) / 2.0) * ((60n > (((60n) - 0) + 50n) ? 60n : (((60n) - 0) + 50n)) * ((720n) / (ceil(((720n) - 5p) / (10u)))))) + ((((ceil(((720n) - 5p) / (10u))) / 2) - floor((ceil(((720n) - 5p) / (10u))) / 2) != 0) ? ((100n > (((60n) - 0) + 80n) ? 100n : (((60n) - 0) + 80n)) * ((720n) / (ceil(((720n) - 5p) / (10u))))) : 0)) / 1 / (((720n) / (ceil(((720n) - 5p) / (10u)))) * (ceil(((720n) - 5p) / (10u))) * ((720n) / (ceil(((720n) - 5p) / (10u)))) * (ceil(((720n) - 5p) / (10u))))           nrs=(((720n) / (ceil(((720n) - 5p) / (10u)))) < 119.5n) ? ((((50n > (((60n) - 0) + 60n) ? 50n : (((60n) - 0) + 60n)) * 120n) + (((720n) / (ceil(((720n) - 5p) / (10u)))) * 50n)) + (floor(((ceil(((720n) - 5p) / (10u))) - 1) / 2.0) * (((((60n) - 0) + 60n) * 120n) + (((720n) / (ceil(((720n) - 5p) / (10u)))) * 100n))) + ((((ceil(((720n) - 5p) / (10u))) / 2) - floor((ceil(((720n) - 5p) / (10u))) / 2) == 0) ? (((50n > (((60n) - 0) + 60n) ? 50n : (((60n) - 0) + 60n)) * 120n) + (((720n) / (ceil(((720n) - 5p) / (10u)))) * 50n)) : 0)) / 1 : (((100n > (((60n) - 0) + 80n) ? 100n : (((60n) - 0) + 80n)) * ((720n) / (ceil(((720n) - 5p) / (10u))))) + (floor(((ceil(((720n) - 5p) / (10u))) - 1) / 2.0) * ((60n > (((60n) - 0) + 50n) ? 60n : (((60n) - 0) + 50n)) * ((720n) / (ceil(((720n) - 5p) / (10u)))))) + ((((ceil(((720n) - 5p) / (10u))) / 2) - floor((ceil(((720n) - 5p) / (10u))) / 2) == 0) ? ((100n > (((60n) - 0) + 80n) ? 100n : (((60n) - 0) + 80n)) * ((720n) / (ceil(((720n) - 5p) / (10u))))) : 0)) / 1 / (((720n) / (ceil(((720n) - 5p) / (10u)))) * (ceil(((720n) - 5p) / (10u))) * ((720n) / (ceil(((720n) - 5p) / (10u)))) * (ceil(((720n) - 5p) / (10u))))           sa=(((720n) / (ceil(((720n) - 5p) / (10u)))) < 119.5n) ? (50n > (((60n) - 0) + 60n) ? 50n : (((60n) - 0) + 60n)) + 5e-08 : (100n > (((60n) - 0) + 80n) ? 100n : (((60n) - 0) + 80n))           sb=(((720n) / (ceil(((720n) - 5p) / (10u)))) < 119.5n) ? (50n > (((60n) - 0) + 60n) ? 50n : (((60n) - 0) + 60n)) + 5e-08 : (100n > (((60n) - 0) + 80n) ? 100n : (((60n) - 0) + 80n))           sd=(((720n) / (ceil(((720n) - 5p) / (10u)))) < 119.5n) ? (((60n) - 0) + 60n) + (2*5e-08) : (60n > (((60n) - 0) + 50n) ? 60n : (((60n) - 0) + 50n))           sca=(( ((720n) / (ceil(((720n) - 5p) / (10u)))) * ( (((1u) * (1u) / ((((720n) / (ceil(((720n) - 5p) / (10u)))) < 119.5n) ? (50n > (((60n) - 0) + 60n) ? 50n : (((60n) - 0) + 60n)) + 5e-08 : (100n > (((60n) - 0) + 80n) ? 100n : (((60n) - 0) + 80n))+60n)) - ((1u) * (1u) / (((((720n) / (ceil(((720n) - 5p) / (10u)))) < 119.5n) ? (50n > (((60n) - 0) + 60n) ? 50n : (((60n) - 0) + 60n)) + 5e-08 : (100n > (((60n) - 0) + 80n) ? 100n : (((60n) - 0) + 80n))+60n)+(45n)))) + ((1u) * (1u) / ((((720n) / (ceil(((720n) - 5p) / (10u)))) < 119.5n) ? (50n > (((60n) - 0) + 60n) ? 50n : (((60n) - 0) + 60n)) + 5e-08 : (100n > (((60n) - 0) + 80n) ? 100n : (((60n) - 0) + 80n))+60n)) - ((1u) * (1u)/ (((((720n) / (ceil(((720n) - 5p) / (10u)))) < 119.5n) ? (50n > (((60n) - 0) + 60n) ? 50n : (((60n) - 0) + 60n)) + 5e-08 : (100n > (((60n) - 0) + 80n) ? 100n : (((60n) - 0) + 80n))+60n)+(45n))))) + ( (45n) * ( (((1u) * (1u) / (60n)) - ((1u) * (1u) / ((60n)+((720n) / (ceil(((720n) - 5p) / (10u))))))) + ((1u) * (1u) / (60n)) - ((1u) * (1u)/ ((60n)+((720n) / (ceil(((720n) - 5p) / (10u))))))))) / (((720n) / (ceil(((720n) - 5p) / (10u)))) * (45n))           scb=((((720n) / (ceil(((720n) - 5p) / (10u)))) * ((((((720n) / (ceil(((720n) - 5p) / (10u)))) < 119.5n) ? (50n > (((60n) - 0) + 60n) ? 50n : (((60n) - 0) + 60n)) + 5e-08 : (100n > (((60n) - 0) + 80n) ? 100n : (((60n) - 0) + 80n))+60n)/10 + (1u)/100)*exp(-10 * ((((720n) / (ceil(((720n) - 5p) / (10u)))) < 119.5n) ? (50n > (((60n) - 0) + 60n) ? 50n : (((60n) - 0) + 60n)) + 5e-08 : (100n > (((60n) - 0) + 80n) ? 100n : (((60n) - 0) + 80n))+60n) / (1u)) - ((((((720n) / (ceil(((720n) - 5p) / (10u)))) < 119.5n) ? (50n > (((60n) - 0) + 60n) ? 50n : (((60n) - 0) + 60n)) + 5e-08 : (100n > (((60n) - 0) + 80n) ? 100n : (((60n) - 0) + 80n))+60n)+(45n))/10 + (1u)/100)*exp(-10 * (((((720n) / (ceil(((720n) - 5p) / (10u)))) < 119.5n) ? (50n > (((60n) - 0) + 60n) ? 50n : (((60n) - 0) + 60n)) + 5e-08 : (100n > (((60n) - 0) + 80n) ? 100n : (((60n) - 0) + 80n))+60n)+(45n)) / (1u)) + (((((720n) / (ceil(((720n) - 5p) / (10u)))) < 119.5n) ? (50n > (((60n) - 0) + 60n) ? 50n : (((60n) - 0) + 60n)) + 5e-08 : (100n > (((60n) - 0) + 80n) ? 100n : (((60n) - 0) + 80n))+60n)/10 + (1u)/100)*exp(-10 * ((((720n) / (ceil(((720n) - 5p) / (10u)))) < 119.5n) ? (50n > (((60n) - 0) + 60n) ? 50n : (((60n) - 0) + 60n)) + 5e-08 : (100n > (((60n) - 0) + 80n) ? 100n : (((60n) - 0) + 80n))+60n) / (1u)) - ((((((720n) / (ceil(((720n) - 5p) / (10u)))) < 119.5n) ? (50n > (((60n) - 0) + 60n) ? 50n : (((60n) - 0) + 60n)) + 5e-08 : (100n > (((60n) - 0) + 80n) ? 100n : (((60n) - 0) + 80n))+60n)+(45n))/10 + (1u)/100)*exp(-10 * (((((720n) / (ceil(((720n) - 5p) / (10u)))) < 119.5n) ? (50n > (((60n) - 0) + 60n) ? 50n : (((60n) - 0) + 60n)) + 5e-08 : (100n > (((60n) - 0) + 80n) ? 100n : (((60n) - 0) + 80n))+60n)+(45n)) / (1u)))) + ((45n) * (((60n)/10 + (1u)/100)*exp(-10 * (60n) / (1u)) - (((60n)+((720n) / (ceil(((720n) - 5p) / (10u)))))/10 + (1u)/100)*exp(-10 * ((60n)+((720n) / (ceil(((720n) - 5p) / (10u))))) / (1u)) + ((60n)/10 + (1u)/100)*exp(-10 * (60n) / (1u)) - (((60n)+((720n) / (ceil(((720n) - 5p) / (10u)))))/10 + (1u)/100)*exp(-10 * ((60n)+((720n) / (ceil(((720n) - 5p) / (10u))))) / (1u))))) / (((720n) / (ceil(((720n) - 5p) / (10u)))) * (45n))           scc=((((720n) / (ceil(((720n) - 5p) / (10u)))) * ((((((720n) / (ceil(((720n) - 5p) / (10u)))) < 119.5n) ? (50n > (((60n) - 0) + 60n) ? 50n : (((60n) - 0) + 60n)) + 5e-08 : (100n > (((60n) - 0) + 80n) ? 100n : (((60n) - 0) + 80n))+60n)/20 + (1u)/400)*exp(-20 * ((((720n) / (ceil(((720n) - 5p) / (10u)))) < 119.5n) ? (50n > (((60n) - 0) + 60n) ? 50n : (((60n) - 0) + 60n)) + 5e-08 : (100n > (((60n) - 0) + 80n) ? 100n : (((60n) - 0) + 80n))+60n) / (1u)) - ((((((720n) / (ceil(((720n) - 5p) / (10u)))) < 119.5n) ? (50n > (((60n) - 0) + 60n) ? 50n : (((60n) - 0) + 60n)) + 5e-08 : (100n > (((60n) - 0) + 80n) ? 100n : (((60n) - 0) + 80n))+60n)+(45n))/20 + (1u)/400)*exp(-20 * (((((720n) / (ceil(((720n) - 5p) / (10u)))) < 119.5n) ? (50n > (((60n) - 0) + 60n) ? 50n : (((60n) - 0) + 60n)) + 5e-08 : (100n > (((60n) - 0) + 80n) ? 100n : (((60n) - 0) + 80n))+60n)+(45n)) / (1u)) + (((((720n) / (ceil(((720n) - 5p) / (10u)))) < 119.5n) ? (50n > (((60n) - 0) + 60n) ? 50n : (((60n) - 0) + 60n)) + 5e-08 : (100n > (((60n) - 0) + 80n) ? 100n : (((60n) - 0) + 80n))+60n)/20 + (1u)/400)*exp(-20 * ((((720n) / (ceil(((720n) - 5p) / (10u)))) < 119.5n) ? (50n > (((60n) - 0) + 60n) ? 50n : (((60n) - 0) + 60n)) + 5e-08 : (100n > (((60n) - 0) + 80n) ? 100n : (((60n) - 0) + 80n))+60n) / (1u)) - ((((((720n) / (ceil(((720n) - 5p) / (10u)))) < 119.5n) ? (50n > (((60n) - 0) + 60n) ? 50n : (((60n) - 0) + 60n)) + 5e-08 : (100n > (((60n) - 0) + 80n) ? 100n : (((60n) - 0) + 80n))+60n)+(45n))/20 + (1u)/400)*exp(-20 * (((((720n) / (ceil(((720n) - 5p) / (10u)))) < 119.5n) ? (50n > (((60n) - 0) + 60n) ? 50n : (((60n) - 0) + 60n)) + 5e-08 : (100n > (((60n) - 0) + 80n) ? 100n : (((60n) - 0) + 80n))+60n)+(45n)) / (1u)))) + ((45n) * (((60n)/20 + (1u)/400)*exp(-20 * (60n) / (1u)) - (((60n)+((720n) / (ceil(((720n) - 5p) / (10u)))))/20 + (1u)/400)*exp(-20 * ((60n)+((720n) / (ceil(((720n) - 5p) / (10u))))) / (1u)) + ((60n)/20 + (1u)/400)*exp(-20 * (60n) / (1u)) - (((60n)+((720n) / (ceil(((720n) - 5p) / (10u)))))/20 + (1u)/400)*exp(-20 * ((60n)+((720n) / (ceil(((720n) - 5p) / (10u))))) / (1u))))) / (((720n) / (ceil(((720n) - 5p) / (10u)))) * (45n))           m=(1)
P0 (Y A VDD VDD) g45p1svt w=(360n) l=45n nf=ceil(((360n) - 5p) / (10u))           as=(((360n) / (ceil(((360n) - 5p) / (10u)))) < 119.5n) ? ((((50n > (((60n) - 0) + 60n) ? 50n : (((60n) - 0) + 60n)) * 120n) + (((360n) / (ceil(((360n) - 5p) / (10u)))) * 50n)) + (floor(((ceil(((360n) - 5p) / (10u))) - 1) / 2.0) * (((((60n) - 0) + 60n) * 120n) + (((360n) / (ceil(((360n) - 5p) / (10u)))) * 100n))) + ((((ceil(((360n) - 5p) / (10u))) / 2) - floor((ceil(((360n) - 5p) / (10u))) / 2) == 0) ? (((50n > (((60n) - 0) + 60n) ? 50n : (((60n) - 0) + 60n)) * 120n) + (((360n) / (ceil(((360n) - 5p) / (10u)))) * 50n)) : 0)) / 1 : (((100n > (((60n) - 0) + 80n) ? 100n : (((60n) - 0) + 80n)) * ((360n) / (ceil(((360n) - 5p) / (10u))))) + (floor(((ceil(((360n) - 5p) / (10u))) - 1) / 2.0) * ((60n > (((60n) - 0) + 50n) ? 60n : (((60n) - 0) + 50n)) * ((360n) / (ceil(((360n) - 5p) / (10u)))))) + ((((ceil(((360n) - 5p) / (10u))) / 2) - floor((ceil(((360n) - 5p) / (10u))) / 2) == 0) ? ((100n > (((60n) - 0) + 80n) ? 100n : (((60n) - 0) + 80n)) * ((360n) / (ceil(((360n) - 5p) / (10u))))) : 0)) / 1           ad=(((360n) / (ceil(((360n) - 5p) / (10u)))) < 119.5n) ? ((floor((ceil(((360n) - 5p) / (10u))) / 2.0) * (((((60n) - 0) + 60n) * 120n) + (((360n) / (ceil(((360n) - 5p) / (10u)))) * 100n))) + ((((ceil(((360n) - 5p) / (10u))) / 2) - floor((ceil(((360n) - 5p) / (10u))) / 2) != 0) ? (((50n > (((60n) - 0) + 60n) ? 50n : (((60n) - 0) + 60n)) * 120n) + (((360n) / (ceil(((360n) - 5p) / (10u)))) * 50n)) : 0)) / 1 : ((floor((ceil(((360n) - 5p) / (10u))) / 2.0) * ((60n > (((60n) - 0) + 50n) ? 60n : (((60n) - 0) + 50n)) * ((360n) / (ceil(((360n) - 5p) / (10u)))))) + ((((ceil(((360n) - 5p) / (10u))) / 2) - floor((ceil(((360n) - 5p) / (10u))) / 2) != 0) ? ((100n > (((60n) - 0) + 80n) ? 100n : (((60n) - 0) + 80n)) * ((360n) / (ceil(((360n) - 5p) / (10u))))) : 0)) / 1           ps=(((360n) / (ceil(((360n) - 5p) / (10u)))) < 119.5n) ? (((2 * (50n > (((60n) - 0) + 60n) ? 50n : (((60n) - 0) + 60n))) + 340n) + (floor(((ceil(((360n) - 5p) / (10u))) - 1) / 2.0) * ((2 * (((60n) - 0) + 60n)) + 440n)) + ((((ceil(((360n) - 5p) / (10u))) / 2) - floor((ceil(((360n) - 5p) / (10u))) / 2) == 0) ? ((2 * (50n > (((60n) - 0) + 60n) ? 50n : (((60n) - 0) + 60n))) + 340n) : 0)) / 1 : (((2 * (100n > (((60n) - 0) + 80n) ? 100n : (((60n) - 0) + 80n))) + (2 * ((360n) / (ceil(((360n) - 5p) / (10u)))))) + (floor(((ceil(((360n) - 5p) / (10u))) - 1) / 2.0) * ((2 * (60n > (((60n) - 0) + 50n) ? 60n : (((60n) - 0) + 50n))) + (2 * ((360n) / (ceil(((360n) - 5p) / (10u))))))) + ((((ceil(((360n) - 5p) / (10u))) / 2) - floor((ceil(((360n) - 5p) / (10u))) / 2) == 0) ? ((2 * (100n > (((60n) - 0) + 80n) ? 100n : (((60n) - 0) + 80n))) + (2 * ((360n) / (ceil(((360n) - 5p) / (10u)))))) : 0)) / 1           pd=(((360n) / (ceil(((360n) - 5p) / (10u)))) < 119.5n) ? ((floor((ceil(((360n) - 5p) / (10u))) / 2.0) * ((2 * (((60n) - 0) + 60n)) + 440n)) + ((((ceil(((360n) - 5p) / (10u))) / 2) - floor((ceil(((360n) - 5p) / (10u))) / 2) != 0) ? ((2 * (50n > (((60n) - 0) + 60n) ? 50n : (((60n) - 0) + 60n))) + 340n) : 0)) / 1 : ((floor((ceil(((360n) - 5p) / (10u))) / 2.0) * ((2 * (60n > (((60n) - 0) + 50n) ? 60n : (((60n) - 0) + 50n))) + (2 * ((360n) / (ceil(((360n) - 5p) / (10u))))))) + ((((ceil(((360n) - 5p) / (10u))) / 2) - floor((ceil(((360n) - 5p) / (10u))) / 2) != 0) ? ((2 * (100n > (((60n) - 0) + 80n) ? 100n : (((60n) - 0) + 80n))) + (2 * ((360n) / (ceil(((360n) - 5p) / (10u)))))) : 0)) / 1           nrd=(((360n) / (ceil(((360n) - 5p) / (10u)))) < 119.5n) ? ((floor((ceil(((360n) - 5p) / (10u))) / 2.0) * (((((60n) - 0) + 60n) * 120n) + (((360n) / (ceil(((360n) - 5p) / (10u)))) * 100n))) + ((((ceil(((360n) - 5p) / (10u))) / 2) - floor((ceil(((360n) - 5p) / (10u))) / 2) != 0) ? (((50n > (((60n) - 0) + 60n) ? 50n : (((60n) - 0) + 60n)) * 120n) + (((360n) / (ceil(((360n) - 5p) / (10u)))) * 50n)) : 0)) / 1 : ((floor((ceil(((360n) - 5p) / (10u))) / 2.0) * ((60n > (((60n) - 0) + 50n) ? 60n : (((60n) - 0) + 50n)) * ((360n) / (ceil(((360n) - 5p) / (10u)))))) + ((((ceil(((360n) - 5p) / (10u))) / 2) - floor((ceil(((360n) - 5p) / (10u))) / 2) != 0) ? ((100n > (((60n) - 0) + 80n) ? 100n : (((60n) - 0) + 80n)) * ((360n) / (ceil(((360n) - 5p) / (10u))))) : 0)) / 1 / (((360n) / (ceil(((360n) - 5p) / (10u)))) * (ceil(((360n) - 5p) / (10u))) * ((360n) / (ceil(((360n) - 5p) / (10u)))) * (ceil(((360n) - 5p) / (10u))))           nrs=(((360n) / (ceil(((360n) - 5p) / (10u)))) < 119.5n) ? ((((50n > (((60n) - 0) + 60n) ? 50n : (((60n) - 0) + 60n)) * 120n) + (((360n) / (ceil(((360n) - 5p) / (10u)))) * 50n)) + (floor(((ceil(((360n) - 5p) / (10u))) - 1) / 2.0) * (((((60n) - 0) + 60n) * 120n) + (((360n) / (ceil(((360n) - 5p) / (10u)))) * 100n))) + ((((ceil(((360n) - 5p) / (10u))) / 2) - floor((ceil(((360n) - 5p) / (10u))) / 2) == 0) ? (((50n > (((60n) - 0) + 60n) ? 50n : (((60n) - 0) + 60n)) * 120n) + (((360n) / (ceil(((360n) - 5p) / (10u)))) * 50n)) : 0)) / 1 : (((100n > (((60n) - 0) + 80n) ? 100n : (((60n) - 0) + 80n)) * ((360n) / (ceil(((360n) - 5p) / (10u))))) + (floor(((ceil(((360n) - 5p) / (10u))) - 1) / 2.0) * ((60n > (((60n) - 0) + 50n) ? 60n : (((60n) - 0) + 50n)) * ((360n) / (ceil(((360n) - 5p) / (10u)))))) + ((((ceil(((360n) - 5p) / (10u))) / 2) - floor((ceil(((360n) - 5p) / (10u))) / 2) == 0) ? ((100n > (((60n) - 0) + 80n) ? 100n : (((60n) - 0) + 80n)) * ((360n) / (ceil(((360n) - 5p) / (10u))))) : 0)) / 1 / (((360n) / (ceil(((360n) - 5p) / (10u)))) * (ceil(((360n) - 5p) / (10u))) * ((360n) / (ceil(((360n) - 5p) / (10u)))) * (ceil(((360n) - 5p) / (10u))))           sa=(((360n) / (ceil(((360n) - 5p) / (10u)))) < 119.5n) ? (50n > (((60n) - 0) + 60n) ? 50n : (((60n) - 0) + 60n)) + 5e-08 : (100n > (((60n) - 0) + 80n) ? 100n : (((60n) - 0) + 80n))           sb=(((360n) / (ceil(((360n) - 5p) / (10u)))) < 119.5n) ? (50n > (((60n) - 0) + 60n) ? 50n : (((60n) - 0) + 60n)) + 5e-08 : (100n > (((60n) - 0) + 80n) ? 100n : (((60n) - 0) + 80n))           sd=(((360n) / (ceil(((360n) - 5p) / (10u)))) < 119.5n) ? (((60n) - 0) + 60n) + (2*5e-08) : (60n > (((60n) - 0) + 50n) ? 60n : (((60n) - 0) + 50n))           sca=(( ((360n) / (ceil(((360n) - 5p) / (10u)))) * ( (((1u) * (1u) / ((((360n) / (ceil(((360n) - 5p) / (10u)))) < 119.5n) ? (50n > (((60n) - 0) + 60n) ? 50n : (((60n) - 0) + 60n)) + 5e-08 : (100n > (((60n) - 0) + 80n) ? 100n : (((60n) - 0) + 80n))+60n)) - ((1u) * (1u) / (((((360n) / (ceil(((360n) - 5p) / (10u)))) < 119.5n) ? (50n > (((60n) - 0) + 60n) ? 50n : (((60n) - 0) + 60n)) + 5e-08 : (100n > (((60n) - 0) + 80n) ? 100n : (((60n) - 0) + 80n))+60n)+(45n)))) + ((1u) * (1u) / ((((360n) / (ceil(((360n) - 5p) / (10u)))) < 119.5n) ? (50n > (((60n) - 0) + 60n) ? 50n : (((60n) - 0) + 60n)) + 5e-08 : (100n > (((60n) - 0) + 80n) ? 100n : (((60n) - 0) + 80n))+60n)) - ((1u) * (1u)/ (((((360n) / (ceil(((360n) - 5p) / (10u)))) < 119.5n) ? (50n > (((60n) - 0) + 60n) ? 50n : (((60n) - 0) + 60n)) + 5e-08 : (100n > (((60n) - 0) + 80n) ? 100n : (((60n) - 0) + 80n))+60n)+(45n))))) + ( (45n) * ( (((1u) * (1u) / (60n)) - ((1u) * (1u) / ((60n)+((360n) / (ceil(((360n) - 5p) / (10u))))))) + ((1u) * (1u) / (60n)) - ((1u) * (1u)/ ((60n)+((360n) / (ceil(((360n) - 5p) / (10u))))))))) / (((360n) / (ceil(((360n) - 5p) / (10u)))) * (45n))           scb=((((360n) / (ceil(((360n) - 5p) / (10u)))) * ((((((360n) / (ceil(((360n) - 5p) / (10u)))) < 119.5n) ? (50n > (((60n) - 0) + 60n) ? 50n : (((60n) - 0) + 60n)) + 5e-08 : (100n > (((60n) - 0) + 80n) ? 100n : (((60n) - 0) + 80n))+60n)/10 + (1u)/100)*exp(-10 * ((((360n) / (ceil(((360n) - 5p) / (10u)))) < 119.5n) ? (50n > (((60n) - 0) + 60n) ? 50n : (((60n) - 0) + 60n)) + 5e-08 : (100n > (((60n) - 0) + 80n) ? 100n : (((60n) - 0) + 80n))+60n) / (1u)) - ((((((360n) / (ceil(((360n) - 5p) / (10u)))) < 119.5n) ? (50n > (((60n) - 0) + 60n) ? 50n : (((60n) - 0) + 60n)) + 5e-08 : (100n > (((60n) - 0) + 80n) ? 100n : (((60n) - 0) + 80n))+60n)+(45n))/10 + (1u)/100)*exp(-10 * (((((360n) / (ceil(((360n) - 5p) / (10u)))) < 119.5n) ? (50n > (((60n) - 0) + 60n) ? 50n : (((60n) - 0) + 60n)) + 5e-08 : (100n > (((60n) - 0) + 80n) ? 100n : (((60n) - 0) + 80n))+60n)+(45n)) / (1u)) + (((((360n) / (ceil(((360n) - 5p) / (10u)))) < 119.5n) ? (50n > (((60n) - 0) + 60n) ? 50n : (((60n) - 0) + 60n)) + 5e-08 : (100n > (((60n) - 0) + 80n) ? 100n : (((60n) - 0) + 80n))+60n)/10 + (1u)/100)*exp(-10 * ((((360n) / (ceil(((360n) - 5p) / (10u)))) < 119.5n) ? (50n > (((60n) - 0) + 60n) ? 50n : (((60n) - 0) + 60n)) + 5e-08 : (100n > (((60n) - 0) + 80n) ? 100n : (((60n) - 0) + 80n))+60n) / (1u)) - ((((((360n) / (ceil(((360n) - 5p) / (10u)))) < 119.5n) ? (50n > (((60n) - 0) + 60n) ? 50n : (((60n) - 0) + 60n)) + 5e-08 : (100n > (((60n) - 0) + 80n) ? 100n : (((60n) - 0) + 80n))+60n)+(45n))/10 + (1u)/100)*exp(-10 * (((((360n) / (ceil(((360n) - 5p) / (10u)))) < 119.5n) ? (50n > (((60n) - 0) + 60n) ? 50n : (((60n) - 0) + 60n)) + 5e-08 : (100n > (((60n) - 0) + 80n) ? 100n : (((60n) - 0) + 80n))+60n)+(45n)) / (1u)))) + ((45n) * (((60n)/10 + (1u)/100)*exp(-10 * (60n) / (1u)) - (((60n)+((360n) / (ceil(((360n) - 5p) / (10u)))))/10 + (1u)/100)*exp(-10 * ((60n)+((360n) / (ceil(((360n) - 5p) / (10u))))) / (1u)) + ((60n)/10 + (1u)/100)*exp(-10 * (60n) / (1u)) - (((60n)+((360n) / (ceil(((360n) - 5p) / (10u)))))/10 + (1u)/100)*exp(-10 * ((60n)+((360n) / (ceil(((360n) - 5p) / (10u))))) / (1u))))) / (((360n) / (ceil(((360n) - 5p) / (10u)))) * (45n))           scc=((((360n) / (ceil(((360n) - 5p) / (10u)))) * ((((((360n) / (ceil(((360n) - 5p) / (10u)))) < 119.5n) ? (50n > (((60n) - 0) + 60n) ? 50n : (((60n) - 0) + 60n)) + 5e-08 : (100n > (((60n) - 0) + 80n) ? 100n : (((60n) - 0) + 80n))+60n)/20 + (1u)/400)*exp(-20 * ((((360n) / (ceil(((360n) - 5p) / (10u)))) < 119.5n) ? (50n > (((60n) - 0) + 60n) ? 50n : (((60n) - 0) + 60n)) + 5e-08 : (100n > (((60n) - 0) + 80n) ? 100n : (((60n) - 0) + 80n))+60n) / (1u)) - ((((((360n) / (ceil(((360n) - 5p) / (10u)))) < 119.5n) ? (50n > (((60n) - 0) + 60n) ? 50n : (((60n) - 0) + 60n)) + 5e-08 : (100n > (((60n) - 0) + 80n) ? 100n : (((60n) - 0) + 80n))+60n)+(45n))/20 + (1u)/400)*exp(-20 * (((((360n) / (ceil(((360n) - 5p) / (10u)))) < 119.5n) ? (50n > (((60n) - 0) + 60n) ? 50n : (((60n) - 0) + 60n)) + 5e-08 : (100n > (((60n) - 0) + 80n) ? 100n : (((60n) - 0) + 80n))+60n)+(45n)) / (1u)) + (((((360n) / (ceil(((360n) - 5p) / (10u)))) < 119.5n) ? (50n > (((60n) - 0) + 60n) ? 50n : (((60n) - 0) + 60n)) + 5e-08 : (100n > (((60n) - 0) + 80n) ? 100n : (((60n) - 0) + 80n))+60n)/20 + (1u)/400)*exp(-20 * ((((360n) / (ceil(((360n) - 5p) / (10u)))) < 119.5n) ? (50n > (((60n) - 0) + 60n) ? 50n : (((60n) - 0) + 60n)) + 5e-08 : (100n > (((60n) - 0) + 80n) ? 100n : (((60n) - 0) + 80n))+60n) / (1u)) - ((((((360n) / (ceil(((360n) - 5p) / (10u)))) < 119.5n) ? (50n > (((60n) - 0) + 60n) ? 50n : (((60n) - 0) + 60n)) + 5e-08 : (100n > (((60n) - 0) + 80n) ? 100n : (((60n) - 0) + 80n))+60n)+(45n))/20 + (1u)/400)*exp(-20 * (((((360n) / (ceil(((360n) - 5p) / (10u)))) < 119.5n) ? (50n > (((60n) - 0) + 60n) ? 50n : (((60n) - 0) + 60n)) + 5e-08 : (100n > (((60n) - 0) + 80n) ? 100n : (((60n) - 0) + 80n))+60n)+(45n)) / (1u)))) + ((45n) * (((60n)/20 + (1u)/400)*exp(-20 * (60n) / (1u)) - (((60n)+((360n) / (ceil(((360n) - 5p) / (10u)))))/20 + (1u)/400)*exp(-20 * ((60n)+((360n) / (ceil(((360n) - 5p) / (10u))))) / (1u)) + ((60n)/20 + (1u)/400)*exp(-20 * (60n) / (1u)) - (((60n)+((360n) / (ceil(((360n) - 5p) / (10u)))))/20 + (1u)/400)*exp(-20 * ((60n)+((360n) / (ceil(((360n) - 5p) / (10u))))) / (1u))))) / (((360n) / (ceil(((360n) - 5p) / (10u)))) * (45n))           m=(1)
P1 (Y B VDD VDD) g45p1svt w=(360n) l=45n nf=ceil(((360n) - 5p) / (10u))           as=(((360n) / (ceil(((360n) - 5p) / (10u)))) < 119.5n) ? ((((50n > (((60n) - 0) + 60n) ? 50n : (((60n) - 0) + 60n)) * 120n) + (((360n) / (ceil(((360n) - 5p) / (10u)))) * 50n)) + (floor(((ceil(((360n) - 5p) / (10u))) - 1) / 2.0) * (((((60n) - 0) + 60n) * 120n) + (((360n) / (ceil(((360n) - 5p) / (10u)))) * 100n))) + ((((ceil(((360n) - 5p) / (10u))) / 2) - floor((ceil(((360n) - 5p) / (10u))) / 2) == 0) ? (((50n > (((60n) - 0) + 60n) ? 50n : (((60n) - 0) + 60n)) * 120n) + (((360n) / (ceil(((360n) - 5p) / (10u)))) * 50n)) : 0)) / 1 : (((100n > (((60n) - 0) + 80n) ? 100n : (((60n) - 0) + 80n)) * ((360n) / (ceil(((360n) - 5p) / (10u))))) + (floor(((ceil(((360n) - 5p) / (10u))) - 1) / 2.0) * ((60n > (((60n) - 0) + 50n) ? 60n : (((60n) - 0) + 50n)) * ((360n) / (ceil(((360n) - 5p) / (10u)))))) + ((((ceil(((360n) - 5p) / (10u))) / 2) - floor((ceil(((360n) - 5p) / (10u))) / 2) == 0) ? ((100n > (((60n) - 0) + 80n) ? 100n : (((60n) - 0) + 80n)) * ((360n) / (ceil(((360n) - 5p) / (10u))))) : 0)) / 1           ad=(((360n) / (ceil(((360n) - 5p) / (10u)))) < 119.5n) ? ((floor((ceil(((360n) - 5p) / (10u))) / 2.0) * (((((60n) - 0) + 60n) * 120n) + (((360n) / (ceil(((360n) - 5p) / (10u)))) * 100n))) + ((((ceil(((360n) - 5p) / (10u))) / 2) - floor((ceil(((360n) - 5p) / (10u))) / 2) != 0) ? (((50n > (((60n) - 0) + 60n) ? 50n : (((60n) - 0) + 60n)) * 120n) + (((360n) / (ceil(((360n) - 5p) / (10u)))) * 50n)) : 0)) / 1 : ((floor((ceil(((360n) - 5p) / (10u))) / 2.0) * ((60n > (((60n) - 0) + 50n) ? 60n : (((60n) - 0) + 50n)) * ((360n) / (ceil(((360n) - 5p) / (10u)))))) + ((((ceil(((360n) - 5p) / (10u))) / 2) - floor((ceil(((360n) - 5p) / (10u))) / 2) != 0) ? ((100n > (((60n) - 0) + 80n) ? 100n : (((60n) - 0) + 80n)) * ((360n) / (ceil(((360n) - 5p) / (10u))))) : 0)) / 1           ps=(((360n) / (ceil(((360n) - 5p) / (10u)))) < 119.5n) ? (((2 * (50n > (((60n) - 0) + 60n) ? 50n : (((60n) - 0) + 60n))) + 340n) + (floor(((ceil(((360n) - 5p) / (10u))) - 1) / 2.0) * ((2 * (((60n) - 0) + 60n)) + 440n)) + ((((ceil(((360n) - 5p) / (10u))) / 2) - floor((ceil(((360n) - 5p) / (10u))) / 2) == 0) ? ((2 * (50n > (((60n) - 0) + 60n) ? 50n : (((60n) - 0) + 60n))) + 340n) : 0)) / 1 : (((2 * (100n > (((60n) - 0) + 80n) ? 100n : (((60n) - 0) + 80n))) + (2 * ((360n) / (ceil(((360n) - 5p) / (10u)))))) + (floor(((ceil(((360n) - 5p) / (10u))) - 1) / 2.0) * ((2 * (60n > (((60n) - 0) + 50n) ? 60n : (((60n) - 0) + 50n))) + (2 * ((360n) / (ceil(((360n) - 5p) / (10u))))))) + ((((ceil(((360n) - 5p) / (10u))) / 2) - floor((ceil(((360n) - 5p) / (10u))) / 2) == 0) ? ((2 * (100n > (((60n) - 0) + 80n) ? 100n : (((60n) - 0) + 80n))) + (2 * ((360n) / (ceil(((360n) - 5p) / (10u)))))) : 0)) / 1           pd=(((360n) / (ceil(((360n) - 5p) / (10u)))) < 119.5n) ? ((floor((ceil(((360n) - 5p) / (10u))) / 2.0) * ((2 * (((60n) - 0) + 60n)) + 440n)) + ((((ceil(((360n) - 5p) / (10u))) / 2) - floor((ceil(((360n) - 5p) / (10u))) / 2) != 0) ? ((2 * (50n > (((60n) - 0) + 60n) ? 50n : (((60n) - 0) + 60n))) + 340n) : 0)) / 1 : ((floor((ceil(((360n) - 5p) / (10u))) / 2.0) * ((2 * (60n > (((60n) - 0) + 50n) ? 60n : (((60n) - 0) + 50n))) + (2 * ((360n) / (ceil(((360n) - 5p) / (10u))))))) + ((((ceil(((360n) - 5p) / (10u))) / 2) - floor((ceil(((360n) - 5p) / (10u))) / 2) != 0) ? ((2 * (100n > (((60n) - 0) + 80n) ? 100n : (((60n) - 0) + 80n))) + (2 * ((360n) / (ceil(((360n) - 5p) / (10u)))))) : 0)) / 1           nrd=(((360n) / (ceil(((360n) - 5p) / (10u)))) < 119.5n) ? ((floor((ceil(((360n) - 5p) / (10u))) / 2.0) * (((((60n) - 0) + 60n) * 120n) + (((360n) / (ceil(((360n) - 5p) / (10u)))) * 100n))) + ((((ceil(((360n) - 5p) / (10u))) / 2) - floor((ceil(((360n) - 5p) / (10u))) / 2) != 0) ? (((50n > (((60n) - 0) + 60n) ? 50n : (((60n) - 0) + 60n)) * 120n) + (((360n) / (ceil(((360n) - 5p) / (10u)))) * 50n)) : 0)) / 1 : ((floor((ceil(((360n) - 5p) / (10u))) / 2.0) * ((60n > (((60n) - 0) + 50n) ? 60n : (((60n) - 0) + 50n)) * ((360n) / (ceil(((360n) - 5p) / (10u)))))) + ((((ceil(((360n) - 5p) / (10u))) / 2) - floor((ceil(((360n) - 5p) / (10u))) / 2) != 0) ? ((100n > (((60n) - 0) + 80n) ? 100n : (((60n) - 0) + 80n)) * ((360n) / (ceil(((360n) - 5p) / (10u))))) : 0)) / 1 / (((360n) / (ceil(((360n) - 5p) / (10u)))) * (ceil(((360n) - 5p) / (10u))) * ((360n) / (ceil(((360n) - 5p) / (10u)))) * (ceil(((360n) - 5p) / (10u))))           nrs=(((360n) / (ceil(((360n) - 5p) / (10u)))) < 119.5n) ? ((((50n > (((60n) - 0) + 60n) ? 50n : (((60n) - 0) + 60n)) * 120n) + (((360n) / (ceil(((360n) - 5p) / (10u)))) * 50n)) + (floor(((ceil(((360n) - 5p) / (10u))) - 1) / 2.0) * (((((60n) - 0) + 60n) * 120n) + (((360n) / (ceil(((360n) - 5p) / (10u)))) * 100n))) + ((((ceil(((360n) - 5p) / (10u))) / 2) - floor((ceil(((360n) - 5p) / (10u))) / 2) == 0) ? (((50n > (((60n) - 0) + 60n) ? 50n : (((60n) - 0) + 60n)) * 120n) + (((360n) / (ceil(((360n) - 5p) / (10u)))) * 50n)) : 0)) / 1 : (((100n > (((60n) - 0) + 80n) ? 100n : (((60n) - 0) + 80n)) * ((360n) / (ceil(((360n) - 5p) / (10u))))) + (floor(((ceil(((360n) - 5p) / (10u))) - 1) / 2.0) * ((60n > (((60n) - 0) + 50n) ? 60n : (((60n) - 0) + 50n)) * ((360n) / (ceil(((360n) - 5p) / (10u)))))) + ((((ceil(((360n) - 5p) / (10u))) / 2) - floor((ceil(((360n) - 5p) / (10u))) / 2) == 0) ? ((100n > (((60n) - 0) + 80n) ? 100n : (((60n) - 0) + 80n)) * ((360n) / (ceil(((360n) - 5p) / (10u))))) : 0)) / 1 / (((360n) / (ceil(((360n) - 5p) / (10u)))) * (ceil(((360n) - 5p) / (10u))) * ((360n) / (ceil(((360n) - 5p) / (10u)))) * (ceil(((360n) - 5p) / (10u))))           sa=(((360n) / (ceil(((360n) - 5p) / (10u)))) < 119.5n) ? (50n > (((60n) - 0) + 60n) ? 50n : (((60n) - 0) + 60n)) + 5e-08 : (100n > (((60n) - 0) + 80n) ? 100n : (((60n) - 0) + 80n))           sb=(((360n) / (ceil(((360n) - 5p) / (10u)))) < 119.5n) ? (50n > (((60n) - 0) + 60n) ? 50n : (((60n) - 0) + 60n)) + 5e-08 : (100n > (((60n) - 0) + 80n) ? 100n : (((60n) - 0) + 80n))           sd=(((360n) / (ceil(((360n) - 5p) / (10u)))) < 119.5n) ? (((60n) - 0) + 60n) + (2*5e-08) : (60n > (((60n) - 0) + 50n) ? 60n : (((60n) - 0) + 50n))           sca=(( ((360n) / (ceil(((360n) - 5p) / (10u)))) * ( (((1u) * (1u) / ((((360n) / (ceil(((360n) - 5p) / (10u)))) < 119.5n) ? (50n > (((60n) - 0) + 60n) ? 50n : (((60n) - 0) + 60n)) + 5e-08 : (100n > (((60n) - 0) + 80n) ? 100n : (((60n) - 0) + 80n))+60n)) - ((1u) * (1u) / (((((360n) / (ceil(((360n) - 5p) / (10u)))) < 119.5n) ? (50n > (((60n) - 0) + 60n) ? 50n : (((60n) - 0) + 60n)) + 5e-08 : (100n > (((60n) - 0) + 80n) ? 100n : (((60n) - 0) + 80n))+60n)+(45n)))) + ((1u) * (1u) / ((((360n) / (ceil(((360n) - 5p) / (10u)))) < 119.5n) ? (50n > (((60n) - 0) + 60n) ? 50n : (((60n) - 0) + 60n)) + 5e-08 : (100n > (((60n) - 0) + 80n) ? 100n : (((60n) - 0) + 80n))+60n)) - ((1u) * (1u)/ (((((360n) / (ceil(((360n) - 5p) / (10u)))) < 119.5n) ? (50n > (((60n) - 0) + 60n) ? 50n : (((60n) - 0) + 60n)) + 5e-08 : (100n > (((60n) - 0) + 80n) ? 100n : (((60n) - 0) + 80n))+60n)+(45n))))) + ( (45n) * ( (((1u) * (1u) / (60n)) - ((1u) * (1u) / ((60n)+((360n) / (ceil(((360n) - 5p) / (10u))))))) + ((1u) * (1u) / (60n)) - ((1u) * (1u)/ ((60n)+((360n) / (ceil(((360n) - 5p) / (10u))))))))) / (((360n) / (ceil(((360n) - 5p) / (10u)))) * (45n))           scb=((((360n) / (ceil(((360n) - 5p) / (10u)))) * ((((((360n) / (ceil(((360n) - 5p) / (10u)))) < 119.5n) ? (50n > (((60n) - 0) + 60n) ? 50n : (((60n) - 0) + 60n)) + 5e-08 : (100n > (((60n) - 0) + 80n) ? 100n : (((60n) - 0) + 80n))+60n)/10 + (1u)/100)*exp(-10 * ((((360n) / (ceil(((360n) - 5p) / (10u)))) < 119.5n) ? (50n > (((60n) - 0) + 60n) ? 50n : (((60n) - 0) + 60n)) + 5e-08 : (100n > (((60n) - 0) + 80n) ? 100n : (((60n) - 0) + 80n))+60n) / (1u)) - ((((((360n) / (ceil(((360n) - 5p) / (10u)))) < 119.5n) ? (50n > (((60n) - 0) + 60n) ? 50n : (((60n) - 0) + 60n)) + 5e-08 : (100n > (((60n) - 0) + 80n) ? 100n : (((60n) - 0) + 80n))+60n)+(45n))/10 + (1u)/100)*exp(-10 * (((((360n) / (ceil(((360n) - 5p) / (10u)))) < 119.5n) ? (50n > (((60n) - 0) + 60n) ? 50n : (((60n) - 0) + 60n)) + 5e-08 : (100n > (((60n) - 0) + 80n) ? 100n : (((60n) - 0) + 80n))+60n)+(45n)) / (1u)) + (((((360n) / (ceil(((360n) - 5p) / (10u)))) < 119.5n) ? (50n > (((60n) - 0) + 60n) ? 50n : (((60n) - 0) + 60n)) + 5e-08 : (100n > (((60n) - 0) + 80n) ? 100n : (((60n) - 0) + 80n))+60n)/10 + (1u)/100)*exp(-10 * ((((360n) / (ceil(((360n) - 5p) / (10u)))) < 119.5n) ? (50n > (((60n) - 0) + 60n) ? 50n : (((60n) - 0) + 60n)) + 5e-08 : (100n > (((60n) - 0) + 80n) ? 100n : (((60n) - 0) + 80n))+60n) / (1u)) - ((((((360n) / (ceil(((360n) - 5p) / (10u)))) < 119.5n) ? (50n > (((60n) - 0) + 60n) ? 50n : (((60n) - 0) + 60n)) + 5e-08 : (100n > (((60n) - 0) + 80n) ? 100n : (((60n) - 0) + 80n))+60n)+(45n))/10 + (1u)/100)*exp(-10 * (((((360n) / (ceil(((360n) - 5p) / (10u)))) < 119.5n) ? (50n > (((60n) - 0) + 60n) ? 50n : (((60n) - 0) + 60n)) + 5e-08 : (100n > (((60n) - 0) + 80n) ? 100n : (((60n) - 0) + 80n))+60n)+(45n)) / (1u)))) + ((45n) * (((60n)/10 + (1u)/100)*exp(-10 * (60n) / (1u)) - (((60n)+((360n) / (ceil(((360n) - 5p) / (10u)))))/10 + (1u)/100)*exp(-10 * ((60n)+((360n) / (ceil(((360n) - 5p) / (10u))))) / (1u)) + ((60n)/10 + (1u)/100)*exp(-10 * (60n) / (1u)) - (((60n)+((360n) / (ceil(((360n) - 5p) / (10u)))))/10 + (1u)/100)*exp(-10 * ((60n)+((360n) / (ceil(((360n) - 5p) / (10u))))) / (1u))))) / (((360n) / (ceil(((360n) - 5p) / (10u)))) * (45n))           scc=((((360n) / (ceil(((360n) - 5p) / (10u)))) * ((((((360n) / (ceil(((360n) - 5p) / (10u)))) < 119.5n) ? (50n > (((60n) - 0) + 60n) ? 50n : (((60n) - 0) + 60n)) + 5e-08 : (100n > (((60n) - 0) + 80n) ? 100n : (((60n) - 0) + 80n))+60n)/20 + (1u)/400)*exp(-20 * ((((360n) / (ceil(((360n) - 5p) / (10u)))) < 119.5n) ? (50n > (((60n) - 0) + 60n) ? 50n : (((60n) - 0) + 60n)) + 5e-08 : (100n > (((60n) - 0) + 80n) ? 100n : (((60n) - 0) + 80n))+60n) / (1u)) - ((((((360n) / (ceil(((360n) - 5p) / (10u)))) < 119.5n) ? (50n > (((60n) - 0) + 60n) ? 50n : (((60n) - 0) + 60n)) + 5e-08 : (100n > (((60n) - 0) + 80n) ? 100n : (((60n) - 0) + 80n))+60n)+(45n))/20 + (1u)/400)*exp(-20 * (((((360n) / (ceil(((360n) - 5p) / (10u)))) < 119.5n) ? (50n > (((60n) - 0) + 60n) ? 50n : (((60n) - 0) + 60n)) + 5e-08 : (100n > (((60n) - 0) + 80n) ? 100n : (((60n) - 0) + 80n))+60n)+(45n)) / (1u)) + (((((360n) / (ceil(((360n) - 5p) / (10u)))) < 119.5n) ? (50n > (((60n) - 0) + 60n) ? 50n : (((60n) - 0) + 60n)) + 5e-08 : (100n > (((60n) - 0) + 80n) ? 100n : (((60n) - 0) + 80n))+60n)/20 + (1u)/400)*exp(-20 * ((((360n) / (ceil(((360n) - 5p) / (10u)))) < 119.5n) ? (50n > (((60n) - 0) + 60n) ? 50n : (((60n) - 0) + 60n)) + 5e-08 : (100n > (((60n) - 0) + 80n) ? 100n : (((60n) - 0) + 80n))+60n) / (1u)) - ((((((360n) / (ceil(((360n) - 5p) / (10u)))) < 119.5n) ? (50n > (((60n) - 0) + 60n) ? 50n : (((60n) - 0) + 60n)) + 5e-08 : (100n > (((60n) - 0) + 80n) ? 100n : (((60n) - 0) + 80n))+60n)+(45n))/20 + (1u)/400)*exp(-20 * (((((360n) / (ceil(((360n) - 5p) / (10u)))) < 119.5n) ? (50n > (((60n) - 0) + 60n) ? 50n : (((60n) - 0) + 60n)) + 5e-08 : (100n > (((60n) - 0) + 80n) ? 100n : (((60n) - 0) + 80n))+60n)+(45n)) / (1u)))) + ((45n) * (((60n)/20 + (1u)/400)*exp(-20 * (60n) / (1u)) - (((60n)+((360n) / (ceil(((360n) - 5p) / (10u)))))/20 + (1u)/400)*exp(-20 * ((60n)+((360n) / (ceil(((360n) - 5p) / (10u))))) / (1u)) + ((60n)/20 + (1u)/400)*exp(-20 * (60n) / (1u)) - (((60n)+((360n) / (ceil(((360n) - 5p) / (10u)))))/20 + (1u)/400)*exp(-20 * ((60n)+((360n) / (ceil(((360n) - 5p) / (10u))))) / (1u))))) / (((360n) / (ceil(((360n) - 5p) / (10u)))) * (45n))           m=(1)
ends
subckt tg (A B EN ENB VDD GND)
N (B EN A GND) g45n1svt w=(1080n) l=45n nf=ceil(((1080n) - 5p) / (10u))           as=(((1080n) / (ceil(((1080n) - 5p) / (10u)))) < 119.5n) ? ((((50n > (((60n) - 0) + 60n) ? 50n : (((60n) - 0) + 60n)) * 120n) + (((1080n) / (ceil(((1080n) - 5p) / (10u)))) * 50n)) + (floor(((ceil(((1080n) - 5p) / (10u))) - 1) / 2.0) * (((((60n) - 0) + 60n) * 120n) + (((1080n) / (ceil(((1080n) - 5p) / (10u)))) * 100n))) + ((((ceil(((1080n) - 5p) / (10u))) / 2) - floor((ceil(((1080n) - 5p) / (10u))) / 2) == 0) ? (((50n > (((60n) - 0) + 60n) ? 50n : (((60n) - 0) + 60n)) * 120n) + (((1080n) / (ceil(((1080n) - 5p) / (10u)))) * 50n)) : 0)) / 1 : (((100n > (((60n) - 0) + 80n) ? 100n : (((60n) - 0) + 80n)) * ((1080n) / (ceil(((1080n) - 5p) / (10u))))) + (floor(((ceil(((1080n) - 5p) / (10u))) - 1) / 2.0) * ((60n > (((60n) - 0) + 50n) ? 60n : (((60n) - 0) + 50n)) * ((1080n) / (ceil(((1080n) - 5p) / (10u)))))) + ((((ceil(((1080n) - 5p) / (10u))) / 2) - floor((ceil(((1080n) - 5p) / (10u))) / 2) == 0) ? ((100n > (((60n) - 0) + 80n) ? 100n : (((60n) - 0) + 80n)) * ((1080n) / (ceil(((1080n) - 5p) / (10u))))) : 0)) / 1           ad=(((1080n) / (ceil(((1080n) - 5p) / (10u)))) < 119.5n) ? ((floor((ceil(((1080n) - 5p) / (10u))) / 2.0) * (((((60n) - 0) + 60n) * 120n) + (((1080n) / (ceil(((1080n) - 5p) / (10u)))) * 100n))) + ((((ceil(((1080n) - 5p) / (10u))) / 2) - floor((ceil(((1080n) - 5p) / (10u))) / 2) != 0) ? (((50n > (((60n) - 0) + 60n) ? 50n : (((60n) - 0) + 60n)) * 120n) + (((1080n) / (ceil(((1080n) - 5p) / (10u)))) * 50n)) : 0)) / 1 : ((floor((ceil(((1080n) - 5p) / (10u))) / 2.0) * ((60n > (((60n) - 0) + 50n) ? 60n : (((60n) - 0) + 50n)) * ((1080n) / (ceil(((1080n) - 5p) / (10u)))))) + ((((ceil(((1080n) - 5p) / (10u))) / 2) - floor((ceil(((1080n) - 5p) / (10u))) / 2) != 0) ? ((100n > (((60n) - 0) + 80n) ? 100n : (((60n) - 0) + 80n)) * ((1080n) / (ceil(((1080n) - 5p) / (10u))))) : 0)) / 1           ps=(((1080n) / (ceil(((1080n) - 5p) / (10u)))) < 119.5n) ? (((2 * (50n > (((60n) - 0) + 60n) ? 50n : (((60n) - 0) + 60n))) + 340n) + (floor(((ceil(((1080n) - 5p) / (10u))) - 1) / 2.0) * ((2 * (((60n) - 0) + 60n)) + 440n)) + ((((ceil(((1080n) - 5p) / (10u))) / 2) - floor((ceil(((1080n) - 5p) / (10u))) / 2) == 0) ? ((2 * (50n > (((60n) - 0) + 60n) ? 50n : (((60n) - 0) + 60n))) + 340n) : 0)) / 1 : (((2 * (100n > (((60n) - 0) + 80n) ? 100n : (((60n) - 0) + 80n))) + (2 * ((1080n) / (ceil(((1080n) - 5p) / (10u)))))) + (floor(((ceil(((1080n) - 5p) / (10u))) - 1) / 2.0) * ((2 * (60n > (((60n) - 0) + 50n) ? 60n : (((60n) - 0) + 50n))) + (2 * ((1080n) / (ceil(((1080n) - 5p) / (10u))))))) + ((((ceil(((1080n) - 5p) / (10u))) / 2) - floor((ceil(((1080n) - 5p) / (10u))) / 2) == 0) ? ((2 * (100n > (((60n) - 0) + 80n) ? 100n : (((60n) - 0) + 80n))) + (2 * ((1080n) / (ceil(((1080n) - 5p) / (10u)))))) : 0)) / 1           pd=(((1080n) / (ceil(((1080n) - 5p) / (10u)))) < 119.5n) ? ((floor((ceil(((1080n) - 5p) / (10u))) / 2.0) * ((2 * (((60n) - 0) + 60n)) + 440n)) + ((((ceil(((1080n) - 5p) / (10u))) / 2) - floor((ceil(((1080n) - 5p) / (10u))) / 2) != 0) ? ((2 * (50n > (((60n) - 0) + 60n) ? 50n : (((60n) - 0) + 60n))) + 340n) : 0)) / 1 : ((floor((ceil(((1080n) - 5p) / (10u))) / 2.0) * ((2 * (60n > (((60n) - 0) + 50n) ? 60n : (((60n) - 0) + 50n))) + (2 * ((1080n) / (ceil(((1080n) - 5p) / (10u))))))) + ((((ceil(((1080n) - 5p) / (10u))) / 2) - floor((ceil(((1080n) - 5p) / (10u))) / 2) != 0) ? ((2 * (100n > (((60n) - 0) + 80n) ? 100n : (((60n) - 0) + 80n))) + (2 * ((1080n) / (ceil(((1080n) - 5p) / (10u)))))) : 0)) / 1           nrd=(((1080n) / (ceil(((1080n) - 5p) / (10u)))) < 119.5n) ? ((floor((ceil(((1080n) - 5p) / (10u))) / 2.0) * (((((60n) - 0) + 60n) * 120n) + (((1080n) / (ceil(((1080n) - 5p) / (10u)))) * 100n))) + ((((ceil(((1080n) - 5p) / (10u))) / 2) - floor((ceil(((1080n) - 5p) / (10u))) / 2) != 0) ? (((50n > (((60n) - 0) + 60n) ? 50n : (((60n) - 0) + 60n)) * 120n) + (((1080n) / (ceil(((1080n) - 5p) / (10u)))) * 50n)) : 0)) / 1 : ((floor((ceil(((1080n) - 5p) / (10u))) / 2.0) * ((60n > (((60n) - 0) + 50n) ? 60n : (((60n) - 0) + 50n)) * ((1080n) / (ceil(((1080n) - 5p) / (10u)))))) + ((((ceil(((1080n) - 5p) / (10u))) / 2) - floor((ceil(((1080n) - 5p) / (10u))) / 2) != 0) ? ((100n > (((60n) - 0) + 80n) ? 100n : (((60n) - 0) + 80n)) * ((1080n) / (ceil(((1080n) - 5p) / (10u))))) : 0)) / 1 / (((1080n) / (ceil(((1080n) - 5p) / (10u)))) * (ceil(((1080n) - 5p) / (10u))) * ((1080n) / (ceil(((1080n) - 5p) / (10u)))) * (ceil(((1080n) - 5p) / (10u))))           nrs=(((1080n) / (ceil(((1080n) - 5p) / (10u)))) < 119.5n) ? ((((50n > (((60n) - 0) + 60n) ? 50n : (((60n) - 0) + 60n)) * 120n) + (((1080n) / (ceil(((1080n) - 5p) / (10u)))) * 50n)) + (floor(((ceil(((1080n) - 5p) / (10u))) - 1) / 2.0) * (((((60n) - 0) + 60n) * 120n) + (((1080n) / (ceil(((1080n) - 5p) / (10u)))) * 100n))) + ((((ceil(((1080n) - 5p) / (10u))) / 2) - floor((ceil(((1080n) - 5p) / (10u))) / 2) == 0) ? (((50n > (((60n) - 0) + 60n) ? 50n : (((60n) - 0) + 60n)) * 120n) + (((1080n) / (ceil(((1080n) - 5p) / (10u)))) * 50n)) : 0)) / 1 : (((100n > (((60n) - 0) + 80n) ? 100n : (((60n) - 0) + 80n)) * ((1080n) / (ceil(((1080n) - 5p) / (10u))))) + (floor(((ceil(((1080n) - 5p) / (10u))) - 1) / 2.0) * ((60n > (((60n) - 0) + 50n) ? 60n : (((60n) - 0) + 50n)) * ((1080n) / (ceil(((1080n) - 5p) / (10u)))))) + ((((ceil(((1080n) - 5p) / (10u))) / 2) - floor((ceil(((1080n) - 5p) / (10u))) / 2) == 0) ? ((100n > (((60n) - 0) + 80n) ? 100n : (((60n) - 0) + 80n)) * ((1080n) / (ceil(((1080n) - 5p) / (10u))))) : 0)) / 1 / (((1080n) / (ceil(((1080n) - 5p) / (10u)))) * (ceil(((1080n) - 5p) / (10u))) * ((1080n) / (ceil(((1080n) - 5p) / (10u)))) * (ceil(((1080n) - 5p) / (10u))))           sa=(((1080n) / (ceil(((1080n) - 5p) / (10u)))) < 119.5n) ? (50n > (((60n) - 0) + 60n) ? 50n : (((60n) - 0) + 60n)) + 5e-08 : (100n > (((60n) - 0) + 80n) ? 100n : (((60n) - 0) + 80n))           sb=(((1080n) / (ceil(((1080n) - 5p) / (10u)))) < 119.5n) ? (50n > (((60n) - 0) + 60n) ? 50n : (((60n) - 0) + 60n)) + 5e-08 : (100n > (((60n) - 0) + 80n) ? 100n : (((60n) - 0) + 80n))           sd=(((1080n) / (ceil(((1080n) - 5p) / (10u)))) < 119.5n) ? (((60n) - 0) + 60n) + (2*5e-08) : (60n > (((60n) - 0) + 50n) ? 60n : (((60n) - 0) + 50n))           sca=(( ((1080n) / (ceil(((1080n) - 5p) / (10u)))) * ( (((1u) * (1u) / ((((1080n) / (ceil(((1080n) - 5p) / (10u)))) < 119.5n) ? (50n > (((60n) - 0) + 60n) ? 50n : (((60n) - 0) + 60n)) + 5e-08 : (100n > (((60n) - 0) + 80n) ? 100n : (((60n) - 0) + 80n))+60n)) - ((1u) * (1u) / (((((1080n) / (ceil(((1080n) - 5p) / (10u)))) < 119.5n) ? (50n > (((60n) - 0) + 60n) ? 50n : (((60n) - 0) + 60n)) + 5e-08 : (100n > (((60n) - 0) + 80n) ? 100n : (((60n) - 0) + 80n))+60n)+(45n)))) + ((1u) * (1u) / ((((1080n) / (ceil(((1080n) - 5p) / (10u)))) < 119.5n) ? (50n > (((60n) - 0) + 60n) ? 50n : (((60n) - 0) + 60n)) + 5e-08 : (100n > (((60n) - 0) + 80n) ? 100n : (((60n) - 0) + 80n))+60n)) - ((1u) * (1u)/ (((((1080n) / (ceil(((1080n) - 5p) / (10u)))) < 119.5n) ? (50n > (((60n) - 0) + 60n) ? 50n : (((60n) - 0) + 60n)) + 5e-08 : (100n > (((60n) - 0) + 80n) ? 100n : (((60n) - 0) + 80n))+60n)+(45n))))) + ( (45n) * ( (((1u) * (1u) / (60n)) - ((1u) * (1u) / ((60n)+((1080n) / (ceil(((1080n) - 5p) / (10u))))))) + ((1u) * (1u) / (60n)) - ((1u) * (1u)/ ((60n)+((1080n) / (ceil(((1080n) - 5p) / (10u))))))))) / (((1080n) / (ceil(((1080n) - 5p) / (10u)))) * (45n))           scb=((((1080n) / (ceil(((1080n) - 5p) / (10u)))) * ((((((1080n) / (ceil(((1080n) - 5p) / (10u)))) < 119.5n) ? (50n > (((60n) - 0) + 60n) ? 50n : (((60n) - 0) + 60n)) + 5e-08 : (100n > (((60n) - 0) + 80n) ? 100n : (((60n) - 0) + 80n))+60n)/10 + (1u)/100)*exp(-10 * ((((1080n) / (ceil(((1080n) - 5p) / (10u)))) < 119.5n) ? (50n > (((60n) - 0) + 60n) ? 50n : (((60n) - 0) + 60n)) + 5e-08 : (100n > (((60n) - 0) + 80n) ? 100n : (((60n) - 0) + 80n))+60n) / (1u)) - ((((((1080n) / (ceil(((1080n) - 5p) / (10u)))) < 119.5n) ? (50n > (((60n) - 0) + 60n) ? 50n : (((60n) - 0) + 60n)) + 5e-08 : (100n > (((60n) - 0) + 80n) ? 100n : (((60n) - 0) + 80n))+60n)+(45n))/10 + (1u)/100)*exp(-10 * (((((1080n) / (ceil(((1080n) - 5p) / (10u)))) < 119.5n) ? (50n > (((60n) - 0) + 60n) ? 50n : (((60n) - 0) + 60n)) + 5e-08 : (100n > (((60n) - 0) + 80n) ? 100n : (((60n) - 0) + 80n))+60n)+(45n)) / (1u)) + (((((1080n) / (ceil(((1080n) - 5p) / (10u)))) < 119.5n) ? (50n > (((60n) - 0) + 60n) ? 50n : (((60n) - 0) + 60n)) + 5e-08 : (100n > (((60n) - 0) + 80n) ? 100n : (((60n) - 0) + 80n))+60n)/10 + (1u)/100)*exp(-10 * ((((1080n) / (ceil(((1080n) - 5p) / (10u)))) < 119.5n) ? (50n > (((60n) - 0) + 60n) ? 50n : (((60n) - 0) + 60n)) + 5e-08 : (100n > (((60n) - 0) + 80n) ? 100n : (((60n) - 0) + 80n))+60n) / (1u)) - ((((((1080n) / (ceil(((1080n) - 5p) / (10u)))) < 119.5n) ? (50n > (((60n) - 0) + 60n) ? 50n : (((60n) - 0) + 60n)) + 5e-08 : (100n > (((60n) - 0) + 80n) ? 100n : (((60n) - 0) + 80n))+60n)+(45n))/10 + (1u)/100)*exp(-10 * (((((1080n) / (ceil(((1080n) - 5p) / (10u)))) < 119.5n) ? (50n > (((60n) - 0) + 60n) ? 50n : (((60n) - 0) + 60n)) + 5e-08 : (100n > (((60n) - 0) + 80n) ? 100n : (((60n) - 0) + 80n))+60n)+(45n)) / (1u)))) + ((45n) * (((60n)/10 + (1u)/100)*exp(-10 * (60n) / (1u)) - (((60n)+((1080n) / (ceil(((1080n) - 5p) / (10u)))))/10 + (1u)/100)*exp(-10 * ((60n)+((1080n) / (ceil(((1080n) - 5p) / (10u))))) / (1u)) + ((60n)/10 + (1u)/100)*exp(-10 * (60n) / (1u)) - (((60n)+((1080n) / (ceil(((1080n) - 5p) / (10u)))))/10 + (1u)/100)*exp(-10 * ((60n)+((1080n) / (ceil(((1080n) - 5p) / (10u))))) / (1u))))) / (((1080n) / (ceil(((1080n) - 5p) / (10u)))) * (45n))           scc=((((1080n) / (ceil(((1080n) - 5p) / (10u)))) * ((((((1080n) / (ceil(((1080n) - 5p) / (10u)))) < 119.5n) ? (50n > (((60n) - 0) + 60n) ? 50n : (((60n) - 0) + 60n)) + 5e-08 : (100n > (((60n) - 0) + 80n) ? 100n : (((60n) - 0) + 80n))+60n)/20 + (1u)/400)*exp(-20 * ((((1080n) / (ceil(((1080n) - 5p) / (10u)))) < 119.5n) ? (50n > (((60n) - 0) + 60n) ? 50n : (((60n) - 0) + 60n)) + 5e-08 : (100n > (((60n) - 0) + 80n) ? 100n : (((60n) - 0) + 80n))+60n) / (1u)) - ((((((1080n) / (ceil(((1080n) - 5p) / (10u)))) < 119.5n) ? (50n > (((60n) - 0) + 60n) ? 50n : (((60n) - 0) + 60n)) + 5e-08 : (100n > (((60n) - 0) + 80n) ? 100n : (((60n) - 0) + 80n))+60n)+(45n))/20 + (1u)/400)*exp(-20 * (((((1080n) / (ceil(((1080n) - 5p) / (10u)))) < 119.5n) ? (50n > (((60n) - 0) + 60n) ? 50n : (((60n) - 0) + 60n)) + 5e-08 : (100n > (((60n) - 0) + 80n) ? 100n : (((60n) - 0) + 80n))+60n)+(45n)) / (1u)) + (((((1080n) / (ceil(((1080n) - 5p) / (10u)))) < 119.5n) ? (50n > (((60n) - 0) + 60n) ? 50n : (((60n) - 0) + 60n)) + 5e-08 : (100n > (((60n) - 0) + 80n) ? 100n : (((60n) - 0) + 80n))+60n)/20 + (1u)/400)*exp(-20 * ((((1080n) / (ceil(((1080n) - 5p) / (10u)))) < 119.5n) ? (50n > (((60n) - 0) + 60n) ? 50n : (((60n) - 0) + 60n)) + 5e-08 : (100n > (((60n) - 0) + 80n) ? 100n : (((60n) - 0) + 80n))+60n) / (1u)) - ((((((1080n) / (ceil(((1080n) - 5p) / (10u)))) < 119.5n) ? (50n > (((60n) - 0) + 60n) ? 50n : (((60n) - 0) + 60n)) + 5e-08 : (100n > (((60n) - 0) + 80n) ? 100n : (((60n) - 0) + 80n))+60n)+(45n))/20 + (1u)/400)*exp(-20 * (((((1080n) / (ceil(((1080n) - 5p) / (10u)))) < 119.5n) ? (50n > (((60n) - 0) + 60n) ? 50n : (((60n) - 0) + 60n)) + 5e-08 : (100n > (((60n) - 0) + 80n) ? 100n : (((60n) - 0) + 80n))+60n)+(45n)) / (1u)))) + ((45n) * (((60n)/20 + (1u)/400)*exp(-20 * (60n) / (1u)) - (((60n)+((1080n) / (ceil(((1080n) - 5p) / (10u)))))/20 + (1u)/400)*exp(-20 * ((60n)+((1080n) / (ceil(((1080n) - 5p) / (10u))))) / (1u)) + ((60n)/20 + (1u)/400)*exp(-20 * (60n) / (1u)) - (((60n)+((1080n) / (ceil(((1080n) - 5p) / (10u)))))/20 + (1u)/400)*exp(-20 * ((60n)+((1080n) / (ceil(((1080n) - 5p) / (10u))))) / (1u))))) / (((1080n) / (ceil(((1080n) - 5p) / (10u)))) * (45n))           m=(1)
P (B ENB A VDD) g45p1svt w=(1080n) l=45n nf=ceil(((1080n) - 5p) / (10u))           as=(((1080n) / (ceil(((1080n) - 5p) / (10u)))) < 119.5n) ? ((((50n > (((60n) - 0) + 60n) ? 50n : (((60n) - 0) + 60n)) * 120n) + (((1080n) / (ceil(((1080n) - 5p) / (10u)))) * 50n)) + (floor(((ceil(((1080n) - 5p) / (10u))) - 1) / 2.0) * (((((60n) - 0) + 60n) * 120n) + (((1080n) / (ceil(((1080n) - 5p) / (10u)))) * 100n))) + ((((ceil(((1080n) - 5p) / (10u))) / 2) - floor((ceil(((1080n) - 5p) / (10u))) / 2) == 0) ? (((50n > (((60n) - 0) + 60n) ? 50n : (((60n) - 0) + 60n)) * 120n) + (((1080n) / (ceil(((1080n) - 5p) / (10u)))) * 50n)) : 0)) / 1 : (((100n > (((60n) - 0) + 80n) ? 100n : (((60n) - 0) + 80n)) * ((1080n) / (ceil(((1080n) - 5p) / (10u))))) + (floor(((ceil(((1080n) - 5p) / (10u))) - 1) / 2.0) * ((60n > (((60n) - 0) + 50n) ? 60n : (((60n) - 0) + 50n)) * ((1080n) / (ceil(((1080n) - 5p) / (10u)))))) + ((((ceil(((1080n) - 5p) / (10u))) / 2) - floor((ceil(((1080n) - 5p) / (10u))) / 2) == 0) ? ((100n > (((60n) - 0) + 80n) ? 100n : (((60n) - 0) + 80n)) * ((1080n) / (ceil(((1080n) - 5p) / (10u))))) : 0)) / 1           ad=(((1080n) / (ceil(((1080n) - 5p) / (10u)))) < 119.5n) ? ((floor((ceil(((1080n) - 5p) / (10u))) / 2.0) * (((((60n) - 0) + 60n) * 120n) + (((1080n) / (ceil(((1080n) - 5p) / (10u)))) * 100n))) + ((((ceil(((1080n) - 5p) / (10u))) / 2) - floor((ceil(((1080n) - 5p) / (10u))) / 2) != 0) ? (((50n > (((60n) - 0) + 60n) ? 50n : (((60n) - 0) + 60n)) * 120n) + (((1080n) / (ceil(((1080n) - 5p) / (10u)))) * 50n)) : 0)) / 1 : ((floor((ceil(((1080n) - 5p) / (10u))) / 2.0) * ((60n > (((60n) - 0) + 50n) ? 60n : (((60n) - 0) + 50n)) * ((1080n) / (ceil(((1080n) - 5p) / (10u)))))) + ((((ceil(((1080n) - 5p) / (10u))) / 2) - floor((ceil(((1080n) - 5p) / (10u))) / 2) != 0) ? ((100n > (((60n) - 0) + 80n) ? 100n : (((60n) - 0) + 80n)) * ((1080n) / (ceil(((1080n) - 5p) / (10u))))) : 0)) / 1           ps=(((1080n) / (ceil(((1080n) - 5p) / (10u)))) < 119.5n) ? (((2 * (50n > (((60n) - 0) + 60n) ? 50n : (((60n) - 0) + 60n))) + 340n) + (floor(((ceil(((1080n) - 5p) / (10u))) - 1) / 2.0) * ((2 * (((60n) - 0) + 60n)) + 440n)) + ((((ceil(((1080n) - 5p) / (10u))) / 2) - floor((ceil(((1080n) - 5p) / (10u))) / 2) == 0) ? ((2 * (50n > (((60n) - 0) + 60n) ? 50n : (((60n) - 0) + 60n))) + 340n) : 0)) / 1 : (((2 * (100n > (((60n) - 0) + 80n) ? 100n : (((60n) - 0) + 80n))) + (2 * ((1080n) / (ceil(((1080n) - 5p) / (10u)))))) + (floor(((ceil(((1080n) - 5p) / (10u))) - 1) / 2.0) * ((2 * (60n > (((60n) - 0) + 50n) ? 60n : (((60n) - 0) + 50n))) + (2 * ((1080n) / (ceil(((1080n) - 5p) / (10u))))))) + ((((ceil(((1080n) - 5p) / (10u))) / 2) - floor((ceil(((1080n) - 5p) / (10u))) / 2) == 0) ? ((2 * (100n > (((60n) - 0) + 80n) ? 100n : (((60n) - 0) + 80n))) + (2 * ((1080n) / (ceil(((1080n) - 5p) / (10u)))))) : 0)) / 1           pd=(((1080n) / (ceil(((1080n) - 5p) / (10u)))) < 119.5n) ? ((floor((ceil(((1080n) - 5p) / (10u))) / 2.0) * ((2 * (((60n) - 0) + 60n)) + 440n)) + ((((ceil(((1080n) - 5p) / (10u))) / 2) - floor((ceil(((1080n) - 5p) / (10u))) / 2) != 0) ? ((2 * (50n > (((60n) - 0) + 60n) ? 50n : (((60n) - 0) + 60n))) + 340n) : 0)) / 1 : ((floor((ceil(((1080n) - 5p) / (10u))) / 2.0) * ((2 * (60n > (((60n) - 0) + 50n) ? 60n : (((60n) - 0) + 50n))) + (2 * ((1080n) / (ceil(((1080n) - 5p) / (10u))))))) + ((((ceil(((1080n) - 5p) / (10u))) / 2) - floor((ceil(((1080n) - 5p) / (10u))) / 2) != 0) ? ((2 * (100n > (((60n) - 0) + 80n) ? 100n : (((60n) - 0) + 80n))) + (2 * ((1080n) / (ceil(((1080n) - 5p) / (10u)))))) : 0)) / 1           nrd=(((1080n) / (ceil(((1080n) - 5p) / (10u)))) < 119.5n) ? ((floor((ceil(((1080n) - 5p) / (10u))) / 2.0) * (((((60n) - 0) + 60n) * 120n) + (((1080n) / (ceil(((1080n) - 5p) / (10u)))) * 100n))) + ((((ceil(((1080n) - 5p) / (10u))) / 2) - floor((ceil(((1080n) - 5p) / (10u))) / 2) != 0) ? (((50n > (((60n) - 0) + 60n) ? 50n : (((60n) - 0) + 60n)) * 120n) + (((1080n) / (ceil(((1080n) - 5p) / (10u)))) * 50n)) : 0)) / 1 : ((floor((ceil(((1080n) - 5p) / (10u))) / 2.0) * ((60n > (((60n) - 0) + 50n) ? 60n : (((60n) - 0) + 50n)) * ((1080n) / (ceil(((1080n) - 5p) / (10u)))))) + ((((ceil(((1080n) - 5p) / (10u))) / 2) - floor((ceil(((1080n) - 5p) / (10u))) / 2) != 0) ? ((100n > (((60n) - 0) + 80n) ? 100n : (((60n) - 0) + 80n)) * ((1080n) / (ceil(((1080n) - 5p) / (10u))))) : 0)) / 1 / (((1080n) / (ceil(((1080n) - 5p) / (10u)))) * (ceil(((1080n) - 5p) / (10u))) * ((1080n) / (ceil(((1080n) - 5p) / (10u)))) * (ceil(((1080n) - 5p) / (10u))))           nrs=(((1080n) / (ceil(((1080n) - 5p) / (10u)))) < 119.5n) ? ((((50n > (((60n) - 0) + 60n) ? 50n : (((60n) - 0) + 60n)) * 120n) + (((1080n) / (ceil(((1080n) - 5p) / (10u)))) * 50n)) + (floor(((ceil(((1080n) - 5p) / (10u))) - 1) / 2.0) * (((((60n) - 0) + 60n) * 120n) + (((1080n) / (ceil(((1080n) - 5p) / (10u)))) * 100n))) + ((((ceil(((1080n) - 5p) / (10u))) / 2) - floor((ceil(((1080n) - 5p) / (10u))) / 2) == 0) ? (((50n > (((60n) - 0) + 60n) ? 50n : (((60n) - 0) + 60n)) * 120n) + (((1080n) / (ceil(((1080n) - 5p) / (10u)))) * 50n)) : 0)) / 1 : (((100n > (((60n) - 0) + 80n) ? 100n : (((60n) - 0) + 80n)) * ((1080n) / (ceil(((1080n) - 5p) / (10u))))) + (floor(((ceil(((1080n) - 5p) / (10u))) - 1) / 2.0) * ((60n > (((60n) - 0) + 50n) ? 60n : (((60n) - 0) + 50n)) * ((1080n) / (ceil(((1080n) - 5p) / (10u)))))) + ((((ceil(((1080n) - 5p) / (10u))) / 2) - floor((ceil(((1080n) - 5p) / (10u))) / 2) == 0) ? ((100n > (((60n) - 0) + 80n) ? 100n : (((60n) - 0) + 80n)) * ((1080n) / (ceil(((1080n) - 5p) / (10u))))) : 0)) / 1 / (((1080n) / (ceil(((1080n) - 5p) / (10u)))) * (ceil(((1080n) - 5p) / (10u))) * ((1080n) / (ceil(((1080n) - 5p) / (10u)))) * (ceil(((1080n) - 5p) / (10u))))           sa=(((1080n) / (ceil(((1080n) - 5p) / (10u)))) < 119.5n) ? (50n > (((60n) - 0) + 60n) ? 50n : (((60n) - 0) + 60n)) + 5e-08 : (100n > (((60n) - 0) + 80n) ? 100n : (((60n) - 0) + 80n))           sb=(((1080n) / (ceil(((1080n) - 5p) / (10u)))) < 119.5n) ? (50n > (((60n) - 0) + 60n) ? 50n : (((60n) - 0) + 60n)) + 5e-08 : (100n > (((60n) - 0) + 80n) ? 100n : (((60n) - 0) + 80n))           sd=(((1080n) / (ceil(((1080n) - 5p) / (10u)))) < 119.5n) ? (((60n) - 0) + 60n) + (2*5e-08) : (60n > (((60n) - 0) + 50n) ? 60n : (((60n) - 0) + 50n))           sca=(( ((1080n) / (ceil(((1080n) - 5p) / (10u)))) * ( (((1u) * (1u) / ((((1080n) / (ceil(((1080n) - 5p) / (10u)))) < 119.5n) ? (50n > (((60n) - 0) + 60n) ? 50n : (((60n) - 0) + 60n)) + 5e-08 : (100n > (((60n) - 0) + 80n) ? 100n : (((60n) - 0) + 80n))+60n)) - ((1u) * (1u) / (((((1080n) / (ceil(((1080n) - 5p) / (10u)))) < 119.5n) ? (50n > (((60n) - 0) + 60n) ? 50n : (((60n) - 0) + 60n)) + 5e-08 : (100n > (((60n) - 0) + 80n) ? 100n : (((60n) - 0) + 80n))+60n)+(45n)))) + ((1u) * (1u) / ((((1080n) / (ceil(((1080n) - 5p) / (10u)))) < 119.5n) ? (50n > (((60n) - 0) + 60n) ? 50n : (((60n) - 0) + 60n)) + 5e-08 : (100n > (((60n) - 0) + 80n) ? 100n : (((60n) - 0) + 80n))+60n)) - ((1u) * (1u)/ (((((1080n) / (ceil(((1080n) - 5p) / (10u)))) < 119.5n) ? (50n > (((60n) - 0) + 60n) ? 50n : (((60n) - 0) + 60n)) + 5e-08 : (100n > (((60n) - 0) + 80n) ? 100n : (((60n) - 0) + 80n))+60n)+(45n))))) + ( (45n) * ( (((1u) * (1u) / (60n)) - ((1u) * (1u) / ((60n)+((1080n) / (ceil(((1080n) - 5p) / (10u))))))) + ((1u) * (1u) / (60n)) - ((1u) * (1u)/ ((60n)+((1080n) / (ceil(((1080n) - 5p) / (10u))))))))) / (((1080n) / (ceil(((1080n) - 5p) / (10u)))) * (45n))           scb=((((1080n) / (ceil(((1080n) - 5p) / (10u)))) * ((((((1080n) / (ceil(((1080n) - 5p) / (10u)))) < 119.5n) ? (50n > (((60n) - 0) + 60n) ? 50n : (((60n) - 0) + 60n)) + 5e-08 : (100n > (((60n) - 0) + 80n) ? 100n : (((60n) - 0) + 80n))+60n)/10 + (1u)/100)*exp(-10 * ((((1080n) / (ceil(((1080n) - 5p) / (10u)))) < 119.5n) ? (50n > (((60n) - 0) + 60n) ? 50n : (((60n) - 0) + 60n)) + 5e-08 : (100n > (((60n) - 0) + 80n) ? 100n : (((60n) - 0) + 80n))+60n) / (1u)) - ((((((1080n) / (ceil(((1080n) - 5p) / (10u)))) < 119.5n) ? (50n > (((60n) - 0) + 60n) ? 50n : (((60n) - 0) + 60n)) + 5e-08 : (100n > (((60n) - 0) + 80n) ? 100n : (((60n) - 0) + 80n))+60n)+(45n))/10 + (1u)/100)*exp(-10 * (((((1080n) / (ceil(((1080n) - 5p) / (10u)))) < 119.5n) ? (50n > (((60n) - 0) + 60n) ? 50n : (((60n) - 0) + 60n)) + 5e-08 : (100n > (((60n) - 0) + 80n) ? 100n : (((60n) - 0) + 80n))+60n)+(45n)) / (1u)) + (((((1080n) / (ceil(((1080n) - 5p) / (10u)))) < 119.5n) ? (50n > (((60n) - 0) + 60n) ? 50n : (((60n) - 0) + 60n)) + 5e-08 : (100n > (((60n) - 0) + 80n) ? 100n : (((60n) - 0) + 80n))+60n)/10 + (1u)/100)*exp(-10 * ((((1080n) / (ceil(((1080n) - 5p) / (10u)))) < 119.5n) ? (50n > (((60n) - 0) + 60n) ? 50n : (((60n) - 0) + 60n)) + 5e-08 : (100n > (((60n) - 0) + 80n) ? 100n : (((60n) - 0) + 80n))+60n) / (1u)) - ((((((1080n) / (ceil(((1080n) - 5p) / (10u)))) < 119.5n) ? (50n > (((60n) - 0) + 60n) ? 50n : (((60n) - 0) + 60n)) + 5e-08 : (100n > (((60n) - 0) + 80n) ? 100n : (((60n) - 0) + 80n))+60n)+(45n))/10 + (1u)/100)*exp(-10 * (((((1080n) / (ceil(((1080n) - 5p) / (10u)))) < 119.5n) ? (50n > (((60n) - 0) + 60n) ? 50n : (((60n) - 0) + 60n)) + 5e-08 : (100n > (((60n) - 0) + 80n) ? 100n : (((60n) - 0) + 80n))+60n)+(45n)) / (1u)))) + ((45n) * (((60n)/10 + (1u)/100)*exp(-10 * (60n) / (1u)) - (((60n)+((1080n) / (ceil(((1080n) - 5p) / (10u)))))/10 + (1u)/100)*exp(-10 * ((60n)+((1080n) / (ceil(((1080n) - 5p) / (10u))))) / (1u)) + ((60n)/10 + (1u)/100)*exp(-10 * (60n) / (1u)) - (((60n)+((1080n) / (ceil(((1080n) - 5p) / (10u)))))/10 + (1u)/100)*exp(-10 * ((60n)+((1080n) / (ceil(((1080n) - 5p) / (10u))))) / (1u))))) / (((1080n) / (ceil(((1080n) - 5p) / (10u)))) * (45n))           scc=((((1080n) / (ceil(((1080n) - 5p) / (10u)))) * ((((((1080n) / (ceil(((1080n) - 5p) / (10u)))) < 119.5n) ? (50n > (((60n) - 0) + 60n) ? 50n : (((60n) - 0) + 60n)) + 5e-08 : (100n > (((60n) - 0) + 80n) ? 100n : (((60n) - 0) + 80n))+60n)/20 + (1u)/400)*exp(-20 * ((((1080n) / (ceil(((1080n) - 5p) / (10u)))) < 119.5n) ? (50n > (((60n) - 0) + 60n) ? 50n : (((60n) - 0) + 60n)) + 5e-08 : (100n > (((60n) - 0) + 80n) ? 100n : (((60n) - 0) + 80n))+60n) / (1u)) - ((((((1080n) / (ceil(((1080n) - 5p) / (10u)))) < 119.5n) ? (50n > (((60n) - 0) + 60n) ? 50n : (((60n) - 0) + 60n)) + 5e-08 : (100n > (((60n) - 0) + 80n) ? 100n : (((60n) - 0) + 80n))+60n)+(45n))/20 + (1u)/400)*exp(-20 * (((((1080n) / (ceil(((1080n) - 5p) / (10u)))) < 119.5n) ? (50n > (((60n) - 0) + 60n) ? 50n : (((60n) - 0) + 60n)) + 5e-08 : (100n > (((60n) - 0) + 80n) ? 100n : (((60n) - 0) + 80n))+60n)+(45n)) / (1u)) + (((((1080n) / (ceil(((1080n) - 5p) / (10u)))) < 119.5n) ? (50n > (((60n) - 0) + 60n) ? 50n : (((60n) - 0) + 60n)) + 5e-08 : (100n > (((60n) - 0) + 80n) ? 100n : (((60n) - 0) + 80n))+60n)/20 + (1u)/400)*exp(-20 * ((((1080n) / (ceil(((1080n) - 5p) / (10u)))) < 119.5n) ? (50n > (((60n) - 0) + 60n) ? 50n : (((60n) - 0) + 60n)) + 5e-08 : (100n > (((60n) - 0) + 80n) ? 100n : (((60n) - 0) + 80n))+60n) / (1u)) - ((((((1080n) / (ceil(((1080n) - 5p) / (10u)))) < 119.5n) ? (50n > (((60n) - 0) + 60n) ? 50n : (((60n) - 0) + 60n)) + 5e-08 : (100n > (((60n) - 0) + 80n) ? 100n : (((60n) - 0) + 80n))+60n)+(45n))/20 + (1u)/400)*exp(-20 * (((((1080n) / (ceil(((1080n) - 5p) / (10u)))) < 119.5n) ? (50n > (((60n) - 0) + 60n) ? 50n : (((60n) - 0) + 60n)) + 5e-08 : (100n > (((60n) - 0) + 80n) ? 100n : (((60n) - 0) + 80n))+60n)+(45n)) / (1u)))) + ((45n) * (((60n)/20 + (1u)/400)*exp(-20 * (60n) / (1u)) - (((60n)+((1080n) / (ceil(((1080n) - 5p) / (10u)))))/20 + (1u)/400)*exp(-20 * ((60n)+((1080n) / (ceil(((1080n) - 5p) / (10u))))) / (1u)) + ((60n)/20 + (1u)/400)*exp(-20 * (60n) / (1u)) - (((60n)+((1080n) / (ceil(((1080n) - 5p) / (10u)))))/20 + (1u)/400)*exp(-20 * ((60n)+((1080n) / (ceil(((1080n) - 5p) / (10u))))) / (1u))))) / (((1080n) / (ceil(((1080n) - 5p) / (10u)))) * (45n))           m=(1)
ends
subckt precharge_unit (BL BLB PCB VDD GND)
P0 (BL PCB VDD VDD) g45p1svt w=(1080n) l=45n nf=ceil(((1080n) - 5p) / (10u))           as=(((1080n) / (ceil(((1080n) - 5p) / (10u)))) < 119.5n) ? ((((50n > (((60n) - 0) + 60n) ? 50n : (((60n) - 0) + 60n)) * 120n) + (((1080n) / (ceil(((1080n) - 5p) / (10u)))) * 50n)) + (floor(((ceil(((1080n) - 5p) / (10u))) - 1) / 2.0) * (((((60n) - 0) + 60n) * 120n) + (((1080n) / (ceil(((1080n) - 5p) / (10u)))) * 100n))) + ((((ceil(((1080n) - 5p) / (10u))) / 2) - floor((ceil(((1080n) - 5p) / (10u))) / 2) == 0) ? (((50n > (((60n) - 0) + 60n) ? 50n : (((60n) - 0) + 60n)) * 120n) + (((1080n) / (ceil(((1080n) - 5p) / (10u)))) * 50n)) : 0)) / 1 : (((100n > (((60n) - 0) + 80n) ? 100n : (((60n) - 0) + 80n)) * ((1080n) / (ceil(((1080n) - 5p) / (10u))))) + (floor(((ceil(((1080n) - 5p) / (10u))) - 1) / 2.0) * ((60n > (((60n) - 0) + 50n) ? 60n : (((60n) - 0) + 50n)) * ((1080n) / (ceil(((1080n) - 5p) / (10u)))))) + ((((ceil(((1080n) - 5p) / (10u))) / 2) - floor((ceil(((1080n) - 5p) / (10u))) / 2) == 0) ? ((100n > (((60n) - 0) + 80n) ? 100n : (((60n) - 0) + 80n)) * ((1080n) / (ceil(((1080n) - 5p) / (10u))))) : 0)) / 1           ad=(((1080n) / (ceil(((1080n) - 5p) / (10u)))) < 119.5n) ? ((floor((ceil(((1080n) - 5p) / (10u))) / 2.0) * (((((60n) - 0) + 60n) * 120n) + (((1080n) / (ceil(((1080n) - 5p) / (10u)))) * 100n))) + ((((ceil(((1080n) - 5p) / (10u))) / 2) - floor((ceil(((1080n) - 5p) / (10u))) / 2) != 0) ? (((50n > (((60n) - 0) + 60n) ? 50n : (((60n) - 0) + 60n)) * 120n) + (((1080n) / (ceil(((1080n) - 5p) / (10u)))) * 50n)) : 0)) / 1 : ((floor((ceil(((1080n) - 5p) / (10u))) / 2.0) * ((60n > (((60n) - 0) + 50n) ? 60n : (((60n) - 0) + 50n)) * ((1080n) / (ceil(((1080n) - 5p) / (10u)))))) + ((((ceil(((1080n) - 5p) / (10u))) / 2) - floor((ceil(((1080n) - 5p) / (10u))) / 2) != 0) ? ((100n > (((60n) - 0) + 80n) ? 100n : (((60n) - 0) + 80n)) * ((1080n) / (ceil(((1080n) - 5p) / (10u))))) : 0)) / 1           ps=(((1080n) / (ceil(((1080n) - 5p) / (10u)))) < 119.5n) ? (((2 * (50n > (((60n) - 0) + 60n) ? 50n : (((60n) - 0) + 60n))) + 340n) + (floor(((ceil(((1080n) - 5p) / (10u))) - 1) / 2.0) * ((2 * (((60n) - 0) + 60n)) + 440n)) + ((((ceil(((1080n) - 5p) / (10u))) / 2) - floor((ceil(((1080n) - 5p) / (10u))) / 2) == 0) ? ((2 * (50n > (((60n) - 0) + 60n) ? 50n : (((60n) - 0) + 60n))) + 340n) : 0)) / 1 : (((2 * (100n > (((60n) - 0) + 80n) ? 100n : (((60n) - 0) + 80n))) + (2 * ((1080n) / (ceil(((1080n) - 5p) / (10u)))))) + (floor(((ceil(((1080n) - 5p) / (10u))) - 1) / 2.0) * ((2 * (60n > (((60n) - 0) + 50n) ? 60n : (((60n) - 0) + 50n))) + (2 * ((1080n) / (ceil(((1080n) - 5p) / (10u))))))) + ((((ceil(((1080n) - 5p) / (10u))) / 2) - floor((ceil(((1080n) - 5p) / (10u))) / 2) == 0) ? ((2 * (100n > (((60n) - 0) + 80n) ? 100n : (((60n) - 0) + 80n))) + (2 * ((1080n) / (ceil(((1080n) - 5p) / (10u)))))) : 0)) / 1           pd=(((1080n) / (ceil(((1080n) - 5p) / (10u)))) < 119.5n) ? ((floor((ceil(((1080n) - 5p) / (10u))) / 2.0) * ((2 * (((60n) - 0) + 60n)) + 440n)) + ((((ceil(((1080n) - 5p) / (10u))) / 2) - floor((ceil(((1080n) - 5p) / (10u))) / 2) != 0) ? ((2 * (50n > (((60n) - 0) + 60n) ? 50n : (((60n) - 0) + 60n))) + 340n) : 0)) / 1 : ((floor((ceil(((1080n) - 5p) / (10u))) / 2.0) * ((2 * (60n > (((60n) - 0) + 50n) ? 60n : (((60n) - 0) + 50n))) + (2 * ((1080n) / (ceil(((1080n) - 5p) / (10u))))))) + ((((ceil(((1080n) - 5p) / (10u))) / 2) - floor((ceil(((1080n) - 5p) / (10u))) / 2) != 0) ? ((2 * (100n > (((60n) - 0) + 80n) ? 100n : (((60n) - 0) + 80n))) + (2 * ((1080n) / (ceil(((1080n) - 5p) / (10u)))))) : 0)) / 1           nrd=(((1080n) / (ceil(((1080n) - 5p) / (10u)))) < 119.5n) ? ((floor((ceil(((1080n) - 5p) / (10u))) / 2.0) * (((((60n) - 0) + 60n) * 120n) + (((1080n) / (ceil(((1080n) - 5p) / (10u)))) * 100n))) + ((((ceil(((1080n) - 5p) / (10u))) / 2) - floor((ceil(((1080n) - 5p) / (10u))) / 2) != 0) ? (((50n > (((60n) - 0) + 60n) ? 50n : (((60n) - 0) + 60n)) * 120n) + (((1080n) / (ceil(((1080n) - 5p) / (10u)))) * 50n)) : 0)) / 1 : ((floor((ceil(((1080n) - 5p) / (10u))) / 2.0) * ((60n > (((60n) - 0) + 50n) ? 60n : (((60n) - 0) + 50n)) * ((1080n) / (ceil(((1080n) - 5p) / (10u)))))) + ((((ceil(((1080n) - 5p) / (10u))) / 2) - floor((ceil(((1080n) - 5p) / (10u))) / 2) != 0) ? ((100n > (((60n) - 0) + 80n) ? 100n : (((60n) - 0) + 80n)) * ((1080n) / (ceil(((1080n) - 5p) / (10u))))) : 0)) / 1 / (((1080n) / (ceil(((1080n) - 5p) / (10u)))) * (ceil(((1080n) - 5p) / (10u))) * ((1080n) / (ceil(((1080n) - 5p) / (10u)))) * (ceil(((1080n) - 5p) / (10u))))           nrs=(((1080n) / (ceil(((1080n) - 5p) / (10u)))) < 119.5n) ? ((((50n > (((60n) - 0) + 60n) ? 50n : (((60n) - 0) + 60n)) * 120n) + (((1080n) / (ceil(((1080n) - 5p) / (10u)))) * 50n)) + (floor(((ceil(((1080n) - 5p) / (10u))) - 1) / 2.0) * (((((60n) - 0) + 60n) * 120n) + (((1080n) / (ceil(((1080n) - 5p) / (10u)))) * 100n))) + ((((ceil(((1080n) - 5p) / (10u))) / 2) - floor((ceil(((1080n) - 5p) / (10u))) / 2) == 0) ? (((50n > (((60n) - 0) + 60n) ? 50n : (((60n) - 0) + 60n)) * 120n) + (((1080n) / (ceil(((1080n) - 5p) / (10u)))) * 50n)) : 0)) / 1 : (((100n > (((60n) - 0) + 80n) ? 100n : (((60n) - 0) + 80n)) * ((1080n) / (ceil(((1080n) - 5p) / (10u))))) + (floor(((ceil(((1080n) - 5p) / (10u))) - 1) / 2.0) * ((60n > (((60n) - 0) + 50n) ? 60n : (((60n) - 0) + 50n)) * ((1080n) / (ceil(((1080n) - 5p) / (10u)))))) + ((((ceil(((1080n) - 5p) / (10u))) / 2) - floor((ceil(((1080n) - 5p) / (10u))) / 2) == 0) ? ((100n > (((60n) - 0) + 80n) ? 100n : (((60n) - 0) + 80n)) * ((1080n) / (ceil(((1080n) - 5p) / (10u))))) : 0)) / 1 / (((1080n) / (ceil(((1080n) - 5p) / (10u)))) * (ceil(((1080n) - 5p) / (10u))) * ((1080n) / (ceil(((1080n) - 5p) / (10u)))) * (ceil(((1080n) - 5p) / (10u))))           sa=(((1080n) / (ceil(((1080n) - 5p) / (10u)))) < 119.5n) ? (50n > (((60n) - 0) + 60n) ? 50n : (((60n) - 0) + 60n)) + 5e-08 : (100n > (((60n) - 0) + 80n) ? 100n : (((60n) - 0) + 80n))           sb=(((1080n) / (ceil(((1080n) - 5p) / (10u)))) < 119.5n) ? (50n > (((60n) - 0) + 60n) ? 50n : (((60n) - 0) + 60n)) + 5e-08 : (100n > (((60n) - 0) + 80n) ? 100n : (((60n) - 0) + 80n))           sd=(((1080n) / (ceil(((1080n) - 5p) / (10u)))) < 119.5n) ? (((60n) - 0) + 60n) + (2*5e-08) : (60n > (((60n) - 0) + 50n) ? 60n : (((60n) - 0) + 50n))           sca=(( ((1080n) / (ceil(((1080n) - 5p) / (10u)))) * ( (((1u) * (1u) / ((((1080n) / (ceil(((1080n) - 5p) / (10u)))) < 119.5n) ? (50n > (((60n) - 0) + 60n) ? 50n : (((60n) - 0) + 60n)) + 5e-08 : (100n > (((60n) - 0) + 80n) ? 100n : (((60n) - 0) + 80n))+60n)) - ((1u) * (1u) / (((((1080n) / (ceil(((1080n) - 5p) / (10u)))) < 119.5n) ? (50n > (((60n) - 0) + 60n) ? 50n : (((60n) - 0) + 60n)) + 5e-08 : (100n > (((60n) - 0) + 80n) ? 100n : (((60n) - 0) + 80n))+60n)+(45n)))) + ((1u) * (1u) / ((((1080n) / (ceil(((1080n) - 5p) / (10u)))) < 119.5n) ? (50n > (((60n) - 0) + 60n) ? 50n : (((60n) - 0) + 60n)) + 5e-08 : (100n > (((60n) - 0) + 80n) ? 100n : (((60n) - 0) + 80n))+60n)) - ((1u) * (1u)/ (((((1080n) / (ceil(((1080n) - 5p) / (10u)))) < 119.5n) ? (50n > (((60n) - 0) + 60n) ? 50n : (((60n) - 0) + 60n)) + 5e-08 : (100n > (((60n) - 0) + 80n) ? 100n : (((60n) - 0) + 80n))+60n)+(45n))))) + ( (45n) * ( (((1u) * (1u) / (60n)) - ((1u) * (1u) / ((60n)+((1080n) / (ceil(((1080n) - 5p) / (10u))))))) + ((1u) * (1u) / (60n)) - ((1u) * (1u)/ ((60n)+((1080n) / (ceil(((1080n) - 5p) / (10u))))))))) / (((1080n) / (ceil(((1080n) - 5p) / (10u)))) * (45n))           scb=((((1080n) / (ceil(((1080n) - 5p) / (10u)))) * ((((((1080n) / (ceil(((1080n) - 5p) / (10u)))) < 119.5n) ? (50n > (((60n) - 0) + 60n) ? 50n : (((60n) - 0) + 60n)) + 5e-08 : (100n > (((60n) - 0) + 80n) ? 100n : (((60n) - 0) + 80n))+60n)/10 + (1u)/100)*exp(-10 * ((((1080n) / (ceil(((1080n) - 5p) / (10u)))) < 119.5n) ? (50n > (((60n) - 0) + 60n) ? 50n : (((60n) - 0) + 60n)) + 5e-08 : (100n > (((60n) - 0) + 80n) ? 100n : (((60n) - 0) + 80n))+60n) / (1u)) - ((((((1080n) / (ceil(((1080n) - 5p) / (10u)))) < 119.5n) ? (50n > (((60n) - 0) + 60n) ? 50n : (((60n) - 0) + 60n)) + 5e-08 : (100n > (((60n) - 0) + 80n) ? 100n : (((60n) - 0) + 80n))+60n)+(45n))/10 + (1u)/100)*exp(-10 * (((((1080n) / (ceil(((1080n) - 5p) / (10u)))) < 119.5n) ? (50n > (((60n) - 0) + 60n) ? 50n : (((60n) - 0) + 60n)) + 5e-08 : (100n > (((60n) - 0) + 80n) ? 100n : (((60n) - 0) + 80n))+60n)+(45n)) / (1u)) + (((((1080n) / (ceil(((1080n) - 5p) / (10u)))) < 119.5n) ? (50n > (((60n) - 0) + 60n) ? 50n : (((60n) - 0) + 60n)) + 5e-08 : (100n > (((60n) - 0) + 80n) ? 100n : (((60n) - 0) + 80n))+60n)/10 + (1u)/100)*exp(-10 * ((((1080n) / (ceil(((1080n) - 5p) / (10u)))) < 119.5n) ? (50n > (((60n) - 0) + 60n) ? 50n : (((60n) - 0) + 60n)) + 5e-08 : (100n > (((60n) - 0) + 80n) ? 100n : (((60n) - 0) + 80n))+60n) / (1u)) - ((((((1080n) / (ceil(((1080n) - 5p) / (10u)))) < 119.5n) ? (50n > (((60n) - 0) + 60n) ? 50n : (((60n) - 0) + 60n)) + 5e-08 : (100n > (((60n) - 0) + 80n) ? 100n : (((60n) - 0) + 80n))+60n)+(45n))/10 + (1u)/100)*exp(-10 * (((((1080n) / (ceil(((1080n) - 5p) / (10u)))) < 119.5n) ? (50n > (((60n) - 0) + 60n) ? 50n : (((60n) - 0) + 60n)) + 5e-08 : (100n > (((60n) - 0) + 80n) ? 100n : (((60n) - 0) + 80n))+60n)+(45n)) / (1u)))) + ((45n) * (((60n)/10 + (1u)/100)*exp(-10 * (60n) / (1u)) - (((60n)+((1080n) / (ceil(((1080n) - 5p) / (10u)))))/10 + (1u)/100)*exp(-10 * ((60n)+((1080n) / (ceil(((1080n) - 5p) / (10u))))) / (1u)) + ((60n)/10 + (1u)/100)*exp(-10 * (60n) / (1u)) - (((60n)+((1080n) / (ceil(((1080n) - 5p) / (10u)))))/10 + (1u)/100)*exp(-10 * ((60n)+((1080n) / (ceil(((1080n) - 5p) / (10u))))) / (1u))))) / (((1080n) / (ceil(((1080n) - 5p) / (10u)))) * (45n))           scc=((((1080n) / (ceil(((1080n) - 5p) / (10u)))) * ((((((1080n) / (ceil(((1080n) - 5p) / (10u)))) < 119.5n) ? (50n > (((60n) - 0) + 60n) ? 50n : (((60n) - 0) + 60n)) + 5e-08 : (100n > (((60n) - 0) + 80n) ? 100n : (((60n) - 0) + 80n))+60n)/20 + (1u)/400)*exp(-20 * ((((1080n) / (ceil(((1080n) - 5p) / (10u)))) < 119.5n) ? (50n > (((60n) - 0) + 60n) ? 50n : (((60n) - 0) + 60n)) + 5e-08 : (100n > (((60n) - 0) + 80n) ? 100n : (((60n) - 0) + 80n))+60n) / (1u)) - ((((((1080n) / (ceil(((1080n) - 5p) / (10u)))) < 119.5n) ? (50n > (((60n) - 0) + 60n) ? 50n : (((60n) - 0) + 60n)) + 5e-08 : (100n > (((60n) - 0) + 80n) ? 100n : (((60n) - 0) + 80n))+60n)+(45n))/20 + (1u)/400)*exp(-20 * (((((1080n) / (ceil(((1080n) - 5p) / (10u)))) < 119.5n) ? (50n > (((60n) - 0) + 60n) ? 50n : (((60n) - 0) + 60n)) + 5e-08 : (100n > (((60n) - 0) + 80n) ? 100n : (((60n) - 0) + 80n))+60n)+(45n)) / (1u)) + (((((1080n) / (ceil(((1080n) - 5p) / (10u)))) < 119.5n) ? (50n > (((60n) - 0) + 60n) ? 50n : (((60n) - 0) + 60n)) + 5e-08 : (100n > (((60n) - 0) + 80n) ? 100n : (((60n) - 0) + 80n))+60n)/20 + (1u)/400)*exp(-20 * ((((1080n) / (ceil(((1080n) - 5p) / (10u)))) < 119.5n) ? (50n > (((60n) - 0) + 60n) ? 50n : (((60n) - 0) + 60n)) + 5e-08 : (100n > (((60n) - 0) + 80n) ? 100n : (((60n) - 0) + 80n))+60n) / (1u)) - ((((((1080n) / (ceil(((1080n) - 5p) / (10u)))) < 119.5n) ? (50n > (((60n) - 0) + 60n) ? 50n : (((60n) - 0) + 60n)) + 5e-08 : (100n > (((60n) - 0) + 80n) ? 100n : (((60n) - 0) + 80n))+60n)+(45n))/20 + (1u)/400)*exp(-20 * (((((1080n) / (ceil(((1080n) - 5p) / (10u)))) < 119.5n) ? (50n > (((60n) - 0) + 60n) ? 50n : (((60n) - 0) + 60n)) + 5e-08 : (100n > (((60n) - 0) + 80n) ? 100n : (((60n) - 0) + 80n))+60n)+(45n)) / (1u)))) + ((45n) * (((60n)/20 + (1u)/400)*exp(-20 * (60n) / (1u)) - (((60n)+((1080n) / (ceil(((1080n) - 5p) / (10u)))))/20 + (1u)/400)*exp(-20 * ((60n)+((1080n) / (ceil(((1080n) - 5p) / (10u))))) / (1u)) + ((60n)/20 + (1u)/400)*exp(-20 * (60n) / (1u)) - (((60n)+((1080n) / (ceil(((1080n) - 5p) / (10u)))))/20 + (1u)/400)*exp(-20 * ((60n)+((1080n) / (ceil(((1080n) - 5p) / (10u))))) / (1u))))) / (((1080n) / (ceil(((1080n) - 5p) / (10u)))) * (45n))           m=(1)
P1 (BLB PCB VDD VDD) g45p1svt w=(1080n) l=45n nf=ceil(((1080n) - 5p) / (10u))           as=(((1080n) / (ceil(((1080n) - 5p) / (10u)))) < 119.5n) ? ((((50n > (((60n) - 0) + 60n) ? 50n : (((60n) - 0) + 60n)) * 120n) + (((1080n) / (ceil(((1080n) - 5p) / (10u)))) * 50n)) + (floor(((ceil(((1080n) - 5p) / (10u))) - 1) / 2.0) * (((((60n) - 0) + 60n) * 120n) + (((1080n) / (ceil(((1080n) - 5p) / (10u)))) * 100n))) + ((((ceil(((1080n) - 5p) / (10u))) / 2) - floor((ceil(((1080n) - 5p) / (10u))) / 2) == 0) ? (((50n > (((60n) - 0) + 60n) ? 50n : (((60n) - 0) + 60n)) * 120n) + (((1080n) / (ceil(((1080n) - 5p) / (10u)))) * 50n)) : 0)) / 1 : (((100n > (((60n) - 0) + 80n) ? 100n : (((60n) - 0) + 80n)) * ((1080n) / (ceil(((1080n) - 5p) / (10u))))) + (floor(((ceil(((1080n) - 5p) / (10u))) - 1) / 2.0) * ((60n > (((60n) - 0) + 50n) ? 60n : (((60n) - 0) + 50n)) * ((1080n) / (ceil(((1080n) - 5p) / (10u)))))) + ((((ceil(((1080n) - 5p) / (10u))) / 2) - floor((ceil(((1080n) - 5p) / (10u))) / 2) == 0) ? ((100n > (((60n) - 0) + 80n) ? 100n : (((60n) - 0) + 80n)) * ((1080n) / (ceil(((1080n) - 5p) / (10u))))) : 0)) / 1           ad=(((1080n) / (ceil(((1080n) - 5p) / (10u)))) < 119.5n) ? ((floor((ceil(((1080n) - 5p) / (10u))) / 2.0) * (((((60n) - 0) + 60n) * 120n) + (((1080n) / (ceil(((1080n) - 5p) / (10u)))) * 100n))) + ((((ceil(((1080n) - 5p) / (10u))) / 2) - floor((ceil(((1080n) - 5p) / (10u))) / 2) != 0) ? (((50n > (((60n) - 0) + 60n) ? 50n : (((60n) - 0) + 60n)) * 120n) + (((1080n) / (ceil(((1080n) - 5p) / (10u)))) * 50n)) : 0)) / 1 : ((floor((ceil(((1080n) - 5p) / (10u))) / 2.0) * ((60n > (((60n) - 0) + 50n) ? 60n : (((60n) - 0) + 50n)) * ((1080n) / (ceil(((1080n) - 5p) / (10u)))))) + ((((ceil(((1080n) - 5p) / (10u))) / 2) - floor((ceil(((1080n) - 5p) / (10u))) / 2) != 0) ? ((100n > (((60n) - 0) + 80n) ? 100n : (((60n) - 0) + 80n)) * ((1080n) / (ceil(((1080n) - 5p) / (10u))))) : 0)) / 1           ps=(((1080n) / (ceil(((1080n) - 5p) / (10u)))) < 119.5n) ? (((2 * (50n > (((60n) - 0) + 60n) ? 50n : (((60n) - 0) + 60n))) + 340n) + (floor(((ceil(((1080n) - 5p) / (10u))) - 1) / 2.0) * ((2 * (((60n) - 0) + 60n)) + 440n)) + ((((ceil(((1080n) - 5p) / (10u))) / 2) - floor((ceil(((1080n) - 5p) / (10u))) / 2) == 0) ? ((2 * (50n > (((60n) - 0) + 60n) ? 50n : (((60n) - 0) + 60n))) + 340n) : 0)) / 1 : (((2 * (100n > (((60n) - 0) + 80n) ? 100n : (((60n) - 0) + 80n))) + (2 * ((1080n) / (ceil(((1080n) - 5p) / (10u)))))) + (floor(((ceil(((1080n) - 5p) / (10u))) - 1) / 2.0) * ((2 * (60n > (((60n) - 0) + 50n) ? 60n : (((60n) - 0) + 50n))) + (2 * ((1080n) / (ceil(((1080n) - 5p) / (10u))))))) + ((((ceil(((1080n) - 5p) / (10u))) / 2) - floor((ceil(((1080n) - 5p) / (10u))) / 2) == 0) ? ((2 * (100n > (((60n) - 0) + 80n) ? 100n : (((60n) - 0) + 80n))) + (2 * ((1080n) / (ceil(((1080n) - 5p) / (10u)))))) : 0)) / 1           pd=(((1080n) / (ceil(((1080n) - 5p) / (10u)))) < 119.5n) ? ((floor((ceil(((1080n) - 5p) / (10u))) / 2.0) * ((2 * (((60n) - 0) + 60n)) + 440n)) + ((((ceil(((1080n) - 5p) / (10u))) / 2) - floor((ceil(((1080n) - 5p) / (10u))) / 2) != 0) ? ((2 * (50n > (((60n) - 0) + 60n) ? 50n : (((60n) - 0) + 60n))) + 340n) : 0)) / 1 : ((floor((ceil(((1080n) - 5p) / (10u))) / 2.0) * ((2 * (60n > (((60n) - 0) + 50n) ? 60n : (((60n) - 0) + 50n))) + (2 * ((1080n) / (ceil(((1080n) - 5p) / (10u))))))) + ((((ceil(((1080n) - 5p) / (10u))) / 2) - floor((ceil(((1080n) - 5p) / (10u))) / 2) != 0) ? ((2 * (100n > (((60n) - 0) + 80n) ? 100n : (((60n) - 0) + 80n))) + (2 * ((1080n) / (ceil(((1080n) - 5p) / (10u)))))) : 0)) / 1           nrd=(((1080n) / (ceil(((1080n) - 5p) / (10u)))) < 119.5n) ? ((floor((ceil(((1080n) - 5p) / (10u))) / 2.0) * (((((60n) - 0) + 60n) * 120n) + (((1080n) / (ceil(((1080n) - 5p) / (10u)))) * 100n))) + ((((ceil(((1080n) - 5p) / (10u))) / 2) - floor((ceil(((1080n) - 5p) / (10u))) / 2) != 0) ? (((50n > (((60n) - 0) + 60n) ? 50n : (((60n) - 0) + 60n)) * 120n) + (((1080n) / (ceil(((1080n) - 5p) / (10u)))) * 50n)) : 0)) / 1 : ((floor((ceil(((1080n) - 5p) / (10u))) / 2.0) * ((60n > (((60n) - 0) + 50n) ? 60n : (((60n) - 0) + 50n)) * ((1080n) / (ceil(((1080n) - 5p) / (10u)))))) + ((((ceil(((1080n) - 5p) / (10u))) / 2) - floor((ceil(((1080n) - 5p) / (10u))) / 2) != 0) ? ((100n > (((60n) - 0) + 80n) ? 100n : (((60n) - 0) + 80n)) * ((1080n) / (ceil(((1080n) - 5p) / (10u))))) : 0)) / 1 / (((1080n) / (ceil(((1080n) - 5p) / (10u)))) * (ceil(((1080n) - 5p) / (10u))) * ((1080n) / (ceil(((1080n) - 5p) / (10u)))) * (ceil(((1080n) - 5p) / (10u))))           nrs=(((1080n) / (ceil(((1080n) - 5p) / (10u)))) < 119.5n) ? ((((50n > (((60n) - 0) + 60n) ? 50n : (((60n) - 0) + 60n)) * 120n) + (((1080n) / (ceil(((1080n) - 5p) / (10u)))) * 50n)) + (floor(((ceil(((1080n) - 5p) / (10u))) - 1) / 2.0) * (((((60n) - 0) + 60n) * 120n) + (((1080n) / (ceil(((1080n) - 5p) / (10u)))) * 100n))) + ((((ceil(((1080n) - 5p) / (10u))) / 2) - floor((ceil(((1080n) - 5p) / (10u))) / 2) == 0) ? (((50n > (((60n) - 0) + 60n) ? 50n : (((60n) - 0) + 60n)) * 120n) + (((1080n) / (ceil(((1080n) - 5p) / (10u)))) * 50n)) : 0)) / 1 : (((100n > (((60n) - 0) + 80n) ? 100n : (((60n) - 0) + 80n)) * ((1080n) / (ceil(((1080n) - 5p) / (10u))))) + (floor(((ceil(((1080n) - 5p) / (10u))) - 1) / 2.0) * ((60n > (((60n) - 0) + 50n) ? 60n : (((60n) - 0) + 50n)) * ((1080n) / (ceil(((1080n) - 5p) / (10u)))))) + ((((ceil(((1080n) - 5p) / (10u))) / 2) - floor((ceil(((1080n) - 5p) / (10u))) / 2) == 0) ? ((100n > (((60n) - 0) + 80n) ? 100n : (((60n) - 0) + 80n)) * ((1080n) / (ceil(((1080n) - 5p) / (10u))))) : 0)) / 1 / (((1080n) / (ceil(((1080n) - 5p) / (10u)))) * (ceil(((1080n) - 5p) / (10u))) * ((1080n) / (ceil(((1080n) - 5p) / (10u)))) * (ceil(((1080n) - 5p) / (10u))))           sa=(((1080n) / (ceil(((1080n) - 5p) / (10u)))) < 119.5n) ? (50n > (((60n) - 0) + 60n) ? 50n : (((60n) - 0) + 60n)) + 5e-08 : (100n > (((60n) - 0) + 80n) ? 100n : (((60n) - 0) + 80n))           sb=(((1080n) / (ceil(((1080n) - 5p) / (10u)))) < 119.5n) ? (50n > (((60n) - 0) + 60n) ? 50n : (((60n) - 0) + 60n)) + 5e-08 : (100n > (((60n) - 0) + 80n) ? 100n : (((60n) - 0) + 80n))           sd=(((1080n) / (ceil(((1080n) - 5p) / (10u)))) < 119.5n) ? (((60n) - 0) + 60n) + (2*5e-08) : (60n > (((60n) - 0) + 50n) ? 60n : (((60n) - 0) + 50n))           sca=(( ((1080n) / (ceil(((1080n) - 5p) / (10u)))) * ( (((1u) * (1u) / ((((1080n) / (ceil(((1080n) - 5p) / (10u)))) < 119.5n) ? (50n > (((60n) - 0) + 60n) ? 50n : (((60n) - 0) + 60n)) + 5e-08 : (100n > (((60n) - 0) + 80n) ? 100n : (((60n) - 0) + 80n))+60n)) - ((1u) * (1u) / (((((1080n) / (ceil(((1080n) - 5p) / (10u)))) < 119.5n) ? (50n > (((60n) - 0) + 60n) ? 50n : (((60n) - 0) + 60n)) + 5e-08 : (100n > (((60n) - 0) + 80n) ? 100n : (((60n) - 0) + 80n))+60n)+(45n)))) + ((1u) * (1u) / ((((1080n) / (ceil(((1080n) - 5p) / (10u)))) < 119.5n) ? (50n > (((60n) - 0) + 60n) ? 50n : (((60n) - 0) + 60n)) + 5e-08 : (100n > (((60n) - 0) + 80n) ? 100n : (((60n) - 0) + 80n))+60n)) - ((1u) * (1u)/ (((((1080n) / (ceil(((1080n) - 5p) / (10u)))) < 119.5n) ? (50n > (((60n) - 0) + 60n) ? 50n : (((60n) - 0) + 60n)) + 5e-08 : (100n > (((60n) - 0) + 80n) ? 100n : (((60n) - 0) + 80n))+60n)+(45n))))) + ( (45n) * ( (((1u) * (1u) / (60n)) - ((1u) * (1u) / ((60n)+((1080n) / (ceil(((1080n) - 5p) / (10u))))))) + ((1u) * (1u) / (60n)) - ((1u) * (1u)/ ((60n)+((1080n) / (ceil(((1080n) - 5p) / (10u))))))))) / (((1080n) / (ceil(((1080n) - 5p) / (10u)))) * (45n))           scb=((((1080n) / (ceil(((1080n) - 5p) / (10u)))) * ((((((1080n) / (ceil(((1080n) - 5p) / (10u)))) < 119.5n) ? (50n > (((60n) - 0) + 60n) ? 50n : (((60n) - 0) + 60n)) + 5e-08 : (100n > (((60n) - 0) + 80n) ? 100n : (((60n) - 0) + 80n))+60n)/10 + (1u)/100)*exp(-10 * ((((1080n) / (ceil(((1080n) - 5p) / (10u)))) < 119.5n) ? (50n > (((60n) - 0) + 60n) ? 50n : (((60n) - 0) + 60n)) + 5e-08 : (100n > (((60n) - 0) + 80n) ? 100n : (((60n) - 0) + 80n))+60n) / (1u)) - ((((((1080n) / (ceil(((1080n) - 5p) / (10u)))) < 119.5n) ? (50n > (((60n) - 0) + 60n) ? 50n : (((60n) - 0) + 60n)) + 5e-08 : (100n > (((60n) - 0) + 80n) ? 100n : (((60n) - 0) + 80n))+60n)+(45n))/10 + (1u)/100)*exp(-10 * (((((1080n) / (ceil(((1080n) - 5p) / (10u)))) < 119.5n) ? (50n > (((60n) - 0) + 60n) ? 50n : (((60n) - 0) + 60n)) + 5e-08 : (100n > (((60n) - 0) + 80n) ? 100n : (((60n) - 0) + 80n))+60n)+(45n)) / (1u)) + (((((1080n) / (ceil(((1080n) - 5p) / (10u)))) < 119.5n) ? (50n > (((60n) - 0) + 60n) ? 50n : (((60n) - 0) + 60n)) + 5e-08 : (100n > (((60n) - 0) + 80n) ? 100n : (((60n) - 0) + 80n))+60n)/10 + (1u)/100)*exp(-10 * ((((1080n) / (ceil(((1080n) - 5p) / (10u)))) < 119.5n) ? (50n > (((60n) - 0) + 60n) ? 50n : (((60n) - 0) + 60n)) + 5e-08 : (100n > (((60n) - 0) + 80n) ? 100n : (((60n) - 0) + 80n))+60n) / (1u)) - ((((((1080n) / (ceil(((1080n) - 5p) / (10u)))) < 119.5n) ? (50n > (((60n) - 0) + 60n) ? 50n : (((60n) - 0) + 60n)) + 5e-08 : (100n > (((60n) - 0) + 80n) ? 100n : (((60n) - 0) + 80n))+60n)+(45n))/10 + (1u)/100)*exp(-10 * (((((1080n) / (ceil(((1080n) - 5p) / (10u)))) < 119.5n) ? (50n > (((60n) - 0) + 60n) ? 50n : (((60n) - 0) + 60n)) + 5e-08 : (100n > (((60n) - 0) + 80n) ? 100n : (((60n) - 0) + 80n))+60n)+(45n)) / (1u)))) + ((45n) * (((60n)/10 + (1u)/100)*exp(-10 * (60n) / (1u)) - (((60n)+((1080n) / (ceil(((1080n) - 5p) / (10u)))))/10 + (1u)/100)*exp(-10 * ((60n)+((1080n) / (ceil(((1080n) - 5p) / (10u))))) / (1u)) + ((60n)/10 + (1u)/100)*exp(-10 * (60n) / (1u)) - (((60n)+((1080n) / (ceil(((1080n) - 5p) / (10u)))))/10 + (1u)/100)*exp(-10 * ((60n)+((1080n) / (ceil(((1080n) - 5p) / (10u))))) / (1u))))) / (((1080n) / (ceil(((1080n) - 5p) / (10u)))) * (45n))           scc=((((1080n) / (ceil(((1080n) - 5p) / (10u)))) * ((((((1080n) / (ceil(((1080n) - 5p) / (10u)))) < 119.5n) ? (50n > (((60n) - 0) + 60n) ? 50n : (((60n) - 0) + 60n)) + 5e-08 : (100n > (((60n) - 0) + 80n) ? 100n : (((60n) - 0) + 80n))+60n)/20 + (1u)/400)*exp(-20 * ((((1080n) / (ceil(((1080n) - 5p) / (10u)))) < 119.5n) ? (50n > (((60n) - 0) + 60n) ? 50n : (((60n) - 0) + 60n)) + 5e-08 : (100n > (((60n) - 0) + 80n) ? 100n : (((60n) - 0) + 80n))+60n) / (1u)) - ((((((1080n) / (ceil(((1080n) - 5p) / (10u)))) < 119.5n) ? (50n > (((60n) - 0) + 60n) ? 50n : (((60n) - 0) + 60n)) + 5e-08 : (100n > (((60n) - 0) + 80n) ? 100n : (((60n) - 0) + 80n))+60n)+(45n))/20 + (1u)/400)*exp(-20 * (((((1080n) / (ceil(((1080n) - 5p) / (10u)))) < 119.5n) ? (50n > (((60n) - 0) + 60n) ? 50n : (((60n) - 0) + 60n)) + 5e-08 : (100n > (((60n) - 0) + 80n) ? 100n : (((60n) - 0) + 80n))+60n)+(45n)) / (1u)) + (((((1080n) / (ceil(((1080n) - 5p) / (10u)))) < 119.5n) ? (50n > (((60n) - 0) + 60n) ? 50n : (((60n) - 0) + 60n)) + 5e-08 : (100n > (((60n) - 0) + 80n) ? 100n : (((60n) - 0) + 80n))+60n)/20 + (1u)/400)*exp(-20 * ((((1080n) / (ceil(((1080n) - 5p) / (10u)))) < 119.5n) ? (50n > (((60n) - 0) + 60n) ? 50n : (((60n) - 0) + 60n)) + 5e-08 : (100n > (((60n) - 0) + 80n) ? 100n : (((60n) - 0) + 80n))+60n) / (1u)) - ((((((1080n) / (ceil(((1080n) - 5p) / (10u)))) < 119.5n) ? (50n > (((60n) - 0) + 60n) ? 50n : (((60n) - 0) + 60n)) + 5e-08 : (100n > (((60n) - 0) + 80n) ? 100n : (((60n) - 0) + 80n))+60n)+(45n))/20 + (1u)/400)*exp(-20 * (((((1080n) / (ceil(((1080n) - 5p) / (10u)))) < 119.5n) ? (50n > (((60n) - 0) + 60n) ? 50n : (((60n) - 0) + 60n)) + 5e-08 : (100n > (((60n) - 0) + 80n) ? 100n : (((60n) - 0) + 80n))+60n)+(45n)) / (1u)))) + ((45n) * (((60n)/20 + (1u)/400)*exp(-20 * (60n) / (1u)) - (((60n)+((1080n) / (ceil(((1080n) - 5p) / (10u)))))/20 + (1u)/400)*exp(-20 * ((60n)+((1080n) / (ceil(((1080n) - 5p) / (10u))))) / (1u)) + ((60n)/20 + (1u)/400)*exp(-20 * (60n) / (1u)) - (((60n)+((1080n) / (ceil(((1080n) - 5p) / (10u)))))/20 + (1u)/400)*exp(-20 * ((60n)+((1080n) / (ceil(((1080n) - 5p) / (10u))))) / (1u))))) / (((1080n) / (ceil(((1080n) - 5p) / (10u)))) * (45n))           m=(1)
PEQ (BL PCB BLB VDD) g45p1svt w=(1080n) l=45n nf=ceil(((1080n) - 5p) / (10u))           as=(((1080n) / (ceil(((1080n) - 5p) / (10u)))) < 119.5n) ? ((((50n > (((60n) - 0) + 60n) ? 50n : (((60n) - 0) + 60n)) * 120n) + (((1080n) / (ceil(((1080n) - 5p) / (10u)))) * 50n)) + (floor(((ceil(((1080n) - 5p) / (10u))) - 1) / 2.0) * (((((60n) - 0) + 60n) * 120n) + (((1080n) / (ceil(((1080n) - 5p) / (10u)))) * 100n))) + ((((ceil(((1080n) - 5p) / (10u))) / 2) - floor((ceil(((1080n) - 5p) / (10u))) / 2) == 0) ? (((50n > (((60n) - 0) + 60n) ? 50n : (((60n) - 0) + 60n)) * 120n) + (((1080n) / (ceil(((1080n) - 5p) / (10u)))) * 50n)) : 0)) / 1 : (((100n > (((60n) - 0) + 80n) ? 100n : (((60n) - 0) + 80n)) * ((1080n) / (ceil(((1080n) - 5p) / (10u))))) + (floor(((ceil(((1080n) - 5p) / (10u))) - 1) / 2.0) * ((60n > (((60n) - 0) + 50n) ? 60n : (((60n) - 0) + 50n)) * ((1080n) / (ceil(((1080n) - 5p) / (10u)))))) + ((((ceil(((1080n) - 5p) / (10u))) / 2) - floor((ceil(((1080n) - 5p) / (10u))) / 2) == 0) ? ((100n > (((60n) - 0) + 80n) ? 100n : (((60n) - 0) + 80n)) * ((1080n) / (ceil(((1080n) - 5p) / (10u))))) : 0)) / 1           ad=(((1080n) / (ceil(((1080n) - 5p) / (10u)))) < 119.5n) ? ((floor((ceil(((1080n) - 5p) / (10u))) / 2.0) * (((((60n) - 0) + 60n) * 120n) + (((1080n) / (ceil(((1080n) - 5p) / (10u)))) * 100n))) + ((((ceil(((1080n) - 5p) / (10u))) / 2) - floor((ceil(((1080n) - 5p) / (10u))) / 2) != 0) ? (((50n > (((60n) - 0) + 60n) ? 50n : (((60n) - 0) + 60n)) * 120n) + (((1080n) / (ceil(((1080n) - 5p) / (10u)))) * 50n)) : 0)) / 1 : ((floor((ceil(((1080n) - 5p) / (10u))) / 2.0) * ((60n > (((60n) - 0) + 50n) ? 60n : (((60n) - 0) + 50n)) * ((1080n) / (ceil(((1080n) - 5p) / (10u)))))) + ((((ceil(((1080n) - 5p) / (10u))) / 2) - floor((ceil(((1080n) - 5p) / (10u))) / 2) != 0) ? ((100n > (((60n) - 0) + 80n) ? 100n : (((60n) - 0) + 80n)) * ((1080n) / (ceil(((1080n) - 5p) / (10u))))) : 0)) / 1           ps=(((1080n) / (ceil(((1080n) - 5p) / (10u)))) < 119.5n) ? (((2 * (50n > (((60n) - 0) + 60n) ? 50n : (((60n) - 0) + 60n))) + 340n) + (floor(((ceil(((1080n) - 5p) / (10u))) - 1) / 2.0) * ((2 * (((60n) - 0) + 60n)) + 440n)) + ((((ceil(((1080n) - 5p) / (10u))) / 2) - floor((ceil(((1080n) - 5p) / (10u))) / 2) == 0) ? ((2 * (50n > (((60n) - 0) + 60n) ? 50n : (((60n) - 0) + 60n))) + 340n) : 0)) / 1 : (((2 * (100n > (((60n) - 0) + 80n) ? 100n : (((60n) - 0) + 80n))) + (2 * ((1080n) / (ceil(((1080n) - 5p) / (10u)))))) + (floor(((ceil(((1080n) - 5p) / (10u))) - 1) / 2.0) * ((2 * (60n > (((60n) - 0) + 50n) ? 60n : (((60n) - 0) + 50n))) + (2 * ((1080n) / (ceil(((1080n) - 5p) / (10u))))))) + ((((ceil(((1080n) - 5p) / (10u))) / 2) - floor((ceil(((1080n) - 5p) / (10u))) / 2) == 0) ? ((2 * (100n > (((60n) - 0) + 80n) ? 100n : (((60n) - 0) + 80n))) + (2 * ((1080n) / (ceil(((1080n) - 5p) / (10u)))))) : 0)) / 1           pd=(((1080n) / (ceil(((1080n) - 5p) / (10u)))) < 119.5n) ? ((floor((ceil(((1080n) - 5p) / (10u))) / 2.0) * ((2 * (((60n) - 0) + 60n)) + 440n)) + ((((ceil(((1080n) - 5p) / (10u))) / 2) - floor((ceil(((1080n) - 5p) / (10u))) / 2) != 0) ? ((2 * (50n > (((60n) - 0) + 60n) ? 50n : (((60n) - 0) + 60n))) + 340n) : 0)) / 1 : ((floor((ceil(((1080n) - 5p) / (10u))) / 2.0) * ((2 * (60n > (((60n) - 0) + 50n) ? 60n : (((60n) - 0) + 50n))) + (2 * ((1080n) / (ceil(((1080n) - 5p) / (10u))))))) + ((((ceil(((1080n) - 5p) / (10u))) / 2) - floor((ceil(((1080n) - 5p) / (10u))) / 2) != 0) ? ((2 * (100n > (((60n) - 0) + 80n) ? 100n : (((60n) - 0) + 80n))) + (2 * ((1080n) / (ceil(((1080n) - 5p) / (10u)))))) : 0)) / 1           nrd=(((1080n) / (ceil(((1080n) - 5p) / (10u)))) < 119.5n) ? ((floor((ceil(((1080n) - 5p) / (10u))) / 2.0) * (((((60n) - 0) + 60n) * 120n) + (((1080n) / (ceil(((1080n) - 5p) / (10u)))) * 100n))) + ((((ceil(((1080n) - 5p) / (10u))) / 2) - floor((ceil(((1080n) - 5p) / (10u))) / 2) != 0) ? (((50n > (((60n) - 0) + 60n) ? 50n : (((60n) - 0) + 60n)) * 120n) + (((1080n) / (ceil(((1080n) - 5p) / (10u)))) * 50n)) : 0)) / 1 : ((floor((ceil(((1080n) - 5p) / (10u))) / 2.0) * ((60n > (((60n) - 0) + 50n) ? 60n : (((60n) - 0) + 50n)) * ((1080n) / (ceil(((1080n) - 5p) / (10u)))))) + ((((ceil(((1080n) - 5p) / (10u))) / 2) - floor((ceil(((1080n) - 5p) / (10u))) / 2) != 0) ? ((100n > (((60n) - 0) + 80n) ? 100n : (((60n) - 0) + 80n)) * ((1080n) / (ceil(((1080n) - 5p) / (10u))))) : 0)) / 1 / (((1080n) / (ceil(((1080n) - 5p) / (10u)))) * (ceil(((1080n) - 5p) / (10u))) * ((1080n) / (ceil(((1080n) - 5p) / (10u)))) * (ceil(((1080n) - 5p) / (10u))))           nrs=(((1080n) / (ceil(((1080n) - 5p) / (10u)))) < 119.5n) ? ((((50n > (((60n) - 0) + 60n) ? 50n : (((60n) - 0) + 60n)) * 120n) + (((1080n) / (ceil(((1080n) - 5p) / (10u)))) * 50n)) + (floor(((ceil(((1080n) - 5p) / (10u))) - 1) / 2.0) * (((((60n) - 0) + 60n) * 120n) + (((1080n) / (ceil(((1080n) - 5p) / (10u)))) * 100n))) + ((((ceil(((1080n) - 5p) / (10u))) / 2) - floor((ceil(((1080n) - 5p) / (10u))) / 2) == 0) ? (((50n > (((60n) - 0) + 60n) ? 50n : (((60n) - 0) + 60n)) * 120n) + (((1080n) / (ceil(((1080n) - 5p) / (10u)))) * 50n)) : 0)) / 1 : (((100n > (((60n) - 0) + 80n) ? 100n : (((60n) - 0) + 80n)) * ((1080n) / (ceil(((1080n) - 5p) / (10u))))) + (floor(((ceil(((1080n) - 5p) / (10u))) - 1) / 2.0) * ((60n > (((60n) - 0) + 50n) ? 60n : (((60n) - 0) + 50n)) * ((1080n) / (ceil(((1080n) - 5p) / (10u)))))) + ((((ceil(((1080n) - 5p) / (10u))) / 2) - floor((ceil(((1080n) - 5p) / (10u))) / 2) == 0) ? ((100n > (((60n) - 0) + 80n) ? 100n : (((60n) - 0) + 80n)) * ((1080n) / (ceil(((1080n) - 5p) / (10u))))) : 0)) / 1 / (((1080n) / (ceil(((1080n) - 5p) / (10u)))) * (ceil(((1080n) - 5p) / (10u))) * ((1080n) / (ceil(((1080n) - 5p) / (10u)))) * (ceil(((1080n) - 5p) / (10u))))           sa=(((1080n) / (ceil(((1080n) - 5p) / (10u)))) < 119.5n) ? (50n > (((60n) - 0) + 60n) ? 50n : (((60n) - 0) + 60n)) + 5e-08 : (100n > (((60n) - 0) + 80n) ? 100n : (((60n) - 0) + 80n))           sb=(((1080n) / (ceil(((1080n) - 5p) / (10u)))) < 119.5n) ? (50n > (((60n) - 0) + 60n) ? 50n : (((60n) - 0) + 60n)) + 5e-08 : (100n > (((60n) - 0) + 80n) ? 100n : (((60n) - 0) + 80n))           sd=(((1080n) / (ceil(((1080n) - 5p) / (10u)))) < 119.5n) ? (((60n) - 0) + 60n) + (2*5e-08) : (60n > (((60n) - 0) + 50n) ? 60n : (((60n) - 0) + 50n))           sca=(( ((1080n) / (ceil(((1080n) - 5p) / (10u)))) * ( (((1u) * (1u) / ((((1080n) / (ceil(((1080n) - 5p) / (10u)))) < 119.5n) ? (50n > (((60n) - 0) + 60n) ? 50n : (((60n) - 0) + 60n)) + 5e-08 : (100n > (((60n) - 0) + 80n) ? 100n : (((60n) - 0) + 80n))+60n)) - ((1u) * (1u) / (((((1080n) / (ceil(((1080n) - 5p) / (10u)))) < 119.5n) ? (50n > (((60n) - 0) + 60n) ? 50n : (((60n) - 0) + 60n)) + 5e-08 : (100n > (((60n) - 0) + 80n) ? 100n : (((60n) - 0) + 80n))+60n)+(45n)))) + ((1u) * (1u) / ((((1080n) / (ceil(((1080n) - 5p) / (10u)))) < 119.5n) ? (50n > (((60n) - 0) + 60n) ? 50n : (((60n) - 0) + 60n)) + 5e-08 : (100n > (((60n) - 0) + 80n) ? 100n : (((60n) - 0) + 80n))+60n)) - ((1u) * (1u)/ (((((1080n) / (ceil(((1080n) - 5p) / (10u)))) < 119.5n) ? (50n > (((60n) - 0) + 60n) ? 50n : (((60n) - 0) + 60n)) + 5e-08 : (100n > (((60n) - 0) + 80n) ? 100n : (((60n) - 0) + 80n))+60n)+(45n))))) + ( (45n) * ( (((1u) * (1u) / (60n)) - ((1u) * (1u) / ((60n)+((1080n) / (ceil(((1080n) - 5p) / (10u))))))) + ((1u) * (1u) / (60n)) - ((1u) * (1u)/ ((60n)+((1080n) / (ceil(((1080n) - 5p) / (10u))))))))) / (((1080n) / (ceil(((1080n) - 5p) / (10u)))) * (45n))           scb=((((1080n) / (ceil(((1080n) - 5p) / (10u)))) * ((((((1080n) / (ceil(((1080n) - 5p) / (10u)))) < 119.5n) ? (50n > (((60n) - 0) + 60n) ? 50n : (((60n) - 0) + 60n)) + 5e-08 : (100n > (((60n) - 0) + 80n) ? 100n : (((60n) - 0) + 80n))+60n)/10 + (1u)/100)*exp(-10 * ((((1080n) / (ceil(((1080n) - 5p) / (10u)))) < 119.5n) ? (50n > (((60n) - 0) + 60n) ? 50n : (((60n) - 0) + 60n)) + 5e-08 : (100n > (((60n) - 0) + 80n) ? 100n : (((60n) - 0) + 80n))+60n) / (1u)) - ((((((1080n) / (ceil(((1080n) - 5p) / (10u)))) < 119.5n) ? (50n > (((60n) - 0) + 60n) ? 50n : (((60n) - 0) + 60n)) + 5e-08 : (100n > (((60n) - 0) + 80n) ? 100n : (((60n) - 0) + 80n))+60n)+(45n))/10 + (1u)/100)*exp(-10 * (((((1080n) / (ceil(((1080n) - 5p) / (10u)))) < 119.5n) ? (50n > (((60n) - 0) + 60n) ? 50n : (((60n) - 0) + 60n)) + 5e-08 : (100n > (((60n) - 0) + 80n) ? 100n : (((60n) - 0) + 80n))+60n)+(45n)) / (1u)) + (((((1080n) / (ceil(((1080n) - 5p) / (10u)))) < 119.5n) ? (50n > (((60n) - 0) + 60n) ? 50n : (((60n) - 0) + 60n)) + 5e-08 : (100n > (((60n) - 0) + 80n) ? 100n : (((60n) - 0) + 80n))+60n)/10 + (1u)/100)*exp(-10 * ((((1080n) / (ceil(((1080n) - 5p) / (10u)))) < 119.5n) ? (50n > (((60n) - 0) + 60n) ? 50n : (((60n) - 0) + 60n)) + 5e-08 : (100n > (((60n) - 0) + 80n) ? 100n : (((60n) - 0) + 80n))+60n) / (1u)) - ((((((1080n) / (ceil(((1080n) - 5p) / (10u)))) < 119.5n) ? (50n > (((60n) - 0) + 60n) ? 50n : (((60n) - 0) + 60n)) + 5e-08 : (100n > (((60n) - 0) + 80n) ? 100n : (((60n) - 0) + 80n))+60n)+(45n))/10 + (1u)/100)*exp(-10 * (((((1080n) / (ceil(((1080n) - 5p) / (10u)))) < 119.5n) ? (50n > (((60n) - 0) + 60n) ? 50n : (((60n) - 0) + 60n)) + 5e-08 : (100n > (((60n) - 0) + 80n) ? 100n : (((60n) - 0) + 80n))+60n)+(45n)) / (1u)))) + ((45n) * (((60n)/10 + (1u)/100)*exp(-10 * (60n) / (1u)) - (((60n)+((1080n) / (ceil(((1080n) - 5p) / (10u)))))/10 + (1u)/100)*exp(-10 * ((60n)+((1080n) / (ceil(((1080n) - 5p) / (10u))))) / (1u)) + ((60n)/10 + (1u)/100)*exp(-10 * (60n) / (1u)) - (((60n)+((1080n) / (ceil(((1080n) - 5p) / (10u)))))/10 + (1u)/100)*exp(-10 * ((60n)+((1080n) / (ceil(((1080n) - 5p) / (10u))))) / (1u))))) / (((1080n) / (ceil(((1080n) - 5p) / (10u)))) * (45n))           scc=((((1080n) / (ceil(((1080n) - 5p) / (10u)))) * ((((((1080n) / (ceil(((1080n) - 5p) / (10u)))) < 119.5n) ? (50n > (((60n) - 0) + 60n) ? 50n : (((60n) - 0) + 60n)) + 5e-08 : (100n > (((60n) - 0) + 80n) ? 100n : (((60n) - 0) + 80n))+60n)/20 + (1u)/400)*exp(-20 * ((((1080n) / (ceil(((1080n) - 5p) / (10u)))) < 119.5n) ? (50n > (((60n) - 0) + 60n) ? 50n : (((60n) - 0) + 60n)) + 5e-08 : (100n > (((60n) - 0) + 80n) ? 100n : (((60n) - 0) + 80n))+60n) / (1u)) - ((((((1080n) / (ceil(((1080n) - 5p) / (10u)))) < 119.5n) ? (50n > (((60n) - 0) + 60n) ? 50n : (((60n) - 0) + 60n)) + 5e-08 : (100n > (((60n) - 0) + 80n) ? 100n : (((60n) - 0) + 80n))+60n)+(45n))/20 + (1u)/400)*exp(-20 * (((((1080n) / (ceil(((1080n) - 5p) / (10u)))) < 119.5n) ? (50n > (((60n) - 0) + 60n) ? 50n : (((60n) - 0) + 60n)) + 5e-08 : (100n > (((60n) - 0) + 80n) ? 100n : (((60n) - 0) + 80n))+60n)+(45n)) / (1u)) + (((((1080n) / (ceil(((1080n) - 5p) / (10u)))) < 119.5n) ? (50n > (((60n) - 0) + 60n) ? 50n : (((60n) - 0) + 60n)) + 5e-08 : (100n > (((60n) - 0) + 80n) ? 100n : (((60n) - 0) + 80n))+60n)/20 + (1u)/400)*exp(-20 * ((((1080n) / (ceil(((1080n) - 5p) / (10u)))) < 119.5n) ? (50n > (((60n) - 0) + 60n) ? 50n : (((60n) - 0) + 60n)) + 5e-08 : (100n > (((60n) - 0) + 80n) ? 100n : (((60n) - 0) + 80n))+60n) / (1u)) - ((((((1080n) / (ceil(((1080n) - 5p) / (10u)))) < 119.5n) ? (50n > (((60n) - 0) + 60n) ? 50n : (((60n) - 0) + 60n)) + 5e-08 : (100n > (((60n) - 0) + 80n) ? 100n : (((60n) - 0) + 80n))+60n)+(45n))/20 + (1u)/400)*exp(-20 * (((((1080n) / (ceil(((1080n) - 5p) / (10u)))) < 119.5n) ? (50n > (((60n) - 0) + 60n) ? 50n : (((60n) - 0) + 60n)) + 5e-08 : (100n > (((60n) - 0) + 80n) ? 100n : (((60n) - 0) + 80n))+60n)+(45n)) / (1u)))) + ((45n) * (((60n)/20 + (1u)/400)*exp(-20 * (60n) / (1u)) - (((60n)+((1080n) / (ceil(((1080n) - 5p) / (10u)))))/20 + (1u)/400)*exp(-20 * ((60n)+((1080n) / (ceil(((1080n) - 5p) / (10u))))) / (1u)) + ((60n)/20 + (1u)/400)*exp(-20 * (60n) / (1u)) - (((60n)+((1080n) / (ceil(((1080n) - 5p) / (10u)))))/20 + (1u)/400)*exp(-20 * ((60n)+((1080n) / (ceil(((1080n) - 5p) / (10u))))) / (1u))))) / (((1080n) / (ceil(((1080n) - 5p) / (10u)))) * (45n))           m=(1)
ends
subckt sense_amp (BIT BIT_bar RE VDD GND AMP_OUT)
PM6 (nd nd VDD VDD) g45p1svt w=(1440n) l=45n nf=ceil(((1440n) - 5p) / (10u))           as=(((1440n) / (ceil(((1440n) - 5p) / (10u)))) < 119.5n) ? ((((50n > (((60n) - 0) + 60n) ? 50n : (((60n) - 0) + 60n)) * 120n) + (((1440n) / (ceil(((1440n) - 5p) / (10u)))) * 50n)) + (floor(((ceil(((1440n) - 5p) / (10u))) - 1) / 2.0) * (((((60n) - 0) + 60n) * 120n) + (((1440n) / (ceil(((1440n) - 5p) / (10u)))) * 100n))) + ((((ceil(((1440n) - 5p) / (10u))) / 2) - floor((ceil(((1440n) - 5p) / (10u))) / 2) == 0) ? (((50n > (((60n) - 0) + 60n) ? 50n : (((60n) - 0) + 60n)) * 120n) + (((1440n) / (ceil(((1440n) - 5p) / (10u)))) * 50n)) : 0)) / 1 : (((100n > (((60n) - 0) + 80n) ? 100n : (((60n) - 0) + 80n)) * ((1440n) / (ceil(((1440n) - 5p) / (10u))))) + (floor(((ceil(((1440n) - 5p) / (10u))) - 1) / 2.0) * ((60n > (((60n) - 0) + 50n) ? 60n : (((60n) - 0) + 50n)) * ((1440n) / (ceil(((1440n) - 5p) / (10u)))))) + ((((ceil(((1440n) - 5p) / (10u))) / 2) - floor((ceil(((1440n) - 5p) / (10u))) / 2) == 0) ? ((100n > (((60n) - 0) + 80n) ? 100n : (((60n) - 0) + 80n)) * ((1440n) / (ceil(((1440n) - 5p) / (10u))))) : 0)) / 1           ad=(((1440n) / (ceil(((1440n) - 5p) / (10u)))) < 119.5n) ? ((floor((ceil(((1440n) - 5p) / (10u))) / 2.0) * (((((60n) - 0) + 60n) * 120n) + (((1440n) / (ceil(((1440n) - 5p) / (10u)))) * 100n))) + ((((ceil(((1440n) - 5p) / (10u))) / 2) - floor((ceil(((1440n) - 5p) / (10u))) / 2) != 0) ? (((50n > (((60n) - 0) + 60n) ? 50n : (((60n) - 0) + 60n)) * 120n) + (((1440n) / (ceil(((1440n) - 5p) / (10u)))) * 50n)) : 0)) / 1 : ((floor((ceil(((1440n) - 5p) / (10u))) / 2.0) * ((60n > (((60n) - 0) + 50n) ? 60n : (((60n) - 0) + 50n)) * ((1440n) / (ceil(((1440n) - 5p) / (10u)))))) + ((((ceil(((1440n) - 5p) / (10u))) / 2) - floor((ceil(((1440n) - 5p) / (10u))) / 2) != 0) ? ((100n > (((60n) - 0) + 80n) ? 100n : (((60n) - 0) + 80n)) * ((1440n) / (ceil(((1440n) - 5p) / (10u))))) : 0)) / 1           ps=(((1440n) / (ceil(((1440n) - 5p) / (10u)))) < 119.5n) ? (((2 * (50n > (((60n) - 0) + 60n) ? 50n : (((60n) - 0) + 60n))) + 340n) + (floor(((ceil(((1440n) - 5p) / (10u))) - 1) / 2.0) * ((2 * (((60n) - 0) + 60n)) + 440n)) + ((((ceil(((1440n) - 5p) / (10u))) / 2) - floor((ceil(((1440n) - 5p) / (10u))) / 2) == 0) ? ((2 * (50n > (((60n) - 0) + 60n) ? 50n : (((60n) - 0) + 60n))) + 340n) : 0)) / 1 : (((2 * (100n > (((60n) - 0) + 80n) ? 100n : (((60n) - 0) + 80n))) + (2 * ((1440n) / (ceil(((1440n) - 5p) / (10u)))))) + (floor(((ceil(((1440n) - 5p) / (10u))) - 1) / 2.0) * ((2 * (60n > (((60n) - 0) + 50n) ? 60n : (((60n) - 0) + 50n))) + (2 * ((1440n) / (ceil(((1440n) - 5p) / (10u))))))) + ((((ceil(((1440n) - 5p) / (10u))) / 2) - floor((ceil(((1440n) - 5p) / (10u))) / 2) == 0) ? ((2 * (100n > (((60n) - 0) + 80n) ? 100n : (((60n) - 0) + 80n))) + (2 * ((1440n) / (ceil(((1440n) - 5p) / (10u)))))) : 0)) / 1           pd=(((1440n) / (ceil(((1440n) - 5p) / (10u)))) < 119.5n) ? ((floor((ceil(((1440n) - 5p) / (10u))) / 2.0) * ((2 * (((60n) - 0) + 60n)) + 440n)) + ((((ceil(((1440n) - 5p) / (10u))) / 2) - floor((ceil(((1440n) - 5p) / (10u))) / 2) != 0) ? ((2 * (50n > (((60n) - 0) + 60n) ? 50n : (((60n) - 0) + 60n))) + 340n) : 0)) / 1 : ((floor((ceil(((1440n) - 5p) / (10u))) / 2.0) * ((2 * (60n > (((60n) - 0) + 50n) ? 60n : (((60n) - 0) + 50n))) + (2 * ((1440n) / (ceil(((1440n) - 5p) / (10u))))))) + ((((ceil(((1440n) - 5p) / (10u))) / 2) - floor((ceil(((1440n) - 5p) / (10u))) / 2) != 0) ? ((2 * (100n > (((60n) - 0) + 80n) ? 100n : (((60n) - 0) + 80n))) + (2 * ((1440n) / (ceil(((1440n) - 5p) / (10u)))))) : 0)) / 1           nrd=(((1440n) / (ceil(((1440n) - 5p) / (10u)))) < 119.5n) ? ((floor((ceil(((1440n) - 5p) / (10u))) / 2.0) * (((((60n) - 0) + 60n) * 120n) + (((1440n) / (ceil(((1440n) - 5p) / (10u)))) * 100n))) + ((((ceil(((1440n) - 5p) / (10u))) / 2) - floor((ceil(((1440n) - 5p) / (10u))) / 2) != 0) ? (((50n > (((60n) - 0) + 60n) ? 50n : (((60n) - 0) + 60n)) * 120n) + (((1440n) / (ceil(((1440n) - 5p) / (10u)))) * 50n)) : 0)) / 1 : ((floor((ceil(((1440n) - 5p) / (10u))) / 2.0) * ((60n > (((60n) - 0) + 50n) ? 60n : (((60n) - 0) + 50n)) * ((1440n) / (ceil(((1440n) - 5p) / (10u)))))) + ((((ceil(((1440n) - 5p) / (10u))) / 2) - floor((ceil(((1440n) - 5p) / (10u))) / 2) != 0) ? ((100n > (((60n) - 0) + 80n) ? 100n : (((60n) - 0) + 80n)) * ((1440n) / (ceil(((1440n) - 5p) / (10u))))) : 0)) / 1 / (((1440n) / (ceil(((1440n) - 5p) / (10u)))) * (ceil(((1440n) - 5p) / (10u))) * ((1440n) / (ceil(((1440n) - 5p) / (10u)))) * (ceil(((1440n) - 5p) / (10u))))           nrs=(((1440n) / (ceil(((1440n) - 5p) / (10u)))) < 119.5n) ? ((((50n > (((60n) - 0) + 60n) ? 50n : (((60n) - 0) + 60n)) * 120n) + (((1440n) / (ceil(((1440n) - 5p) / (10u)))) * 50n)) + (floor(((ceil(((1440n) - 5p) / (10u))) - 1) / 2.0) * (((((60n) - 0) + 60n) * 120n) + (((1440n) / (ceil(((1440n) - 5p) / (10u)))) * 100n))) + ((((ceil(((1440n) - 5p) / (10u))) / 2) - floor((ceil(((1440n) - 5p) / (10u))) / 2) == 0) ? (((50n > (((60n) - 0) + 60n) ? 50n : (((60n) - 0) + 60n)) * 120n) + (((1440n) / (ceil(((1440n) - 5p) / (10u)))) * 50n)) : 0)) / 1 : (((100n > (((60n) - 0) + 80n) ? 100n : (((60n) - 0) + 80n)) * ((1440n) / (ceil(((1440n) - 5p) / (10u))))) + (floor(((ceil(((1440n) - 5p) / (10u))) - 1) / 2.0) * ((60n > (((60n) - 0) + 50n) ? 60n : (((60n) - 0) + 50n)) * ((1440n) / (ceil(((1440n) - 5p) / (10u)))))) + ((((ceil(((1440n) - 5p) / (10u))) / 2) - floor((ceil(((1440n) - 5p) / (10u))) / 2) == 0) ? ((100n > (((60n) - 0) + 80n) ? 100n : (((60n) - 0) + 80n)) * ((1440n) / (ceil(((1440n) - 5p) / (10u))))) : 0)) / 1 / (((1440n) / (ceil(((1440n) - 5p) / (10u)))) * (ceil(((1440n) - 5p) / (10u))) * ((1440n) / (ceil(((1440n) - 5p) / (10u)))) * (ceil(((1440n) - 5p) / (10u))))           sa=(((1440n) / (ceil(((1440n) - 5p) / (10u)))) < 119.5n) ? (50n > (((60n) - 0) + 60n) ? 50n : (((60n) - 0) + 60n)) + 5e-08 : (100n > (((60n) - 0) + 80n) ? 100n : (((60n) - 0) + 80n))           sb=(((1440n) / (ceil(((1440n) - 5p) / (10u)))) < 119.5n) ? (50n > (((60n) - 0) + 60n) ? 50n : (((60n) - 0) + 60n)) + 5e-08 : (100n > (((60n) - 0) + 80n) ? 100n : (((60n) - 0) + 80n))           sd=(((1440n) / (ceil(((1440n) - 5p) / (10u)))) < 119.5n) ? (((60n) - 0) + 60n) + (2*5e-08) : (60n > (((60n) - 0) + 50n) ? 60n : (((60n) - 0) + 50n))           sca=(( ((1440n) / (ceil(((1440n) - 5p) / (10u)))) * ( (((1u) * (1u) / ((((1440n) / (ceil(((1440n) - 5p) / (10u)))) < 119.5n) ? (50n > (((60n) - 0) + 60n) ? 50n : (((60n) - 0) + 60n)) + 5e-08 : (100n > (((60n) - 0) + 80n) ? 100n : (((60n) - 0) + 80n))+60n)) - ((1u) * (1u) / (((((1440n) / (ceil(((1440n) - 5p) / (10u)))) < 119.5n) ? (50n > (((60n) - 0) + 60n) ? 50n : (((60n) - 0) + 60n)) + 5e-08 : (100n > (((60n) - 0) + 80n) ? 100n : (((60n) - 0) + 80n))+60n)+(45n)))) + ((1u) * (1u) / ((((1440n) / (ceil(((1440n) - 5p) / (10u)))) < 119.5n) ? (50n > (((60n) - 0) + 60n) ? 50n : (((60n) - 0) + 60n)) + 5e-08 : (100n > (((60n) - 0) + 80n) ? 100n : (((60n) - 0) + 80n))+60n)) - ((1u) * (1u)/ (((((1440n) / (ceil(((1440n) - 5p) / (10u)))) < 119.5n) ? (50n > (((60n) - 0) + 60n) ? 50n : (((60n) - 0) + 60n)) + 5e-08 : (100n > (((60n) - 0) + 80n) ? 100n : (((60n) - 0) + 80n))+60n)+(45n))))) + ( (45n) * ( (((1u) * (1u) / (60n)) - ((1u) * (1u) / ((60n)+((1440n) / (ceil(((1440n) - 5p) / (10u))))))) + ((1u) * (1u) / (60n)) - ((1u) * (1u)/ ((60n)+((1440n) / (ceil(((1440n) - 5p) / (10u))))))))) / (((1440n) / (ceil(((1440n) - 5p) / (10u)))) * (45n))           scb=((((1440n) / (ceil(((1440n) - 5p) / (10u)))) * ((((((1440n) / (ceil(((1440n) - 5p) / (10u)))) < 119.5n) ? (50n > (((60n) - 0) + 60n) ? 50n : (((60n) - 0) + 60n)) + 5e-08 : (100n > (((60n) - 0) + 80n) ? 100n : (((60n) - 0) + 80n))+60n)/10 + (1u)/100)*exp(-10 * ((((1440n) / (ceil(((1440n) - 5p) / (10u)))) < 119.5n) ? (50n > (((60n) - 0) + 60n) ? 50n : (((60n) - 0) + 60n)) + 5e-08 : (100n > (((60n) - 0) + 80n) ? 100n : (((60n) - 0) + 80n))+60n) / (1u)) - ((((((1440n) / (ceil(((1440n) - 5p) / (10u)))) < 119.5n) ? (50n > (((60n) - 0) + 60n) ? 50n : (((60n) - 0) + 60n)) + 5e-08 : (100n > (((60n) - 0) + 80n) ? 100n : (((60n) - 0) + 80n))+60n)+(45n))/10 + (1u)/100)*exp(-10 * (((((1440n) / (ceil(((1440n) - 5p) / (10u)))) < 119.5n) ? (50n > (((60n) - 0) + 60n) ? 50n : (((60n) - 0) + 60n)) + 5e-08 : (100n > (((60n) - 0) + 80n) ? 100n : (((60n) - 0) + 80n))+60n)+(45n)) / (1u)) + (((((1440n) / (ceil(((1440n) - 5p) / (10u)))) < 119.5n) ? (50n > (((60n) - 0) + 60n) ? 50n : (((60n) - 0) + 60n)) + 5e-08 : (100n > (((60n) - 0) + 80n) ? 100n : (((60n) - 0) + 80n))+60n)/10 + (1u)/100)*exp(-10 * ((((1440n) / (ceil(((1440n) - 5p) / (10u)))) < 119.5n) ? (50n > (((60n) - 0) + 60n) ? 50n : (((60n) - 0) + 60n)) + 5e-08 : (100n > (((60n) - 0) + 80n) ? 100n : (((60n) - 0) + 80n))+60n) / (1u)) - ((((((1440n) / (ceil(((1440n) - 5p) / (10u)))) < 119.5n) ? (50n > (((60n) - 0) + 60n) ? 50n : (((60n) - 0) + 60n)) + 5e-08 : (100n > (((60n) - 0) + 80n) ? 100n : (((60n) - 0) + 80n))+60n)+(45n))/10 + (1u)/100)*exp(-10 * (((((1440n) / (ceil(((1440n) - 5p) / (10u)))) < 119.5n) ? (50n > (((60n) - 0) + 60n) ? 50n : (((60n) - 0) + 60n)) + 5e-08 : (100n > (((60n) - 0) + 80n) ? 100n : (((60n) - 0) + 80n))+60n)+(45n)) / (1u)))) + ((45n) * (((60n)/10 + (1u)/100)*exp(-10 * (60n) / (1u)) - (((60n)+((1440n) / (ceil(((1440n) - 5p) / (10u)))))/10 + (1u)/100)*exp(-10 * ((60n)+((1440n) / (ceil(((1440n) - 5p) / (10u))))) / (1u)) + ((60n)/10 + (1u)/100)*exp(-10 * (60n) / (1u)) - (((60n)+((1440n) / (ceil(((1440n) - 5p) / (10u)))))/10 + (1u)/100)*exp(-10 * ((60n)+((1440n) / (ceil(((1440n) - 5p) / (10u))))) / (1u))))) / (((1440n) / (ceil(((1440n) - 5p) / (10u)))) * (45n))           scc=((((1440n) / (ceil(((1440n) - 5p) / (10u)))) * ((((((1440n) / (ceil(((1440n) - 5p) / (10u)))) < 119.5n) ? (50n > (((60n) - 0) + 60n) ? 50n : (((60n) - 0) + 60n)) + 5e-08 : (100n > (((60n) - 0) + 80n) ? 100n : (((60n) - 0) + 80n))+60n)/20 + (1u)/400)*exp(-20 * ((((1440n) / (ceil(((1440n) - 5p) / (10u)))) < 119.5n) ? (50n > (((60n) - 0) + 60n) ? 50n : (((60n) - 0) + 60n)) + 5e-08 : (100n > (((60n) - 0) + 80n) ? 100n : (((60n) - 0) + 80n))+60n) / (1u)) - ((((((1440n) / (ceil(((1440n) - 5p) / (10u)))) < 119.5n) ? (50n > (((60n) - 0) + 60n) ? 50n : (((60n) - 0) + 60n)) + 5e-08 : (100n > (((60n) - 0) + 80n) ? 100n : (((60n) - 0) + 80n))+60n)+(45n))/20 + (1u)/400)*exp(-20 * (((((1440n) / (ceil(((1440n) - 5p) / (10u)))) < 119.5n) ? (50n > (((60n) - 0) + 60n) ? 50n : (((60n) - 0) + 60n)) + 5e-08 : (100n > (((60n) - 0) + 80n) ? 100n : (((60n) - 0) + 80n))+60n)+(45n)) / (1u)) + (((((1440n) / (ceil(((1440n) - 5p) / (10u)))) < 119.5n) ? (50n > (((60n) - 0) + 60n) ? 50n : (((60n) - 0) + 60n)) + 5e-08 : (100n > (((60n) - 0) + 80n) ? 100n : (((60n) - 0) + 80n))+60n)/20 + (1u)/400)*exp(-20 * ((((1440n) / (ceil(((1440n) - 5p) / (10u)))) < 119.5n) ? (50n > (((60n) - 0) + 60n) ? 50n : (((60n) - 0) + 60n)) + 5e-08 : (100n > (((60n) - 0) + 80n) ? 100n : (((60n) - 0) + 80n))+60n) / (1u)) - ((((((1440n) / (ceil(((1440n) - 5p) / (10u)))) < 119.5n) ? (50n > (((60n) - 0) + 60n) ? 50n : (((60n) - 0) + 60n)) + 5e-08 : (100n > (((60n) - 0) + 80n) ? 100n : (((60n) - 0) + 80n))+60n)+(45n))/20 + (1u)/400)*exp(-20 * (((((1440n) / (ceil(((1440n) - 5p) / (10u)))) < 119.5n) ? (50n > (((60n) - 0) + 60n) ? 50n : (((60n) - 0) + 60n)) + 5e-08 : (100n > (((60n) - 0) + 80n) ? 100n : (((60n) - 0) + 80n))+60n)+(45n)) / (1u)))) + ((45n) * (((60n)/20 + (1u)/400)*exp(-20 * (60n) / (1u)) - (((60n)+((1440n) / (ceil(((1440n) - 5p) / (10u)))))/20 + (1u)/400)*exp(-20 * ((60n)+((1440n) / (ceil(((1440n) - 5p) / (10u))))) / (1u)) + ((60n)/20 + (1u)/400)*exp(-20 * (60n) / (1u)) - (((60n)+((1440n) / (ceil(((1440n) - 5p) / (10u)))))/20 + (1u)/400)*exp(-20 * ((60n)+((1440n) / (ceil(((1440n) - 5p) / (10u))))) / (1u))))) / (((1440n) / (ceil(((1440n) - 5p) / (10u)))) * (45n))           m=(1)
PM5 (ns nd VDD VDD) g45p1svt w=(1440n) l=45n nf=ceil(((1440n) - 5p) / (10u))           as=(((1440n) / (ceil(((1440n) - 5p) / (10u)))) < 119.5n) ? ((((50n > (((60n) - 0) + 60n) ? 50n : (((60n) - 0) + 60n)) * 120n) + (((1440n) / (ceil(((1440n) - 5p) / (10u)))) * 50n)) + (floor(((ceil(((1440n) - 5p) / (10u))) - 1) / 2.0) * (((((60n) - 0) + 60n) * 120n) + (((1440n) / (ceil(((1440n) - 5p) / (10u)))) * 100n))) + ((((ceil(((1440n) - 5p) / (10u))) / 2) - floor((ceil(((1440n) - 5p) / (10u))) / 2) == 0) ? (((50n > (((60n) - 0) + 60n) ? 50n : (((60n) - 0) + 60n)) * 120n) + (((1440n) / (ceil(((1440n) - 5p) / (10u)))) * 50n)) : 0)) / 1 : (((100n > (((60n) - 0) + 80n) ? 100n : (((60n) - 0) + 80n)) * ((1440n) / (ceil(((1440n) - 5p) / (10u))))) + (floor(((ceil(((1440n) - 5p) / (10u))) - 1) / 2.0) * ((60n > (((60n) - 0) + 50n) ? 60n : (((60n) - 0) + 50n)) * ((1440n) / (ceil(((1440n) - 5p) / (10u)))))) + ((((ceil(((1440n) - 5p) / (10u))) / 2) - floor((ceil(((1440n) - 5p) / (10u))) / 2) == 0) ? ((100n > (((60n) - 0) + 80n) ? 100n : (((60n) - 0) + 80n)) * ((1440n) / (ceil(((1440n) - 5p) / (10u))))) : 0)) / 1           ad=(((1440n) / (ceil(((1440n) - 5p) / (10u)))) < 119.5n) ? ((floor((ceil(((1440n) - 5p) / (10u))) / 2.0) * (((((60n) - 0) + 60n) * 120n) + (((1440n) / (ceil(((1440n) - 5p) / (10u)))) * 100n))) + ((((ceil(((1440n) - 5p) / (10u))) / 2) - floor((ceil(((1440n) - 5p) / (10u))) / 2) != 0) ? (((50n > (((60n) - 0) + 60n) ? 50n : (((60n) - 0) + 60n)) * 120n) + (((1440n) / (ceil(((1440n) - 5p) / (10u)))) * 50n)) : 0)) / 1 : ((floor((ceil(((1440n) - 5p) / (10u))) / 2.0) * ((60n > (((60n) - 0) + 50n) ? 60n : (((60n) - 0) + 50n)) * ((1440n) / (ceil(((1440n) - 5p) / (10u)))))) + ((((ceil(((1440n) - 5p) / (10u))) / 2) - floor((ceil(((1440n) - 5p) / (10u))) / 2) != 0) ? ((100n > (((60n) - 0) + 80n) ? 100n : (((60n) - 0) + 80n)) * ((1440n) / (ceil(((1440n) - 5p) / (10u))))) : 0)) / 1           ps=(((1440n) / (ceil(((1440n) - 5p) / (10u)))) < 119.5n) ? (((2 * (50n > (((60n) - 0) + 60n) ? 50n : (((60n) - 0) + 60n))) + 340n) + (floor(((ceil(((1440n) - 5p) / (10u))) - 1) / 2.0) * ((2 * (((60n) - 0) + 60n)) + 440n)) + ((((ceil(((1440n) - 5p) / (10u))) / 2) - floor((ceil(((1440n) - 5p) / (10u))) / 2) == 0) ? ((2 * (50n > (((60n) - 0) + 60n) ? 50n : (((60n) - 0) + 60n))) + 340n) : 0)) / 1 : (((2 * (100n > (((60n) - 0) + 80n) ? 100n : (((60n) - 0) + 80n))) + (2 * ((1440n) / (ceil(((1440n) - 5p) / (10u)))))) + (floor(((ceil(((1440n) - 5p) / (10u))) - 1) / 2.0) * ((2 * (60n > (((60n) - 0) + 50n) ? 60n : (((60n) - 0) + 50n))) + (2 * ((1440n) / (ceil(((1440n) - 5p) / (10u))))))) + ((((ceil(((1440n) - 5p) / (10u))) / 2) - floor((ceil(((1440n) - 5p) / (10u))) / 2) == 0) ? ((2 * (100n > (((60n) - 0) + 80n) ? 100n : (((60n) - 0) + 80n))) + (2 * ((1440n) / (ceil(((1440n) - 5p) / (10u)))))) : 0)) / 1           pd=(((1440n) / (ceil(((1440n) - 5p) / (10u)))) < 119.5n) ? ((floor((ceil(((1440n) - 5p) / (10u))) / 2.0) * ((2 * (((60n) - 0) + 60n)) + 440n)) + ((((ceil(((1440n) - 5p) / (10u))) / 2) - floor((ceil(((1440n) - 5p) / (10u))) / 2) != 0) ? ((2 * (50n > (((60n) - 0) + 60n) ? 50n : (((60n) - 0) + 60n))) + 340n) : 0)) / 1 : ((floor((ceil(((1440n) - 5p) / (10u))) / 2.0) * ((2 * (60n > (((60n) - 0) + 50n) ? 60n : (((60n) - 0) + 50n))) + (2 * ((1440n) / (ceil(((1440n) - 5p) / (10u))))))) + ((((ceil(((1440n) - 5p) / (10u))) / 2) - floor((ceil(((1440n) - 5p) / (10u))) / 2) != 0) ? ((2 * (100n > (((60n) - 0) + 80n) ? 100n : (((60n) - 0) + 80n))) + (2 * ((1440n) / (ceil(((1440n) - 5p) / (10u)))))) : 0)) / 1           nrd=(((1440n) / (ceil(((1440n) - 5p) / (10u)))) < 119.5n) ? ((floor((ceil(((1440n) - 5p) / (10u))) / 2.0) * (((((60n) - 0) + 60n) * 120n) + (((1440n) / (ceil(((1440n) - 5p) / (10u)))) * 100n))) + ((((ceil(((1440n) - 5p) / (10u))) / 2) - floor((ceil(((1440n) - 5p) / (10u))) / 2) != 0) ? (((50n > (((60n) - 0) + 60n) ? 50n : (((60n) - 0) + 60n)) * 120n) + (((1440n) / (ceil(((1440n) - 5p) / (10u)))) * 50n)) : 0)) / 1 : ((floor((ceil(((1440n) - 5p) / (10u))) / 2.0) * ((60n > (((60n) - 0) + 50n) ? 60n : (((60n) - 0) + 50n)) * ((1440n) / (ceil(((1440n) - 5p) / (10u)))))) + ((((ceil(((1440n) - 5p) / (10u))) / 2) - floor((ceil(((1440n) - 5p) / (10u))) / 2) != 0) ? ((100n > (((60n) - 0) + 80n) ? 100n : (((60n) - 0) + 80n)) * ((1440n) / (ceil(((1440n) - 5p) / (10u))))) : 0)) / 1 / (((1440n) / (ceil(((1440n) - 5p) / (10u)))) * (ceil(((1440n) - 5p) / (10u))) * ((1440n) / (ceil(((1440n) - 5p) / (10u)))) * (ceil(((1440n) - 5p) / (10u))))           nrs=(((1440n) / (ceil(((1440n) - 5p) / (10u)))) < 119.5n) ? ((((50n > (((60n) - 0) + 60n) ? 50n : (((60n) - 0) + 60n)) * 120n) + (((1440n) / (ceil(((1440n) - 5p) / (10u)))) * 50n)) + (floor(((ceil(((1440n) - 5p) / (10u))) - 1) / 2.0) * (((((60n) - 0) + 60n) * 120n) + (((1440n) / (ceil(((1440n) - 5p) / (10u)))) * 100n))) + ((((ceil(((1440n) - 5p) / (10u))) / 2) - floor((ceil(((1440n) - 5p) / (10u))) / 2) == 0) ? (((50n > (((60n) - 0) + 60n) ? 50n : (((60n) - 0) + 60n)) * 120n) + (((1440n) / (ceil(((1440n) - 5p) / (10u)))) * 50n)) : 0)) / 1 : (((100n > (((60n) - 0) + 80n) ? 100n : (((60n) - 0) + 80n)) * ((1440n) / (ceil(((1440n) - 5p) / (10u))))) + (floor(((ceil(((1440n) - 5p) / (10u))) - 1) / 2.0) * ((60n > (((60n) - 0) + 50n) ? 60n : (((60n) - 0) + 50n)) * ((1440n) / (ceil(((1440n) - 5p) / (10u)))))) + ((((ceil(((1440n) - 5p) / (10u))) / 2) - floor((ceil(((1440n) - 5p) / (10u))) / 2) == 0) ? ((100n > (((60n) - 0) + 80n) ? 100n : (((60n) - 0) + 80n)) * ((1440n) / (ceil(((1440n) - 5p) / (10u))))) : 0)) / 1 / (((1440n) / (ceil(((1440n) - 5p) / (10u)))) * (ceil(((1440n) - 5p) / (10u))) * ((1440n) / (ceil(((1440n) - 5p) / (10u)))) * (ceil(((1440n) - 5p) / (10u))))           sa=(((1440n) / (ceil(((1440n) - 5p) / (10u)))) < 119.5n) ? (50n > (((60n) - 0) + 60n) ? 50n : (((60n) - 0) + 60n)) + 5e-08 : (100n > (((60n) - 0) + 80n) ? 100n : (((60n) - 0) + 80n))           sb=(((1440n) / (ceil(((1440n) - 5p) / (10u)))) < 119.5n) ? (50n > (((60n) - 0) + 60n) ? 50n : (((60n) - 0) + 60n)) + 5e-08 : (100n > (((60n) - 0) + 80n) ? 100n : (((60n) - 0) + 80n))           sd=(((1440n) / (ceil(((1440n) - 5p) / (10u)))) < 119.5n) ? (((60n) - 0) + 60n) + (2*5e-08) : (60n > (((60n) - 0) + 50n) ? 60n : (((60n) - 0) + 50n))           sca=(( ((1440n) / (ceil(((1440n) - 5p) / (10u)))) * ( (((1u) * (1u) / ((((1440n) / (ceil(((1440n) - 5p) / (10u)))) < 119.5n) ? (50n > (((60n) - 0) + 60n) ? 50n : (((60n) - 0) + 60n)) + 5e-08 : (100n > (((60n) - 0) + 80n) ? 100n : (((60n) - 0) + 80n))+60n)) - ((1u) * (1u) / (((((1440n) / (ceil(((1440n) - 5p) / (10u)))) < 119.5n) ? (50n > (((60n) - 0) + 60n) ? 50n : (((60n) - 0) + 60n)) + 5e-08 : (100n > (((60n) - 0) + 80n) ? 100n : (((60n) - 0) + 80n))+60n)+(45n)))) + ((1u) * (1u) / ((((1440n) / (ceil(((1440n) - 5p) / (10u)))) < 119.5n) ? (50n > (((60n) - 0) + 60n) ? 50n : (((60n) - 0) + 60n)) + 5e-08 : (100n > (((60n) - 0) + 80n) ? 100n : (((60n) - 0) + 80n))+60n)) - ((1u) * (1u)/ (((((1440n) / (ceil(((1440n) - 5p) / (10u)))) < 119.5n) ? (50n > (((60n) - 0) + 60n) ? 50n : (((60n) - 0) + 60n)) + 5e-08 : (100n > (((60n) - 0) + 80n) ? 100n : (((60n) - 0) + 80n))+60n)+(45n))))) + ( (45n) * ( (((1u) * (1u) / (60n)) - ((1u) * (1u) / ((60n)+((1440n) / (ceil(((1440n) - 5p) / (10u))))))) + ((1u) * (1u) / (60n)) - ((1u) * (1u)/ ((60n)+((1440n) / (ceil(((1440n) - 5p) / (10u))))))))) / (((1440n) / (ceil(((1440n) - 5p) / (10u)))) * (45n))           scb=((((1440n) / (ceil(((1440n) - 5p) / (10u)))) * ((((((1440n) / (ceil(((1440n) - 5p) / (10u)))) < 119.5n) ? (50n > (((60n) - 0) + 60n) ? 50n : (((60n) - 0) + 60n)) + 5e-08 : (100n > (((60n) - 0) + 80n) ? 100n : (((60n) - 0) + 80n))+60n)/10 + (1u)/100)*exp(-10 * ((((1440n) / (ceil(((1440n) - 5p) / (10u)))) < 119.5n) ? (50n > (((60n) - 0) + 60n) ? 50n : (((60n) - 0) + 60n)) + 5e-08 : (100n > (((60n) - 0) + 80n) ? 100n : (((60n) - 0) + 80n))+60n) / (1u)) - ((((((1440n) / (ceil(((1440n) - 5p) / (10u)))) < 119.5n) ? (50n > (((60n) - 0) + 60n) ? 50n : (((60n) - 0) + 60n)) + 5e-08 : (100n > (((60n) - 0) + 80n) ? 100n : (((60n) - 0) + 80n))+60n)+(45n))/10 + (1u)/100)*exp(-10 * (((((1440n) / (ceil(((1440n) - 5p) / (10u)))) < 119.5n) ? (50n > (((60n) - 0) + 60n) ? 50n : (((60n) - 0) + 60n)) + 5e-08 : (100n > (((60n) - 0) + 80n) ? 100n : (((60n) - 0) + 80n))+60n)+(45n)) / (1u)) + (((((1440n) / (ceil(((1440n) - 5p) / (10u)))) < 119.5n) ? (50n > (((60n) - 0) + 60n) ? 50n : (((60n) - 0) + 60n)) + 5e-08 : (100n > (((60n) - 0) + 80n) ? 100n : (((60n) - 0) + 80n))+60n)/10 + (1u)/100)*exp(-10 * ((((1440n) / (ceil(((1440n) - 5p) / (10u)))) < 119.5n) ? (50n > (((60n) - 0) + 60n) ? 50n : (((60n) - 0) + 60n)) + 5e-08 : (100n > (((60n) - 0) + 80n) ? 100n : (((60n) - 0) + 80n))+60n) / (1u)) - ((((((1440n) / (ceil(((1440n) - 5p) / (10u)))) < 119.5n) ? (50n > (((60n) - 0) + 60n) ? 50n : (((60n) - 0) + 60n)) + 5e-08 : (100n > (((60n) - 0) + 80n) ? 100n : (((60n) - 0) + 80n))+60n)+(45n))/10 + (1u)/100)*exp(-10 * (((((1440n) / (ceil(((1440n) - 5p) / (10u)))) < 119.5n) ? (50n > (((60n) - 0) + 60n) ? 50n : (((60n) - 0) + 60n)) + 5e-08 : (100n > (((60n) - 0) + 80n) ? 100n : (((60n) - 0) + 80n))+60n)+(45n)) / (1u)))) + ((45n) * (((60n)/10 + (1u)/100)*exp(-10 * (60n) / (1u)) - (((60n)+((1440n) / (ceil(((1440n) - 5p) / (10u)))))/10 + (1u)/100)*exp(-10 * ((60n)+((1440n) / (ceil(((1440n) - 5p) / (10u))))) / (1u)) + ((60n)/10 + (1u)/100)*exp(-10 * (60n) / (1u)) - (((60n)+((1440n) / (ceil(((1440n) - 5p) / (10u)))))/10 + (1u)/100)*exp(-10 * ((60n)+((1440n) / (ceil(((1440n) - 5p) / (10u))))) / (1u))))) / (((1440n) / (ceil(((1440n) - 5p) / (10u)))) * (45n))           scc=((((1440n) / (ceil(((1440n) - 5p) / (10u)))) * ((((((1440n) / (ceil(((1440n) - 5p) / (10u)))) < 119.5n) ? (50n > (((60n) - 0) + 60n) ? 50n : (((60n) - 0) + 60n)) + 5e-08 : (100n > (((60n) - 0) + 80n) ? 100n : (((60n) - 0) + 80n))+60n)/20 + (1u)/400)*exp(-20 * ((((1440n) / (ceil(((1440n) - 5p) / (10u)))) < 119.5n) ? (50n > (((60n) - 0) + 60n) ? 50n : (((60n) - 0) + 60n)) + 5e-08 : (100n > (((60n) - 0) + 80n) ? 100n : (((60n) - 0) + 80n))+60n) / (1u)) - ((((((1440n) / (ceil(((1440n) - 5p) / (10u)))) < 119.5n) ? (50n > (((60n) - 0) + 60n) ? 50n : (((60n) - 0) + 60n)) + 5e-08 : (100n > (((60n) - 0) + 80n) ? 100n : (((60n) - 0) + 80n))+60n)+(45n))/20 + (1u)/400)*exp(-20 * (((((1440n) / (ceil(((1440n) - 5p) / (10u)))) < 119.5n) ? (50n > (((60n) - 0) + 60n) ? 50n : (((60n) - 0) + 60n)) + 5e-08 : (100n > (((60n) - 0) + 80n) ? 100n : (((60n) - 0) + 80n))+60n)+(45n)) / (1u)) + (((((1440n) / (ceil(((1440n) - 5p) / (10u)))) < 119.5n) ? (50n > (((60n) - 0) + 60n) ? 50n : (((60n) - 0) + 60n)) + 5e-08 : (100n > (((60n) - 0) + 80n) ? 100n : (((60n) - 0) + 80n))+60n)/20 + (1u)/400)*exp(-20 * ((((1440n) / (ceil(((1440n) - 5p) / (10u)))) < 119.5n) ? (50n > (((60n) - 0) + 60n) ? 50n : (((60n) - 0) + 60n)) + 5e-08 : (100n > (((60n) - 0) + 80n) ? 100n : (((60n) - 0) + 80n))+60n) / (1u)) - ((((((1440n) / (ceil(((1440n) - 5p) / (10u)))) < 119.5n) ? (50n > (((60n) - 0) + 60n) ? 50n : (((60n) - 0) + 60n)) + 5e-08 : (100n > (((60n) - 0) + 80n) ? 100n : (((60n) - 0) + 80n))+60n)+(45n))/20 + (1u)/400)*exp(-20 * (((((1440n) / (ceil(((1440n) - 5p) / (10u)))) < 119.5n) ? (50n > (((60n) - 0) + 60n) ? 50n : (((60n) - 0) + 60n)) + 5e-08 : (100n > (((60n) - 0) + 80n) ? 100n : (((60n) - 0) + 80n))+60n)+(45n)) / (1u)))) + ((45n) * (((60n)/20 + (1u)/400)*exp(-20 * (60n) / (1u)) - (((60n)+((1440n) / (ceil(((1440n) - 5p) / (10u)))))/20 + (1u)/400)*exp(-20 * ((60n)+((1440n) / (ceil(((1440n) - 5p) / (10u))))) / (1u)) + ((60n)/20 + (1u)/400)*exp(-20 * (60n) / (1u)) - (((60n)+((1440n) / (ceil(((1440n) - 5p) / (10u)))))/20 + (1u)/400)*exp(-20 * ((60n)+((1440n) / (ceil(((1440n) - 5p) / (10u))))) / (1u))))) / (((1440n) / (ceil(((1440n) - 5p) / (10u)))) * (45n))           m=(1)
PM7 (AMP_OUT ns VDD VDD) g45p1svt w=(360n) l=45n nf=ceil(((360n) - 5p) / (10u))           as=(((360n) / (ceil(((360n) - 5p) / (10u)))) < 119.5n) ? ((((50n > (((60n) - 0) + 60n) ? 50n : (((60n) - 0) + 60n)) * 120n) + (((360n) / (ceil(((360n) - 5p) / (10u)))) * 50n)) + (floor(((ceil(((360n) - 5p) / (10u))) - 1) / 2.0) * (((((60n) - 0) + 60n) * 120n) + (((360n) / (ceil(((360n) - 5p) / (10u)))) * 100n))) + ((((ceil(((360n) - 5p) / (10u))) / 2) - floor((ceil(((360n) - 5p) / (10u))) / 2) == 0) ? (((50n > (((60n) - 0) + 60n) ? 50n : (((60n) - 0) + 60n)) * 120n) + (((360n) / (ceil(((360n) - 5p) / (10u)))) * 50n)) : 0)) / 1 : (((100n > (((60n) - 0) + 80n) ? 100n : (((60n) - 0) + 80n)) * ((360n) / (ceil(((360n) - 5p) / (10u))))) + (floor(((ceil(((360n) - 5p) / (10u))) - 1) / 2.0) * ((60n > (((60n) - 0) + 50n) ? 60n : (((60n) - 0) + 50n)) * ((360n) / (ceil(((360n) - 5p) / (10u)))))) + ((((ceil(((360n) - 5p) / (10u))) / 2) - floor((ceil(((360n) - 5p) / (10u))) / 2) == 0) ? ((100n > (((60n) - 0) + 80n) ? 100n : (((60n) - 0) + 80n)) * ((360n) / (ceil(((360n) - 5p) / (10u))))) : 0)) / 1           ad=(((360n) / (ceil(((360n) - 5p) / (10u)))) < 119.5n) ? ((floor((ceil(((360n) - 5p) / (10u))) / 2.0) * (((((60n) - 0) + 60n) * 120n) + (((360n) / (ceil(((360n) - 5p) / (10u)))) * 100n))) + ((((ceil(((360n) - 5p) / (10u))) / 2) - floor((ceil(((360n) - 5p) / (10u))) / 2) != 0) ? (((50n > (((60n) - 0) + 60n) ? 50n : (((60n) - 0) + 60n)) * 120n) + (((360n) / (ceil(((360n) - 5p) / (10u)))) * 50n)) : 0)) / 1 : ((floor((ceil(((360n) - 5p) / (10u))) / 2.0) * ((60n > (((60n) - 0) + 50n) ? 60n : (((60n) - 0) + 50n)) * ((360n) / (ceil(((360n) - 5p) / (10u)))))) + ((((ceil(((360n) - 5p) / (10u))) / 2) - floor((ceil(((360n) - 5p) / (10u))) / 2) != 0) ? ((100n > (((60n) - 0) + 80n) ? 100n : (((60n) - 0) + 80n)) * ((360n) / (ceil(((360n) - 5p) / (10u))))) : 0)) / 1           ps=(((360n) / (ceil(((360n) - 5p) / (10u)))) < 119.5n) ? (((2 * (50n > (((60n) - 0) + 60n) ? 50n : (((60n) - 0) + 60n))) + 340n) + (floor(((ceil(((360n) - 5p) / (10u))) - 1) / 2.0) * ((2 * (((60n) - 0) + 60n)) + 440n)) + ((((ceil(((360n) - 5p) / (10u))) / 2) - floor((ceil(((360n) - 5p) / (10u))) / 2) == 0) ? ((2 * (50n > (((60n) - 0) + 60n) ? 50n : (((60n) - 0) + 60n))) + 340n) : 0)) / 1 : (((2 * (100n > (((60n) - 0) + 80n) ? 100n : (((60n) - 0) + 80n))) + (2 * ((360n) / (ceil(((360n) - 5p) / (10u)))))) + (floor(((ceil(((360n) - 5p) / (10u))) - 1) / 2.0) * ((2 * (60n > (((60n) - 0) + 50n) ? 60n : (((60n) - 0) + 50n))) + (2 * ((360n) / (ceil(((360n) - 5p) / (10u))))))) + ((((ceil(((360n) - 5p) / (10u))) / 2) - floor((ceil(((360n) - 5p) / (10u))) / 2) == 0) ? ((2 * (100n > (((60n) - 0) + 80n) ? 100n : (((60n) - 0) + 80n))) + (2 * ((360n) / (ceil(((360n) - 5p) / (10u)))))) : 0)) / 1           pd=(((360n) / (ceil(((360n) - 5p) / (10u)))) < 119.5n) ? ((floor((ceil(((360n) - 5p) / (10u))) / 2.0) * ((2 * (((60n) - 0) + 60n)) + 440n)) + ((((ceil(((360n) - 5p) / (10u))) / 2) - floor((ceil(((360n) - 5p) / (10u))) / 2) != 0) ? ((2 * (50n > (((60n) - 0) + 60n) ? 50n : (((60n) - 0) + 60n))) + 340n) : 0)) / 1 : ((floor((ceil(((360n) - 5p) / (10u))) / 2.0) * ((2 * (60n > (((60n) - 0) + 50n) ? 60n : (((60n) - 0) + 50n))) + (2 * ((360n) / (ceil(((360n) - 5p) / (10u))))))) + ((((ceil(((360n) - 5p) / (10u))) / 2) - floor((ceil(((360n) - 5p) / (10u))) / 2) != 0) ? ((2 * (100n > (((60n) - 0) + 80n) ? 100n : (((60n) - 0) + 80n))) + (2 * ((360n) / (ceil(((360n) - 5p) / (10u)))))) : 0)) / 1           nrd=(((360n) / (ceil(((360n) - 5p) / (10u)))) < 119.5n) ? ((floor((ceil(((360n) - 5p) / (10u))) / 2.0) * (((((60n) - 0) + 60n) * 120n) + (((360n) / (ceil(((360n) - 5p) / (10u)))) * 100n))) + ((((ceil(((360n) - 5p) / (10u))) / 2) - floor((ceil(((360n) - 5p) / (10u))) / 2) != 0) ? (((50n > (((60n) - 0) + 60n) ? 50n : (((60n) - 0) + 60n)) * 120n) + (((360n) / (ceil(((360n) - 5p) / (10u)))) * 50n)) : 0)) / 1 : ((floor((ceil(((360n) - 5p) / (10u))) / 2.0) * ((60n > (((60n) - 0) + 50n) ? 60n : (((60n) - 0) + 50n)) * ((360n) / (ceil(((360n) - 5p) / (10u)))))) + ((((ceil(((360n) - 5p) / (10u))) / 2) - floor((ceil(((360n) - 5p) / (10u))) / 2) != 0) ? ((100n > (((60n) - 0) + 80n) ? 100n : (((60n) - 0) + 80n)) * ((360n) / (ceil(((360n) - 5p) / (10u))))) : 0)) / 1 / (((360n) / (ceil(((360n) - 5p) / (10u)))) * (ceil(((360n) - 5p) / (10u))) * ((360n) / (ceil(((360n) - 5p) / (10u)))) * (ceil(((360n) - 5p) / (10u))))           nrs=(((360n) / (ceil(((360n) - 5p) / (10u)))) < 119.5n) ? ((((50n > (((60n) - 0) + 60n) ? 50n : (((60n) - 0) + 60n)) * 120n) + (((360n) / (ceil(((360n) - 5p) / (10u)))) * 50n)) + (floor(((ceil(((360n) - 5p) / (10u))) - 1) / 2.0) * (((((60n) - 0) + 60n) * 120n) + (((360n) / (ceil(((360n) - 5p) / (10u)))) * 100n))) + ((((ceil(((360n) - 5p) / (10u))) / 2) - floor((ceil(((360n) - 5p) / (10u))) / 2) == 0) ? (((50n > (((60n) - 0) + 60n) ? 50n : (((60n) - 0) + 60n)) * 120n) + (((360n) / (ceil(((360n) - 5p) / (10u)))) * 50n)) : 0)) / 1 : (((100n > (((60n) - 0) + 80n) ? 100n : (((60n) - 0) + 80n)) * ((360n) / (ceil(((360n) - 5p) / (10u))))) + (floor(((ceil(((360n) - 5p) / (10u))) - 1) / 2.0) * ((60n > (((60n) - 0) + 50n) ? 60n : (((60n) - 0) + 50n)) * ((360n) / (ceil(((360n) - 5p) / (10u)))))) + ((((ceil(((360n) - 5p) / (10u))) / 2) - floor((ceil(((360n) - 5p) / (10u))) / 2) == 0) ? ((100n > (((60n) - 0) + 80n) ? 100n : (((60n) - 0) + 80n)) * ((360n) / (ceil(((360n) - 5p) / (10u))))) : 0)) / 1 / (((360n) / (ceil(((360n) - 5p) / (10u)))) * (ceil(((360n) - 5p) / (10u))) * ((360n) / (ceil(((360n) - 5p) / (10u)))) * (ceil(((360n) - 5p) / (10u))))           sa=(((360n) / (ceil(((360n) - 5p) / (10u)))) < 119.5n) ? (50n > (((60n) - 0) + 60n) ? 50n : (((60n) - 0) + 60n)) + 5e-08 : (100n > (((60n) - 0) + 80n) ? 100n : (((60n) - 0) + 80n))           sb=(((360n) / (ceil(((360n) - 5p) / (10u)))) < 119.5n) ? (50n > (((60n) - 0) + 60n) ? 50n : (((60n) - 0) + 60n)) + 5e-08 : (100n > (((60n) - 0) + 80n) ? 100n : (((60n) - 0) + 80n))           sd=(((360n) / (ceil(((360n) - 5p) / (10u)))) < 119.5n) ? (((60n) - 0) + 60n) + (2*5e-08) : (60n > (((60n) - 0) + 50n) ? 60n : (((60n) - 0) + 50n))           sca=(( ((360n) / (ceil(((360n) - 5p) / (10u)))) * ( (((1u) * (1u) / ((((360n) / (ceil(((360n) - 5p) / (10u)))) < 119.5n) ? (50n > (((60n) - 0) + 60n) ? 50n : (((60n) - 0) + 60n)) + 5e-08 : (100n > (((60n) - 0) + 80n) ? 100n : (((60n) - 0) + 80n))+60n)) - ((1u) * (1u) / (((((360n) / (ceil(((360n) - 5p) / (10u)))) < 119.5n) ? (50n > (((60n) - 0) + 60n) ? 50n : (((60n) - 0) + 60n)) + 5e-08 : (100n > (((60n) - 0) + 80n) ? 100n : (((60n) - 0) + 80n))+60n)+(45n)))) + ((1u) * (1u) / ((((360n) / (ceil(((360n) - 5p) / (10u)))) < 119.5n) ? (50n > (((60n) - 0) + 60n) ? 50n : (((60n) - 0) + 60n)) + 5e-08 : (100n > (((60n) - 0) + 80n) ? 100n : (((60n) - 0) + 80n))+60n)) - ((1u) * (1u)/ (((((360n) / (ceil(((360n) - 5p) / (10u)))) < 119.5n) ? (50n > (((60n) - 0) + 60n) ? 50n : (((60n) - 0) + 60n)) + 5e-08 : (100n > (((60n) - 0) + 80n) ? 100n : (((60n) - 0) + 80n))+60n)+(45n))))) + ( (45n) * ( (((1u) * (1u) / (60n)) - ((1u) * (1u) / ((60n)+((360n) / (ceil(((360n) - 5p) / (10u))))))) + ((1u) * (1u) / (60n)) - ((1u) * (1u)/ ((60n)+((360n) / (ceil(((360n) - 5p) / (10u))))))))) / (((360n) / (ceil(((360n) - 5p) / (10u)))) * (45n))           scb=((((360n) / (ceil(((360n) - 5p) / (10u)))) * ((((((360n) / (ceil(((360n) - 5p) / (10u)))) < 119.5n) ? (50n > (((60n) - 0) + 60n) ? 50n : (((60n) - 0) + 60n)) + 5e-08 : (100n > (((60n) - 0) + 80n) ? 100n : (((60n) - 0) + 80n))+60n)/10 + (1u)/100)*exp(-10 * ((((360n) / (ceil(((360n) - 5p) / (10u)))) < 119.5n) ? (50n > (((60n) - 0) + 60n) ? 50n : (((60n) - 0) + 60n)) + 5e-08 : (100n > (((60n) - 0) + 80n) ? 100n : (((60n) - 0) + 80n))+60n) / (1u)) - ((((((360n) / (ceil(((360n) - 5p) / (10u)))) < 119.5n) ? (50n > (((60n) - 0) + 60n) ? 50n : (((60n) - 0) + 60n)) + 5e-08 : (100n > (((60n) - 0) + 80n) ? 100n : (((60n) - 0) + 80n))+60n)+(45n))/10 + (1u)/100)*exp(-10 * (((((360n) / (ceil(((360n) - 5p) / (10u)))) < 119.5n) ? (50n > (((60n) - 0) + 60n) ? 50n : (((60n) - 0) + 60n)) + 5e-08 : (100n > (((60n) - 0) + 80n) ? 100n : (((60n) - 0) + 80n))+60n)+(45n)) / (1u)) + (((((360n) / (ceil(((360n) - 5p) / (10u)))) < 119.5n) ? (50n > (((60n) - 0) + 60n) ? 50n : (((60n) - 0) + 60n)) + 5e-08 : (100n > (((60n) - 0) + 80n) ? 100n : (((60n) - 0) + 80n))+60n)/10 + (1u)/100)*exp(-10 * ((((360n) / (ceil(((360n) - 5p) / (10u)))) < 119.5n) ? (50n > (((60n) - 0) + 60n) ? 50n : (((60n) - 0) + 60n)) + 5e-08 : (100n > (((60n) - 0) + 80n) ? 100n : (((60n) - 0) + 80n))+60n) / (1u)) - ((((((360n) / (ceil(((360n) - 5p) / (10u)))) < 119.5n) ? (50n > (((60n) - 0) + 60n) ? 50n : (((60n) - 0) + 60n)) + 5e-08 : (100n > (((60n) - 0) + 80n) ? 100n : (((60n) - 0) + 80n))+60n)+(45n))/10 + (1u)/100)*exp(-10 * (((((360n) / (ceil(((360n) - 5p) / (10u)))) < 119.5n) ? (50n > (((60n) - 0) + 60n) ? 50n : (((60n) - 0) + 60n)) + 5e-08 : (100n > (((60n) - 0) + 80n) ? 100n : (((60n) - 0) + 80n))+60n)+(45n)) / (1u)))) + ((45n) * (((60n)/10 + (1u)/100)*exp(-10 * (60n) / (1u)) - (((60n)+((360n) / (ceil(((360n) - 5p) / (10u)))))/10 + (1u)/100)*exp(-10 * ((60n)+((360n) / (ceil(((360n) - 5p) / (10u))))) / (1u)) + ((60n)/10 + (1u)/100)*exp(-10 * (60n) / (1u)) - (((60n)+((360n) / (ceil(((360n) - 5p) / (10u)))))/10 + (1u)/100)*exp(-10 * ((60n)+((360n) / (ceil(((360n) - 5p) / (10u))))) / (1u))))) / (((360n) / (ceil(((360n) - 5p) / (10u)))) * (45n))           scc=((((360n) / (ceil(((360n) - 5p) / (10u)))) * ((((((360n) / (ceil(((360n) - 5p) / (10u)))) < 119.5n) ? (50n > (((60n) - 0) + 60n) ? 50n : (((60n) - 0) + 60n)) + 5e-08 : (100n > (((60n) - 0) + 80n) ? 100n : (((60n) - 0) + 80n))+60n)/20 + (1u)/400)*exp(-20 * ((((360n) / (ceil(((360n) - 5p) / (10u)))) < 119.5n) ? (50n > (((60n) - 0) + 60n) ? 50n : (((60n) - 0) + 60n)) + 5e-08 : (100n > (((60n) - 0) + 80n) ? 100n : (((60n) - 0) + 80n))+60n) / (1u)) - ((((((360n) / (ceil(((360n) - 5p) / (10u)))) < 119.5n) ? (50n > (((60n) - 0) + 60n) ? 50n : (((60n) - 0) + 60n)) + 5e-08 : (100n > (((60n) - 0) + 80n) ? 100n : (((60n) - 0) + 80n))+60n)+(45n))/20 + (1u)/400)*exp(-20 * (((((360n) / (ceil(((360n) - 5p) / (10u)))) < 119.5n) ? (50n > (((60n) - 0) + 60n) ? 50n : (((60n) - 0) + 60n)) + 5e-08 : (100n > (((60n) - 0) + 80n) ? 100n : (((60n) - 0) + 80n))+60n)+(45n)) / (1u)) + (((((360n) / (ceil(((360n) - 5p) / (10u)))) < 119.5n) ? (50n > (((60n) - 0) + 60n) ? 50n : (((60n) - 0) + 60n)) + 5e-08 : (100n > (((60n) - 0) + 80n) ? 100n : (((60n) - 0) + 80n))+60n)/20 + (1u)/400)*exp(-20 * ((((360n) / (ceil(((360n) - 5p) / (10u)))) < 119.5n) ? (50n > (((60n) - 0) + 60n) ? 50n : (((60n) - 0) + 60n)) + 5e-08 : (100n > (((60n) - 0) + 80n) ? 100n : (((60n) - 0) + 80n))+60n) / (1u)) - ((((((360n) / (ceil(((360n) - 5p) / (10u)))) < 119.5n) ? (50n > (((60n) - 0) + 60n) ? 50n : (((60n) - 0) + 60n)) + 5e-08 : (100n > (((60n) - 0) + 80n) ? 100n : (((60n) - 0) + 80n))+60n)+(45n))/20 + (1u)/400)*exp(-20 * (((((360n) / (ceil(((360n) - 5p) / (10u)))) < 119.5n) ? (50n > (((60n) - 0) + 60n) ? 50n : (((60n) - 0) + 60n)) + 5e-08 : (100n > (((60n) - 0) + 80n) ? 100n : (((60n) - 0) + 80n))+60n)+(45n)) / (1u)))) + ((45n) * (((60n)/20 + (1u)/400)*exp(-20 * (60n) / (1u)) - (((60n)+((360n) / (ceil(((360n) - 5p) / (10u)))))/20 + (1u)/400)*exp(-20 * ((60n)+((360n) / (ceil(((360n) - 5p) / (10u))))) / (1u)) + ((60n)/20 + (1u)/400)*exp(-20 * (60n) / (1u)) - (((60n)+((360n) / (ceil(((360n) - 5p) / (10u)))))/20 + (1u)/400)*exp(-20 * ((60n)+((360n) / (ceil(((360n) - 5p) / (10u))))) / (1u))))) / (((360n) / (ceil(((360n) - 5p) / (10u)))) * (45n))           m=(1)
NM41 (ns BIT tail GND) g45n1svt w=(240n) l=45n nf=ceil(((240n) - 5p) / (10u))           as=(((240n) / (ceil(((240n) - 5p) / (10u)))) < 119.5n) ? ((((50n > (((60n) - 0) + 60n) ? 50n : (((60n) - 0) + 60n)) * 120n) + (((240n) / (ceil(((240n) - 5p) / (10u)))) * 50n)) + (floor(((ceil(((240n) - 5p) / (10u))) - 1) / 2.0) * (((((60n) - 0) + 60n) * 120n) + (((240n) / (ceil(((240n) - 5p) / (10u)))) * 100n))) + ((((ceil(((240n) - 5p) / (10u))) / 2) - floor((ceil(((240n) - 5p) / (10u))) / 2) == 0) ? (((50n > (((60n) - 0) + 60n) ? 50n : (((60n) - 0) + 60n)) * 120n) + (((240n) / (ceil(((240n) - 5p) / (10u)))) * 50n)) : 0)) / 1 : (((100n > (((60n) - 0) + 80n) ? 100n : (((60n) - 0) + 80n)) * ((240n) / (ceil(((240n) - 5p) / (10u))))) + (floor(((ceil(((240n) - 5p) / (10u))) - 1) / 2.0) * ((60n > (((60n) - 0) + 50n) ? 60n : (((60n) - 0) + 50n)) * ((240n) / (ceil(((240n) - 5p) / (10u)))))) + ((((ceil(((240n) - 5p) / (10u))) / 2) - floor((ceil(((240n) - 5p) / (10u))) / 2) == 0) ? ((100n > (((60n) - 0) + 80n) ? 100n : (((60n) - 0) + 80n)) * ((240n) / (ceil(((240n) - 5p) / (10u))))) : 0)) / 1           ad=(((240n) / (ceil(((240n) - 5p) / (10u)))) < 119.5n) ? ((floor((ceil(((240n) - 5p) / (10u))) / 2.0) * (((((60n) - 0) + 60n) * 120n) + (((240n) / (ceil(((240n) - 5p) / (10u)))) * 100n))) + ((((ceil(((240n) - 5p) / (10u))) / 2) - floor((ceil(((240n) - 5p) / (10u))) / 2) != 0) ? (((50n > (((60n) - 0) + 60n) ? 50n : (((60n) - 0) + 60n)) * 120n) + (((240n) / (ceil(((240n) - 5p) / (10u)))) * 50n)) : 0)) / 1 : ((floor((ceil(((240n) - 5p) / (10u))) / 2.0) * ((60n > (((60n) - 0) + 50n) ? 60n : (((60n) - 0) + 50n)) * ((240n) / (ceil(((240n) - 5p) / (10u)))))) + ((((ceil(((240n) - 5p) / (10u))) / 2) - floor((ceil(((240n) - 5p) / (10u))) / 2) != 0) ? ((100n > (((60n) - 0) + 80n) ? 100n : (((60n) - 0) + 80n)) * ((240n) / (ceil(((240n) - 5p) / (10u))))) : 0)) / 1           ps=(((240n) / (ceil(((240n) - 5p) / (10u)))) < 119.5n) ? (((2 * (50n > (((60n) - 0) + 60n) ? 50n : (((60n) - 0) + 60n))) + 340n) + (floor(((ceil(((240n) - 5p) / (10u))) - 1) / 2.0) * ((2 * (((60n) - 0) + 60n)) + 440n)) + ((((ceil(((240n) - 5p) / (10u))) / 2) - floor((ceil(((240n) - 5p) / (10u))) / 2) == 0) ? ((2 * (50n > (((60n) - 0) + 60n) ? 50n : (((60n) - 0) + 60n))) + 340n) : 0)) / 1 : (((2 * (100n > (((60n) - 0) + 80n) ? 100n : (((60n) - 0) + 80n))) + (2 * ((240n) / (ceil(((240n) - 5p) / (10u)))))) + (floor(((ceil(((240n) - 5p) / (10u))) - 1) / 2.0) * ((2 * (60n > (((60n) - 0) + 50n) ? 60n : (((60n) - 0) + 50n))) + (2 * ((240n) / (ceil(((240n) - 5p) / (10u))))))) + ((((ceil(((240n) - 5p) / (10u))) / 2) - floor((ceil(((240n) - 5p) / (10u))) / 2) == 0) ? ((2 * (100n > (((60n) - 0) + 80n) ? 100n : (((60n) - 0) + 80n))) + (2 * ((240n) / (ceil(((240n) - 5p) / (10u)))))) : 0)) / 1           pd=(((240n) / (ceil(((240n) - 5p) / (10u)))) < 119.5n) ? ((floor((ceil(((240n) - 5p) / (10u))) / 2.0) * ((2 * (((60n) - 0) + 60n)) + 440n)) + ((((ceil(((240n) - 5p) / (10u))) / 2) - floor((ceil(((240n) - 5p) / (10u))) / 2) != 0) ? ((2 * (50n > (((60n) - 0) + 60n) ? 50n : (((60n) - 0) + 60n))) + 340n) : 0)) / 1 : ((floor((ceil(((240n) - 5p) / (10u))) / 2.0) * ((2 * (60n > (((60n) - 0) + 50n) ? 60n : (((60n) - 0) + 50n))) + (2 * ((240n) / (ceil(((240n) - 5p) / (10u))))))) + ((((ceil(((240n) - 5p) / (10u))) / 2) - floor((ceil(((240n) - 5p) / (10u))) / 2) != 0) ? ((2 * (100n > (((60n) - 0) + 80n) ? 100n : (((60n) - 0) + 80n))) + (2 * ((240n) / (ceil(((240n) - 5p) / (10u)))))) : 0)) / 1           nrd=(((240n) / (ceil(((240n) - 5p) / (10u)))) < 119.5n) ? ((floor((ceil(((240n) - 5p) / (10u))) / 2.0) * (((((60n) - 0) + 60n) * 120n) + (((240n) / (ceil(((240n) - 5p) / (10u)))) * 100n))) + ((((ceil(((240n) - 5p) / (10u))) / 2) - floor((ceil(((240n) - 5p) / (10u))) / 2) != 0) ? (((50n > (((60n) - 0) + 60n) ? 50n : (((60n) - 0) + 60n)) * 120n) + (((240n) / (ceil(((240n) - 5p) / (10u)))) * 50n)) : 0)) / 1 : ((floor((ceil(((240n) - 5p) / (10u))) / 2.0) * ((60n > (((60n) - 0) + 50n) ? 60n : (((60n) - 0) + 50n)) * ((240n) / (ceil(((240n) - 5p) / (10u)))))) + ((((ceil(((240n) - 5p) / (10u))) / 2) - floor((ceil(((240n) - 5p) / (10u))) / 2) != 0) ? ((100n > (((60n) - 0) + 80n) ? 100n : (((60n) - 0) + 80n)) * ((240n) / (ceil(((240n) - 5p) / (10u))))) : 0)) / 1 / (((240n) / (ceil(((240n) - 5p) / (10u)))) * (ceil(((240n) - 5p) / (10u))) * ((240n) / (ceil(((240n) - 5p) / (10u)))) * (ceil(((240n) - 5p) / (10u))))           nrs=(((240n) / (ceil(((240n) - 5p) / (10u)))) < 119.5n) ? ((((50n > (((60n) - 0) + 60n) ? 50n : (((60n) - 0) + 60n)) * 120n) + (((240n) / (ceil(((240n) - 5p) / (10u)))) * 50n)) + (floor(((ceil(((240n) - 5p) / (10u))) - 1) / 2.0) * (((((60n) - 0) + 60n) * 120n) + (((240n) / (ceil(((240n) - 5p) / (10u)))) * 100n))) + ((((ceil(((240n) - 5p) / (10u))) / 2) - floor((ceil(((240n) - 5p) / (10u))) / 2) == 0) ? (((50n > (((60n) - 0) + 60n) ? 50n : (((60n) - 0) + 60n)) * 120n) + (((240n) / (ceil(((240n) - 5p) / (10u)))) * 50n)) : 0)) / 1 : (((100n > (((60n) - 0) + 80n) ? 100n : (((60n) - 0) + 80n)) * ((240n) / (ceil(((240n) - 5p) / (10u))))) + (floor(((ceil(((240n) - 5p) / (10u))) - 1) / 2.0) * ((60n > (((60n) - 0) + 50n) ? 60n : (((60n) - 0) + 50n)) * ((240n) / (ceil(((240n) - 5p) / (10u)))))) + ((((ceil(((240n) - 5p) / (10u))) / 2) - floor((ceil(((240n) - 5p) / (10u))) / 2) == 0) ? ((100n > (((60n) - 0) + 80n) ? 100n : (((60n) - 0) + 80n)) * ((240n) / (ceil(((240n) - 5p) / (10u))))) : 0)) / 1 / (((240n) / (ceil(((240n) - 5p) / (10u)))) * (ceil(((240n) - 5p) / (10u))) * ((240n) / (ceil(((240n) - 5p) / (10u)))) * (ceil(((240n) - 5p) / (10u))))           sa=(((240n) / (ceil(((240n) - 5p) / (10u)))) < 119.5n) ? (50n > (((60n) - 0) + 60n) ? 50n : (((60n) - 0) + 60n)) + 5e-08 : (100n > (((60n) - 0) + 80n) ? 100n : (((60n) - 0) + 80n))           sb=(((240n) / (ceil(((240n) - 5p) / (10u)))) < 119.5n) ? (50n > (((60n) - 0) + 60n) ? 50n : (((60n) - 0) + 60n)) + 5e-08 : (100n > (((60n) - 0) + 80n) ? 100n : (((60n) - 0) + 80n))           sd=(((240n) / (ceil(((240n) - 5p) / (10u)))) < 119.5n) ? (((60n) - 0) + 60n) + (2*5e-08) : (60n > (((60n) - 0) + 50n) ? 60n : (((60n) - 0) + 50n))           sca=(( ((240n) / (ceil(((240n) - 5p) / (10u)))) * ( (((1u) * (1u) / ((((240n) / (ceil(((240n) - 5p) / (10u)))) < 119.5n) ? (50n > (((60n) - 0) + 60n) ? 50n : (((60n) - 0) + 60n)) + 5e-08 : (100n > (((60n) - 0) + 80n) ? 100n : (((60n) - 0) + 80n))+60n)) - ((1u) * (1u) / (((((240n) / (ceil(((240n) - 5p) / (10u)))) < 119.5n) ? (50n > (((60n) - 0) + 60n) ? 50n : (((60n) - 0) + 60n)) + 5e-08 : (100n > (((60n) - 0) + 80n) ? 100n : (((60n) - 0) + 80n))+60n)+(45n)))) + ((1u) * (1u) / ((((240n) / (ceil(((240n) - 5p) / (10u)))) < 119.5n) ? (50n > (((60n) - 0) + 60n) ? 50n : (((60n) - 0) + 60n)) + 5e-08 : (100n > (((60n) - 0) + 80n) ? 100n : (((60n) - 0) + 80n))+60n)) - ((1u) * (1u)/ (((((240n) / (ceil(((240n) - 5p) / (10u)))) < 119.5n) ? (50n > (((60n) - 0) + 60n) ? 50n : (((60n) - 0) + 60n)) + 5e-08 : (100n > (((60n) - 0) + 80n) ? 100n : (((60n) - 0) + 80n))+60n)+(45n))))) + ( (45n) * ( (((1u) * (1u) / (60n)) - ((1u) * (1u) / ((60n)+((240n) / (ceil(((240n) - 5p) / (10u))))))) + ((1u) * (1u) / (60n)) - ((1u) * (1u)/ ((60n)+((240n) / (ceil(((240n) - 5p) / (10u))))))))) / (((240n) / (ceil(((240n) - 5p) / (10u)))) * (45n))           scb=((((240n) / (ceil(((240n) - 5p) / (10u)))) * ((((((240n) / (ceil(((240n) - 5p) / (10u)))) < 119.5n) ? (50n > (((60n) - 0) + 60n) ? 50n : (((60n) - 0) + 60n)) + 5e-08 : (100n > (((60n) - 0) + 80n) ? 100n : (((60n) - 0) + 80n))+60n)/10 + (1u)/100)*exp(-10 * ((((240n) / (ceil(((240n) - 5p) / (10u)))) < 119.5n) ? (50n > (((60n) - 0) + 60n) ? 50n : (((60n) - 0) + 60n)) + 5e-08 : (100n > (((60n) - 0) + 80n) ? 100n : (((60n) - 0) + 80n))+60n) / (1u)) - ((((((240n) / (ceil(((240n) - 5p) / (10u)))) < 119.5n) ? (50n > (((60n) - 0) + 60n) ? 50n : (((60n) - 0) + 60n)) + 5e-08 : (100n > (((60n) - 0) + 80n) ? 100n : (((60n) - 0) + 80n))+60n)+(45n))/10 + (1u)/100)*exp(-10 * (((((240n) / (ceil(((240n) - 5p) / (10u)))) < 119.5n) ? (50n > (((60n) - 0) + 60n) ? 50n : (((60n) - 0) + 60n)) + 5e-08 : (100n > (((60n) - 0) + 80n) ? 100n : (((60n) - 0) + 80n))+60n)+(45n)) / (1u)) + (((((240n) / (ceil(((240n) - 5p) / (10u)))) < 119.5n) ? (50n > (((60n) - 0) + 60n) ? 50n : (((60n) - 0) + 60n)) + 5e-08 : (100n > (((60n) - 0) + 80n) ? 100n : (((60n) - 0) + 80n))+60n)/10 + (1u)/100)*exp(-10 * ((((240n) / (ceil(((240n) - 5p) / (10u)))) < 119.5n) ? (50n > (((60n) - 0) + 60n) ? 50n : (((60n) - 0) + 60n)) + 5e-08 : (100n > (((60n) - 0) + 80n) ? 100n : (((60n) - 0) + 80n))+60n) / (1u)) - ((((((240n) / (ceil(((240n) - 5p) / (10u)))) < 119.5n) ? (50n > (((60n) - 0) + 60n) ? 50n : (((60n) - 0) + 60n)) + 5e-08 : (100n > (((60n) - 0) + 80n) ? 100n : (((60n) - 0) + 80n))+60n)+(45n))/10 + (1u)/100)*exp(-10 * (((((240n) / (ceil(((240n) - 5p) / (10u)))) < 119.5n) ? (50n > (((60n) - 0) + 60n) ? 50n : (((60n) - 0) + 60n)) + 5e-08 : (100n > (((60n) - 0) + 80n) ? 100n : (((60n) - 0) + 80n))+60n)+(45n)) / (1u)))) + ((45n) * (((60n)/10 + (1u)/100)*exp(-10 * (60n) / (1u)) - (((60n)+((240n) / (ceil(((240n) - 5p) / (10u)))))/10 + (1u)/100)*exp(-10 * ((60n)+((240n) / (ceil(((240n) - 5p) / (10u))))) / (1u)) + ((60n)/10 + (1u)/100)*exp(-10 * (60n) / (1u)) - (((60n)+((240n) / (ceil(((240n) - 5p) / (10u)))))/10 + (1u)/100)*exp(-10 * ((60n)+((240n) / (ceil(((240n) - 5p) / (10u))))) / (1u))))) / (((240n) / (ceil(((240n) - 5p) / (10u)))) * (45n))           scc=((((240n) / (ceil(((240n) - 5p) / (10u)))) * ((((((240n) / (ceil(((240n) - 5p) / (10u)))) < 119.5n) ? (50n > (((60n) - 0) + 60n) ? 50n : (((60n) - 0) + 60n)) + 5e-08 : (100n > (((60n) - 0) + 80n) ? 100n : (((60n) - 0) + 80n))+60n)/20 + (1u)/400)*exp(-20 * ((((240n) / (ceil(((240n) - 5p) / (10u)))) < 119.5n) ? (50n > (((60n) - 0) + 60n) ? 50n : (((60n) - 0) + 60n)) + 5e-08 : (100n > (((60n) - 0) + 80n) ? 100n : (((60n) - 0) + 80n))+60n) / (1u)) - ((((((240n) / (ceil(((240n) - 5p) / (10u)))) < 119.5n) ? (50n > (((60n) - 0) + 60n) ? 50n : (((60n) - 0) + 60n)) + 5e-08 : (100n > (((60n) - 0) + 80n) ? 100n : (((60n) - 0) + 80n))+60n)+(45n))/20 + (1u)/400)*exp(-20 * (((((240n) / (ceil(((240n) - 5p) / (10u)))) < 119.5n) ? (50n > (((60n) - 0) + 60n) ? 50n : (((60n) - 0) + 60n)) + 5e-08 : (100n > (((60n) - 0) + 80n) ? 100n : (((60n) - 0) + 80n))+60n)+(45n)) / (1u)) + (((((240n) / (ceil(((240n) - 5p) / (10u)))) < 119.5n) ? (50n > (((60n) - 0) + 60n) ? 50n : (((60n) - 0) + 60n)) + 5e-08 : (100n > (((60n) - 0) + 80n) ? 100n : (((60n) - 0) + 80n))+60n)/20 + (1u)/400)*exp(-20 * ((((240n) / (ceil(((240n) - 5p) / (10u)))) < 119.5n) ? (50n > (((60n) - 0) + 60n) ? 50n : (((60n) - 0) + 60n)) + 5e-08 : (100n > (((60n) - 0) + 80n) ? 100n : (((60n) - 0) + 80n))+60n) / (1u)) - ((((((240n) / (ceil(((240n) - 5p) / (10u)))) < 119.5n) ? (50n > (((60n) - 0) + 60n) ? 50n : (((60n) - 0) + 60n)) + 5e-08 : (100n > (((60n) - 0) + 80n) ? 100n : (((60n) - 0) + 80n))+60n)+(45n))/20 + (1u)/400)*exp(-20 * (((((240n) / (ceil(((240n) - 5p) / (10u)))) < 119.5n) ? (50n > (((60n) - 0) + 60n) ? 50n : (((60n) - 0) + 60n)) + 5e-08 : (100n > (((60n) - 0) + 80n) ? 100n : (((60n) - 0) + 80n))+60n)+(45n)) / (1u)))) + ((45n) * (((60n)/20 + (1u)/400)*exp(-20 * (60n) / (1u)) - (((60n)+((240n) / (ceil(((240n) - 5p) / (10u)))))/20 + (1u)/400)*exp(-20 * ((60n)+((240n) / (ceil(((240n) - 5p) / (10u))))) / (1u)) + ((60n)/20 + (1u)/400)*exp(-20 * (60n) / (1u)) - (((60n)+((240n) / (ceil(((240n) - 5p) / (10u)))))/20 + (1u)/400)*exp(-20 * ((60n)+((240n) / (ceil(((240n) - 5p) / (10u))))) / (1u))))) / (((240n) / (ceil(((240n) - 5p) / (10u)))) * (45n))           m=(1)
NM40 (nd BIT_bar tail GND) g45n1svt w=(240n) l=45n nf=ceil(((240n) - 5p) / (10u))           as=(((240n) / (ceil(((240n) - 5p) / (10u)))) < 119.5n) ? ((((50n > (((60n) - 0) + 60n) ? 50n : (((60n) - 0) + 60n)) * 120n) + (((240n) / (ceil(((240n) - 5p) / (10u)))) * 50n)) + (floor(((ceil(((240n) - 5p) / (10u))) - 1) / 2.0) * (((((60n) - 0) + 60n) * 120n) + (((240n) / (ceil(((240n) - 5p) / (10u)))) * 100n))) + ((((ceil(((240n) - 5p) / (10u))) / 2) - floor((ceil(((240n) - 5p) / (10u))) / 2) == 0) ? (((50n > (((60n) - 0) + 60n) ? 50n : (((60n) - 0) + 60n)) * 120n) + (((240n) / (ceil(((240n) - 5p) / (10u)))) * 50n)) : 0)) / 1 : (((100n > (((60n) - 0) + 80n) ? 100n : (((60n) - 0) + 80n)) * ((240n) / (ceil(((240n) - 5p) / (10u))))) + (floor(((ceil(((240n) - 5p) / (10u))) - 1) / 2.0) * ((60n > (((60n) - 0) + 50n) ? 60n : (((60n) - 0) + 50n)) * ((240n) / (ceil(((240n) - 5p) / (10u)))))) + ((((ceil(((240n) - 5p) / (10u))) / 2) - floor((ceil(((240n) - 5p) / (10u))) / 2) == 0) ? ((100n > (((60n) - 0) + 80n) ? 100n : (((60n) - 0) + 80n)) * ((240n) / (ceil(((240n) - 5p) / (10u))))) : 0)) / 1           ad=(((240n) / (ceil(((240n) - 5p) / (10u)))) < 119.5n) ? ((floor((ceil(((240n) - 5p) / (10u))) / 2.0) * (((((60n) - 0) + 60n) * 120n) + (((240n) / (ceil(((240n) - 5p) / (10u)))) * 100n))) + ((((ceil(((240n) - 5p) / (10u))) / 2) - floor((ceil(((240n) - 5p) / (10u))) / 2) != 0) ? (((50n > (((60n) - 0) + 60n) ? 50n : (((60n) - 0) + 60n)) * 120n) + (((240n) / (ceil(((240n) - 5p) / (10u)))) * 50n)) : 0)) / 1 : ((floor((ceil(((240n) - 5p) / (10u))) / 2.0) * ((60n > (((60n) - 0) + 50n) ? 60n : (((60n) - 0) + 50n)) * ((240n) / (ceil(((240n) - 5p) / (10u)))))) + ((((ceil(((240n) - 5p) / (10u))) / 2) - floor((ceil(((240n) - 5p) / (10u))) / 2) != 0) ? ((100n > (((60n) - 0) + 80n) ? 100n : (((60n) - 0) + 80n)) * ((240n) / (ceil(((240n) - 5p) / (10u))))) : 0)) / 1           ps=(((240n) / (ceil(((240n) - 5p) / (10u)))) < 119.5n) ? (((2 * (50n > (((60n) - 0) + 60n) ? 50n : (((60n) - 0) + 60n))) + 340n) + (floor(((ceil(((240n) - 5p) / (10u))) - 1) / 2.0) * ((2 * (((60n) - 0) + 60n)) + 440n)) + ((((ceil(((240n) - 5p) / (10u))) / 2) - floor((ceil(((240n) - 5p) / (10u))) / 2) == 0) ? ((2 * (50n > (((60n) - 0) + 60n) ? 50n : (((60n) - 0) + 60n))) + 340n) : 0)) / 1 : (((2 * (100n > (((60n) - 0) + 80n) ? 100n : (((60n) - 0) + 80n))) + (2 * ((240n) / (ceil(((240n) - 5p) / (10u)))))) + (floor(((ceil(((240n) - 5p) / (10u))) - 1) / 2.0) * ((2 * (60n > (((60n) - 0) + 50n) ? 60n : (((60n) - 0) + 50n))) + (2 * ((240n) / (ceil(((240n) - 5p) / (10u))))))) + ((((ceil(((240n) - 5p) / (10u))) / 2) - floor((ceil(((240n) - 5p) / (10u))) / 2) == 0) ? ((2 * (100n > (((60n) - 0) + 80n) ? 100n : (((60n) - 0) + 80n))) + (2 * ((240n) / (ceil(((240n) - 5p) / (10u)))))) : 0)) / 1           pd=(((240n) / (ceil(((240n) - 5p) / (10u)))) < 119.5n) ? ((floor((ceil(((240n) - 5p) / (10u))) / 2.0) * ((2 * (((60n) - 0) + 60n)) + 440n)) + ((((ceil(((240n) - 5p) / (10u))) / 2) - floor((ceil(((240n) - 5p) / (10u))) / 2) != 0) ? ((2 * (50n > (((60n) - 0) + 60n) ? 50n : (((60n) - 0) + 60n))) + 340n) : 0)) / 1 : ((floor((ceil(((240n) - 5p) / (10u))) / 2.0) * ((2 * (60n > (((60n) - 0) + 50n) ? 60n : (((60n) - 0) + 50n))) + (2 * ((240n) / (ceil(((240n) - 5p) / (10u))))))) + ((((ceil(((240n) - 5p) / (10u))) / 2) - floor((ceil(((240n) - 5p) / (10u))) / 2) != 0) ? ((2 * (100n > (((60n) - 0) + 80n) ? 100n : (((60n) - 0) + 80n))) + (2 * ((240n) / (ceil(((240n) - 5p) / (10u)))))) : 0)) / 1           nrd=(((240n) / (ceil(((240n) - 5p) / (10u)))) < 119.5n) ? ((floor((ceil(((240n) - 5p) / (10u))) / 2.0) * (((((60n) - 0) + 60n) * 120n) + (((240n) / (ceil(((240n) - 5p) / (10u)))) * 100n))) + ((((ceil(((240n) - 5p) / (10u))) / 2) - floor((ceil(((240n) - 5p) / (10u))) / 2) != 0) ? (((50n > (((60n) - 0) + 60n) ? 50n : (((60n) - 0) + 60n)) * 120n) + (((240n) / (ceil(((240n) - 5p) / (10u)))) * 50n)) : 0)) / 1 : ((floor((ceil(((240n) - 5p) / (10u))) / 2.0) * ((60n > (((60n) - 0) + 50n) ? 60n : (((60n) - 0) + 50n)) * ((240n) / (ceil(((240n) - 5p) / (10u)))))) + ((((ceil(((240n) - 5p) / (10u))) / 2) - floor((ceil(((240n) - 5p) / (10u))) / 2) != 0) ? ((100n > (((60n) - 0) + 80n) ? 100n : (((60n) - 0) + 80n)) * ((240n) / (ceil(((240n) - 5p) / (10u))))) : 0)) / 1 / (((240n) / (ceil(((240n) - 5p) / (10u)))) * (ceil(((240n) - 5p) / (10u))) * ((240n) / (ceil(((240n) - 5p) / (10u)))) * (ceil(((240n) - 5p) / (10u))))           nrs=(((240n) / (ceil(((240n) - 5p) / (10u)))) < 119.5n) ? ((((50n > (((60n) - 0) + 60n) ? 50n : (((60n) - 0) + 60n)) * 120n) + (((240n) / (ceil(((240n) - 5p) / (10u)))) * 50n)) + (floor(((ceil(((240n) - 5p) / (10u))) - 1) / 2.0) * (((((60n) - 0) + 60n) * 120n) + (((240n) / (ceil(((240n) - 5p) / (10u)))) * 100n))) + ((((ceil(((240n) - 5p) / (10u))) / 2) - floor((ceil(((240n) - 5p) / (10u))) / 2) == 0) ? (((50n > (((60n) - 0) + 60n) ? 50n : (((60n) - 0) + 60n)) * 120n) + (((240n) / (ceil(((240n) - 5p) / (10u)))) * 50n)) : 0)) / 1 : (((100n > (((60n) - 0) + 80n) ? 100n : (((60n) - 0) + 80n)) * ((240n) / (ceil(((240n) - 5p) / (10u))))) + (floor(((ceil(((240n) - 5p) / (10u))) - 1) / 2.0) * ((60n > (((60n) - 0) + 50n) ? 60n : (((60n) - 0) + 50n)) * ((240n) / (ceil(((240n) - 5p) / (10u)))))) + ((((ceil(((240n) - 5p) / (10u))) / 2) - floor((ceil(((240n) - 5p) / (10u))) / 2) == 0) ? ((100n > (((60n) - 0) + 80n) ? 100n : (((60n) - 0) + 80n)) * ((240n) / (ceil(((240n) - 5p) / (10u))))) : 0)) / 1 / (((240n) / (ceil(((240n) - 5p) / (10u)))) * (ceil(((240n) - 5p) / (10u))) * ((240n) / (ceil(((240n) - 5p) / (10u)))) * (ceil(((240n) - 5p) / (10u))))           sa=(((240n) / (ceil(((240n) - 5p) / (10u)))) < 119.5n) ? (50n > (((60n) - 0) + 60n) ? 50n : (((60n) - 0) + 60n)) + 5e-08 : (100n > (((60n) - 0) + 80n) ? 100n : (((60n) - 0) + 80n))           sb=(((240n) / (ceil(((240n) - 5p) / (10u)))) < 119.5n) ? (50n > (((60n) - 0) + 60n) ? 50n : (((60n) - 0) + 60n)) + 5e-08 : (100n > (((60n) - 0) + 80n) ? 100n : (((60n) - 0) + 80n))           sd=(((240n) / (ceil(((240n) - 5p) / (10u)))) < 119.5n) ? (((60n) - 0) + 60n) + (2*5e-08) : (60n > (((60n) - 0) + 50n) ? 60n : (((60n) - 0) + 50n))           sca=(( ((240n) / (ceil(((240n) - 5p) / (10u)))) * ( (((1u) * (1u) / ((((240n) / (ceil(((240n) - 5p) / (10u)))) < 119.5n) ? (50n > (((60n) - 0) + 60n) ? 50n : (((60n) - 0) + 60n)) + 5e-08 : (100n > (((60n) - 0) + 80n) ? 100n : (((60n) - 0) + 80n))+60n)) - ((1u) * (1u) / (((((240n) / (ceil(((240n) - 5p) / (10u)))) < 119.5n) ? (50n > (((60n) - 0) + 60n) ? 50n : (((60n) - 0) + 60n)) + 5e-08 : (100n > (((60n) - 0) + 80n) ? 100n : (((60n) - 0) + 80n))+60n)+(45n)))) + ((1u) * (1u) / ((((240n) / (ceil(((240n) - 5p) / (10u)))) < 119.5n) ? (50n > (((60n) - 0) + 60n) ? 50n : (((60n) - 0) + 60n)) + 5e-08 : (100n > (((60n) - 0) + 80n) ? 100n : (((60n) - 0) + 80n))+60n)) - ((1u) * (1u)/ (((((240n) / (ceil(((240n) - 5p) / (10u)))) < 119.5n) ? (50n > (((60n) - 0) + 60n) ? 50n : (((60n) - 0) + 60n)) + 5e-08 : (100n > (((60n) - 0) + 80n) ? 100n : (((60n) - 0) + 80n))+60n)+(45n))))) + ( (45n) * ( (((1u) * (1u) / (60n)) - ((1u) * (1u) / ((60n)+((240n) / (ceil(((240n) - 5p) / (10u))))))) + ((1u) * (1u) / (60n)) - ((1u) * (1u)/ ((60n)+((240n) / (ceil(((240n) - 5p) / (10u))))))))) / (((240n) / (ceil(((240n) - 5p) / (10u)))) * (45n))           scb=((((240n) / (ceil(((240n) - 5p) / (10u)))) * ((((((240n) / (ceil(((240n) - 5p) / (10u)))) < 119.5n) ? (50n > (((60n) - 0) + 60n) ? 50n : (((60n) - 0) + 60n)) + 5e-08 : (100n > (((60n) - 0) + 80n) ? 100n : (((60n) - 0) + 80n))+60n)/10 + (1u)/100)*exp(-10 * ((((240n) / (ceil(((240n) - 5p) / (10u)))) < 119.5n) ? (50n > (((60n) - 0) + 60n) ? 50n : (((60n) - 0) + 60n)) + 5e-08 : (100n > (((60n) - 0) + 80n) ? 100n : (((60n) - 0) + 80n))+60n) / (1u)) - ((((((240n) / (ceil(((240n) - 5p) / (10u)))) < 119.5n) ? (50n > (((60n) - 0) + 60n) ? 50n : (((60n) - 0) + 60n)) + 5e-08 : (100n > (((60n) - 0) + 80n) ? 100n : (((60n) - 0) + 80n))+60n)+(45n))/10 + (1u)/100)*exp(-10 * (((((240n) / (ceil(((240n) - 5p) / (10u)))) < 119.5n) ? (50n > (((60n) - 0) + 60n) ? 50n : (((60n) - 0) + 60n)) + 5e-08 : (100n > (((60n) - 0) + 80n) ? 100n : (((60n) - 0) + 80n))+60n)+(45n)) / (1u)) + (((((240n) / (ceil(((240n) - 5p) / (10u)))) < 119.5n) ? (50n > (((60n) - 0) + 60n) ? 50n : (((60n) - 0) + 60n)) + 5e-08 : (100n > (((60n) - 0) + 80n) ? 100n : (((60n) - 0) + 80n))+60n)/10 + (1u)/100)*exp(-10 * ((((240n) / (ceil(((240n) - 5p) / (10u)))) < 119.5n) ? (50n > (((60n) - 0) + 60n) ? 50n : (((60n) - 0) + 60n)) + 5e-08 : (100n > (((60n) - 0) + 80n) ? 100n : (((60n) - 0) + 80n))+60n) / (1u)) - ((((((240n) / (ceil(((240n) - 5p) / (10u)))) < 119.5n) ? (50n > (((60n) - 0) + 60n) ? 50n : (((60n) - 0) + 60n)) + 5e-08 : (100n > (((60n) - 0) + 80n) ? 100n : (((60n) - 0) + 80n))+60n)+(45n))/10 + (1u)/100)*exp(-10 * (((((240n) / (ceil(((240n) - 5p) / (10u)))) < 119.5n) ? (50n > (((60n) - 0) + 60n) ? 50n : (((60n) - 0) + 60n)) + 5e-08 : (100n > (((60n) - 0) + 80n) ? 100n : (((60n) - 0) + 80n))+60n)+(45n)) / (1u)))) + ((45n) * (((60n)/10 + (1u)/100)*exp(-10 * (60n) / (1u)) - (((60n)+((240n) / (ceil(((240n) - 5p) / (10u)))))/10 + (1u)/100)*exp(-10 * ((60n)+((240n) / (ceil(((240n) - 5p) / (10u))))) / (1u)) + ((60n)/10 + (1u)/100)*exp(-10 * (60n) / (1u)) - (((60n)+((240n) / (ceil(((240n) - 5p) / (10u)))))/10 + (1u)/100)*exp(-10 * ((60n)+((240n) / (ceil(((240n) - 5p) / (10u))))) / (1u))))) / (((240n) / (ceil(((240n) - 5p) / (10u)))) * (45n))           scc=((((240n) / (ceil(((240n) - 5p) / (10u)))) * ((((((240n) / (ceil(((240n) - 5p) / (10u)))) < 119.5n) ? (50n > (((60n) - 0) + 60n) ? 50n : (((60n) - 0) + 60n)) + 5e-08 : (100n > (((60n) - 0) + 80n) ? 100n : (((60n) - 0) + 80n))+60n)/20 + (1u)/400)*exp(-20 * ((((240n) / (ceil(((240n) - 5p) / (10u)))) < 119.5n) ? (50n > (((60n) - 0) + 60n) ? 50n : (((60n) - 0) + 60n)) + 5e-08 : (100n > (((60n) - 0) + 80n) ? 100n : (((60n) - 0) + 80n))+60n) / (1u)) - ((((((240n) / (ceil(((240n) - 5p) / (10u)))) < 119.5n) ? (50n > (((60n) - 0) + 60n) ? 50n : (((60n) - 0) + 60n)) + 5e-08 : (100n > (((60n) - 0) + 80n) ? 100n : (((60n) - 0) + 80n))+60n)+(45n))/20 + (1u)/400)*exp(-20 * (((((240n) / (ceil(((240n) - 5p) / (10u)))) < 119.5n) ? (50n > (((60n) - 0) + 60n) ? 50n : (((60n) - 0) + 60n)) + 5e-08 : (100n > (((60n) - 0) + 80n) ? 100n : (((60n) - 0) + 80n))+60n)+(45n)) / (1u)) + (((((240n) / (ceil(((240n) - 5p) / (10u)))) < 119.5n) ? (50n > (((60n) - 0) + 60n) ? 50n : (((60n) - 0) + 60n)) + 5e-08 : (100n > (((60n) - 0) + 80n) ? 100n : (((60n) - 0) + 80n))+60n)/20 + (1u)/400)*exp(-20 * ((((240n) / (ceil(((240n) - 5p) / (10u)))) < 119.5n) ? (50n > (((60n) - 0) + 60n) ? 50n : (((60n) - 0) + 60n)) + 5e-08 : (100n > (((60n) - 0) + 80n) ? 100n : (((60n) - 0) + 80n))+60n) / (1u)) - ((((((240n) / (ceil(((240n) - 5p) / (10u)))) < 119.5n) ? (50n > (((60n) - 0) + 60n) ? 50n : (((60n) - 0) + 60n)) + 5e-08 : (100n > (((60n) - 0) + 80n) ? 100n : (((60n) - 0) + 80n))+60n)+(45n))/20 + (1u)/400)*exp(-20 * (((((240n) / (ceil(((240n) - 5p) / (10u)))) < 119.5n) ? (50n > (((60n) - 0) + 60n) ? 50n : (((60n) - 0) + 60n)) + 5e-08 : (100n > (((60n) - 0) + 80n) ? 100n : (((60n) - 0) + 80n))+60n)+(45n)) / (1u)))) + ((45n) * (((60n)/20 + (1u)/400)*exp(-20 * (60n) / (1u)) - (((60n)+((240n) / (ceil(((240n) - 5p) / (10u)))))/20 + (1u)/400)*exp(-20 * ((60n)+((240n) / (ceil(((240n) - 5p) / (10u))))) / (1u)) + ((60n)/20 + (1u)/400)*exp(-20 * (60n) / (1u)) - (((60n)+((240n) / (ceil(((240n) - 5p) / (10u)))))/20 + (1u)/400)*exp(-20 * ((60n)+((240n) / (ceil(((240n) - 5p) / (10u))))) / (1u))))) / (((240n) / (ceil(((240n) - 5p) / (10u)))) * (45n))           m=(1)
NM39 (AMP_OUT ns GND GND) g45n1svt w=(360n) l=45n nf=ceil(((360n) - 5p) / (10u))           as=(((360n) / (ceil(((360n) - 5p) / (10u)))) < 119.5n) ? ((((50n > (((60n) - 0) + 60n) ? 50n : (((60n) - 0) + 60n)) * 120n) + (((360n) / (ceil(((360n) - 5p) / (10u)))) * 50n)) + (floor(((ceil(((360n) - 5p) / (10u))) - 1) / 2.0) * (((((60n) - 0) + 60n) * 120n) + (((360n) / (ceil(((360n) - 5p) / (10u)))) * 100n))) + ((((ceil(((360n) - 5p) / (10u))) / 2) - floor((ceil(((360n) - 5p) / (10u))) / 2) == 0) ? (((50n > (((60n) - 0) + 60n) ? 50n : (((60n) - 0) + 60n)) * 120n) + (((360n) / (ceil(((360n) - 5p) / (10u)))) * 50n)) : 0)) / 1 : (((100n > (((60n) - 0) + 80n) ? 100n : (((60n) - 0) + 80n)) * ((360n) / (ceil(((360n) - 5p) / (10u))))) + (floor(((ceil(((360n) - 5p) / (10u))) - 1) / 2.0) * ((60n > (((60n) - 0) + 50n) ? 60n : (((60n) - 0) + 50n)) * ((360n) / (ceil(((360n) - 5p) / (10u)))))) + ((((ceil(((360n) - 5p) / (10u))) / 2) - floor((ceil(((360n) - 5p) / (10u))) / 2) == 0) ? ((100n > (((60n) - 0) + 80n) ? 100n : (((60n) - 0) + 80n)) * ((360n) / (ceil(((360n) - 5p) / (10u))))) : 0)) / 1           ad=(((360n) / (ceil(((360n) - 5p) / (10u)))) < 119.5n) ? ((floor((ceil(((360n) - 5p) / (10u))) / 2.0) * (((((60n) - 0) + 60n) * 120n) + (((360n) / (ceil(((360n) - 5p) / (10u)))) * 100n))) + ((((ceil(((360n) - 5p) / (10u))) / 2) - floor((ceil(((360n) - 5p) / (10u))) / 2) != 0) ? (((50n > (((60n) - 0) + 60n) ? 50n : (((60n) - 0) + 60n)) * 120n) + (((360n) / (ceil(((360n) - 5p) / (10u)))) * 50n)) : 0)) / 1 : ((floor((ceil(((360n) - 5p) / (10u))) / 2.0) * ((60n > (((60n) - 0) + 50n) ? 60n : (((60n) - 0) + 50n)) * ((360n) / (ceil(((360n) - 5p) / (10u)))))) + ((((ceil(((360n) - 5p) / (10u))) / 2) - floor((ceil(((360n) - 5p) / (10u))) / 2) != 0) ? ((100n > (((60n) - 0) + 80n) ? 100n : (((60n) - 0) + 80n)) * ((360n) / (ceil(((360n) - 5p) / (10u))))) : 0)) / 1           ps=(((360n) / (ceil(((360n) - 5p) / (10u)))) < 119.5n) ? (((2 * (50n > (((60n) - 0) + 60n) ? 50n : (((60n) - 0) + 60n))) + 340n) + (floor(((ceil(((360n) - 5p) / (10u))) - 1) / 2.0) * ((2 * (((60n) - 0) + 60n)) + 440n)) + ((((ceil(((360n) - 5p) / (10u))) / 2) - floor((ceil(((360n) - 5p) / (10u))) / 2) == 0) ? ((2 * (50n > (((60n) - 0) + 60n) ? 50n : (((60n) - 0) + 60n))) + 340n) : 0)) / 1 : (((2 * (100n > (((60n) - 0) + 80n) ? 100n : (((60n) - 0) + 80n))) + (2 * ((360n) / (ceil(((360n) - 5p) / (10u)))))) + (floor(((ceil(((360n) - 5p) / (10u))) - 1) / 2.0) * ((2 * (60n > (((60n) - 0) + 50n) ? 60n : (((60n) - 0) + 50n))) + (2 * ((360n) / (ceil(((360n) - 5p) / (10u))))))) + ((((ceil(((360n) - 5p) / (10u))) / 2) - floor((ceil(((360n) - 5p) / (10u))) / 2) == 0) ? ((2 * (100n > (((60n) - 0) + 80n) ? 100n : (((60n) - 0) + 80n))) + (2 * ((360n) / (ceil(((360n) - 5p) / (10u)))))) : 0)) / 1           pd=(((360n) / (ceil(((360n) - 5p) / (10u)))) < 119.5n) ? ((floor((ceil(((360n) - 5p) / (10u))) / 2.0) * ((2 * (((60n) - 0) + 60n)) + 440n)) + ((((ceil(((360n) - 5p) / (10u))) / 2) - floor((ceil(((360n) - 5p) / (10u))) / 2) != 0) ? ((2 * (50n > (((60n) - 0) + 60n) ? 50n : (((60n) - 0) + 60n))) + 340n) : 0)) / 1 : ((floor((ceil(((360n) - 5p) / (10u))) / 2.0) * ((2 * (60n > (((60n) - 0) + 50n) ? 60n : (((60n) - 0) + 50n))) + (2 * ((360n) / (ceil(((360n) - 5p) / (10u))))))) + ((((ceil(((360n) - 5p) / (10u))) / 2) - floor((ceil(((360n) - 5p) / (10u))) / 2) != 0) ? ((2 * (100n > (((60n) - 0) + 80n) ? 100n : (((60n) - 0) + 80n))) + (2 * ((360n) / (ceil(((360n) - 5p) / (10u)))))) : 0)) / 1           nrd=(((360n) / (ceil(((360n) - 5p) / (10u)))) < 119.5n) ? ((floor((ceil(((360n) - 5p) / (10u))) / 2.0) * (((((60n) - 0) + 60n) * 120n) + (((360n) / (ceil(((360n) - 5p) / (10u)))) * 100n))) + ((((ceil(((360n) - 5p) / (10u))) / 2) - floor((ceil(((360n) - 5p) / (10u))) / 2) != 0) ? (((50n > (((60n) - 0) + 60n) ? 50n : (((60n) - 0) + 60n)) * 120n) + (((360n) / (ceil(((360n) - 5p) / (10u)))) * 50n)) : 0)) / 1 : ((floor((ceil(((360n) - 5p) / (10u))) / 2.0) * ((60n > (((60n) - 0) + 50n) ? 60n : (((60n) - 0) + 50n)) * ((360n) / (ceil(((360n) - 5p) / (10u)))))) + ((((ceil(((360n) - 5p) / (10u))) / 2) - floor((ceil(((360n) - 5p) / (10u))) / 2) != 0) ? ((100n > (((60n) - 0) + 80n) ? 100n : (((60n) - 0) + 80n)) * ((360n) / (ceil(((360n) - 5p) / (10u))))) : 0)) / 1 / (((360n) / (ceil(((360n) - 5p) / (10u)))) * (ceil(((360n) - 5p) / (10u))) * ((360n) / (ceil(((360n) - 5p) / (10u)))) * (ceil(((360n) - 5p) / (10u))))           nrs=(((360n) / (ceil(((360n) - 5p) / (10u)))) < 119.5n) ? ((((50n > (((60n) - 0) + 60n) ? 50n : (((60n) - 0) + 60n)) * 120n) + (((360n) / (ceil(((360n) - 5p) / (10u)))) * 50n)) + (floor(((ceil(((360n) - 5p) / (10u))) - 1) / 2.0) * (((((60n) - 0) + 60n) * 120n) + (((360n) / (ceil(((360n) - 5p) / (10u)))) * 100n))) + ((((ceil(((360n) - 5p) / (10u))) / 2) - floor((ceil(((360n) - 5p) / (10u))) / 2) == 0) ? (((50n > (((60n) - 0) + 60n) ? 50n : (((60n) - 0) + 60n)) * 120n) + (((360n) / (ceil(((360n) - 5p) / (10u)))) * 50n)) : 0)) / 1 : (((100n > (((60n) - 0) + 80n) ? 100n : (((60n) - 0) + 80n)) * ((360n) / (ceil(((360n) - 5p) / (10u))))) + (floor(((ceil(((360n) - 5p) / (10u))) - 1) / 2.0) * ((60n > (((60n) - 0) + 50n) ? 60n : (((60n) - 0) + 50n)) * ((360n) / (ceil(((360n) - 5p) / (10u)))))) + ((((ceil(((360n) - 5p) / (10u))) / 2) - floor((ceil(((360n) - 5p) / (10u))) / 2) == 0) ? ((100n > (((60n) - 0) + 80n) ? 100n : (((60n) - 0) + 80n)) * ((360n) / (ceil(((360n) - 5p) / (10u))))) : 0)) / 1 / (((360n) / (ceil(((360n) - 5p) / (10u)))) * (ceil(((360n) - 5p) / (10u))) * ((360n) / (ceil(((360n) - 5p) / (10u)))) * (ceil(((360n) - 5p) / (10u))))           sa=(((360n) / (ceil(((360n) - 5p) / (10u)))) < 119.5n) ? (50n > (((60n) - 0) + 60n) ? 50n : (((60n) - 0) + 60n)) + 5e-08 : (100n > (((60n) - 0) + 80n) ? 100n : (((60n) - 0) + 80n))           sb=(((360n) / (ceil(((360n) - 5p) / (10u)))) < 119.5n) ? (50n > (((60n) - 0) + 60n) ? 50n : (((60n) - 0) + 60n)) + 5e-08 : (100n > (((60n) - 0) + 80n) ? 100n : (((60n) - 0) + 80n))           sd=(((360n) / (ceil(((360n) - 5p) / (10u)))) < 119.5n) ? (((60n) - 0) + 60n) + (2*5e-08) : (60n > (((60n) - 0) + 50n) ? 60n : (((60n) - 0) + 50n))           sca=(( ((360n) / (ceil(((360n) - 5p) / (10u)))) * ( (((1u) * (1u) / ((((360n) / (ceil(((360n) - 5p) / (10u)))) < 119.5n) ? (50n > (((60n) - 0) + 60n) ? 50n : (((60n) - 0) + 60n)) + 5e-08 : (100n > (((60n) - 0) + 80n) ? 100n : (((60n) - 0) + 80n))+60n)) - ((1u) * (1u) / (((((360n) / (ceil(((360n) - 5p) / (10u)))) < 119.5n) ? (50n > (((60n) - 0) + 60n) ? 50n : (((60n) - 0) + 60n)) + 5e-08 : (100n > (((60n) - 0) + 80n) ? 100n : (((60n) - 0) + 80n))+60n)+(45n)))) + ((1u) * (1u) / ((((360n) / (ceil(((360n) - 5p) / (10u)))) < 119.5n) ? (50n > (((60n) - 0) + 60n) ? 50n : (((60n) - 0) + 60n)) + 5e-08 : (100n > (((60n) - 0) + 80n) ? 100n : (((60n) - 0) + 80n))+60n)) - ((1u) * (1u)/ (((((360n) / (ceil(((360n) - 5p) / (10u)))) < 119.5n) ? (50n > (((60n) - 0) + 60n) ? 50n : (((60n) - 0) + 60n)) + 5e-08 : (100n > (((60n) - 0) + 80n) ? 100n : (((60n) - 0) + 80n))+60n)+(45n))))) + ( (45n) * ( (((1u) * (1u) / (60n)) - ((1u) * (1u) / ((60n)+((360n) / (ceil(((360n) - 5p) / (10u))))))) + ((1u) * (1u) / (60n)) - ((1u) * (1u)/ ((60n)+((360n) / (ceil(((360n) - 5p) / (10u))))))))) / (((360n) / (ceil(((360n) - 5p) / (10u)))) * (45n))           scb=((((360n) / (ceil(((360n) - 5p) / (10u)))) * ((((((360n) / (ceil(((360n) - 5p) / (10u)))) < 119.5n) ? (50n > (((60n) - 0) + 60n) ? 50n : (((60n) - 0) + 60n)) + 5e-08 : (100n > (((60n) - 0) + 80n) ? 100n : (((60n) - 0) + 80n))+60n)/10 + (1u)/100)*exp(-10 * ((((360n) / (ceil(((360n) - 5p) / (10u)))) < 119.5n) ? (50n > (((60n) - 0) + 60n) ? 50n : (((60n) - 0) + 60n)) + 5e-08 : (100n > (((60n) - 0) + 80n) ? 100n : (((60n) - 0) + 80n))+60n) / (1u)) - ((((((360n) / (ceil(((360n) - 5p) / (10u)))) < 119.5n) ? (50n > (((60n) - 0) + 60n) ? 50n : (((60n) - 0) + 60n)) + 5e-08 : (100n > (((60n) - 0) + 80n) ? 100n : (((60n) - 0) + 80n))+60n)+(45n))/10 + (1u)/100)*exp(-10 * (((((360n) / (ceil(((360n) - 5p) / (10u)))) < 119.5n) ? (50n > (((60n) - 0) + 60n) ? 50n : (((60n) - 0) + 60n)) + 5e-08 : (100n > (((60n) - 0) + 80n) ? 100n : (((60n) - 0) + 80n))+60n)+(45n)) / (1u)) + (((((360n) / (ceil(((360n) - 5p) / (10u)))) < 119.5n) ? (50n > (((60n) - 0) + 60n) ? 50n : (((60n) - 0) + 60n)) + 5e-08 : (100n > (((60n) - 0) + 80n) ? 100n : (((60n) - 0) + 80n))+60n)/10 + (1u)/100)*exp(-10 * ((((360n) / (ceil(((360n) - 5p) / (10u)))) < 119.5n) ? (50n > (((60n) - 0) + 60n) ? 50n : (((60n) - 0) + 60n)) + 5e-08 : (100n > (((60n) - 0) + 80n) ? 100n : (((60n) - 0) + 80n))+60n) / (1u)) - ((((((360n) / (ceil(((360n) - 5p) / (10u)))) < 119.5n) ? (50n > (((60n) - 0) + 60n) ? 50n : (((60n) - 0) + 60n)) + 5e-08 : (100n > (((60n) - 0) + 80n) ? 100n : (((60n) - 0) + 80n))+60n)+(45n))/10 + (1u)/100)*exp(-10 * (((((360n) / (ceil(((360n) - 5p) / (10u)))) < 119.5n) ? (50n > (((60n) - 0) + 60n) ? 50n : (((60n) - 0) + 60n)) + 5e-08 : (100n > (((60n) - 0) + 80n) ? 100n : (((60n) - 0) + 80n))+60n)+(45n)) / (1u)))) + ((45n) * (((60n)/10 + (1u)/100)*exp(-10 * (60n) / (1u)) - (((60n)+((360n) / (ceil(((360n) - 5p) / (10u)))))/10 + (1u)/100)*exp(-10 * ((60n)+((360n) / (ceil(((360n) - 5p) / (10u))))) / (1u)) + ((60n)/10 + (1u)/100)*exp(-10 * (60n) / (1u)) - (((60n)+((360n) / (ceil(((360n) - 5p) / (10u)))))/10 + (1u)/100)*exp(-10 * ((60n)+((360n) / (ceil(((360n) - 5p) / (10u))))) / (1u))))) / (((360n) / (ceil(((360n) - 5p) / (10u)))) * (45n))           scc=((((360n) / (ceil(((360n) - 5p) / (10u)))) * ((((((360n) / (ceil(((360n) - 5p) / (10u)))) < 119.5n) ? (50n > (((60n) - 0) + 60n) ? 50n : (((60n) - 0) + 60n)) + 5e-08 : (100n > (((60n) - 0) + 80n) ? 100n : (((60n) - 0) + 80n))+60n)/20 + (1u)/400)*exp(-20 * ((((360n) / (ceil(((360n) - 5p) / (10u)))) < 119.5n) ? (50n > (((60n) - 0) + 60n) ? 50n : (((60n) - 0) + 60n)) + 5e-08 : (100n > (((60n) - 0) + 80n) ? 100n : (((60n) - 0) + 80n))+60n) / (1u)) - ((((((360n) / (ceil(((360n) - 5p) / (10u)))) < 119.5n) ? (50n > (((60n) - 0) + 60n) ? 50n : (((60n) - 0) + 60n)) + 5e-08 : (100n > (((60n) - 0) + 80n) ? 100n : (((60n) - 0) + 80n))+60n)+(45n))/20 + (1u)/400)*exp(-20 * (((((360n) / (ceil(((360n) - 5p) / (10u)))) < 119.5n) ? (50n > (((60n) - 0) + 60n) ? 50n : (((60n) - 0) + 60n)) + 5e-08 : (100n > (((60n) - 0) + 80n) ? 100n : (((60n) - 0) + 80n))+60n)+(45n)) / (1u)) + (((((360n) / (ceil(((360n) - 5p) / (10u)))) < 119.5n) ? (50n > (((60n) - 0) + 60n) ? 50n : (((60n) - 0) + 60n)) + 5e-08 : (100n > (((60n) - 0) + 80n) ? 100n : (((60n) - 0) + 80n))+60n)/20 + (1u)/400)*exp(-20 * ((((360n) / (ceil(((360n) - 5p) / (10u)))) < 119.5n) ? (50n > (((60n) - 0) + 60n) ? 50n : (((60n) - 0) + 60n)) + 5e-08 : (100n > (((60n) - 0) + 80n) ? 100n : (((60n) - 0) + 80n))+60n) / (1u)) - ((((((360n) / (ceil(((360n) - 5p) / (10u)))) < 119.5n) ? (50n > (((60n) - 0) + 60n) ? 50n : (((60n) - 0) + 60n)) + 5e-08 : (100n > (((60n) - 0) + 80n) ? 100n : (((60n) - 0) + 80n))+60n)+(45n))/20 + (1u)/400)*exp(-20 * (((((360n) / (ceil(((360n) - 5p) / (10u)))) < 119.5n) ? (50n > (((60n) - 0) + 60n) ? 50n : (((60n) - 0) + 60n)) + 5e-08 : (100n > (((60n) - 0) + 80n) ? 100n : (((60n) - 0) + 80n))+60n)+(45n)) / (1u)))) + ((45n) * (((60n)/20 + (1u)/400)*exp(-20 * (60n) / (1u)) - (((60n)+((360n) / (ceil(((360n) - 5p) / (10u)))))/20 + (1u)/400)*exp(-20 * ((60n)+((360n) / (ceil(((360n) - 5p) / (10u))))) / (1u)) + ((60n)/20 + (1u)/400)*exp(-20 * (60n) / (1u)) - (((60n)+((360n) / (ceil(((360n) - 5p) / (10u)))))/20 + (1u)/400)*exp(-20 * ((60n)+((360n) / (ceil(((360n) - 5p) / (10u))))) / (1u))))) / (((360n) / (ceil(((360n) - 5p) / (10u)))) * (45n))           m=(1)
NM38 (tail RE GND GND) g45n1svt w=(360n) l=45n nf=ceil(((360n) - 5p) / (10u))           as=(((360n) / (ceil(((360n) - 5p) / (10u)))) < 119.5n) ? ((((50n > (((60n) - 0) + 60n) ? 50n : (((60n) - 0) + 60n)) * 120n) + (((360n) / (ceil(((360n) - 5p) / (10u)))) * 50n)) + (floor(((ceil(((360n) - 5p) / (10u))) - 1) / 2.0) * (((((60n) - 0) + 60n) * 120n) + (((360n) / (ceil(((360n) - 5p) / (10u)))) * 100n))) + ((((ceil(((360n) - 5p) / (10u))) / 2) - floor((ceil(((360n) - 5p) / (10u))) / 2) == 0) ? (((50n > (((60n) - 0) + 60n) ? 50n : (((60n) - 0) + 60n)) * 120n) + (((360n) / (ceil(((360n) - 5p) / (10u)))) * 50n)) : 0)) / 1 : (((100n > (((60n) - 0) + 80n) ? 100n : (((60n) - 0) + 80n)) * ((360n) / (ceil(((360n) - 5p) / (10u))))) + (floor(((ceil(((360n) - 5p) / (10u))) - 1) / 2.0) * ((60n > (((60n) - 0) + 50n) ? 60n : (((60n) - 0) + 50n)) * ((360n) / (ceil(((360n) - 5p) / (10u)))))) + ((((ceil(((360n) - 5p) / (10u))) / 2) - floor((ceil(((360n) - 5p) / (10u))) / 2) == 0) ? ((100n > (((60n) - 0) + 80n) ? 100n : (((60n) - 0) + 80n)) * ((360n) / (ceil(((360n) - 5p) / (10u))))) : 0)) / 1           ad=(((360n) / (ceil(((360n) - 5p) / (10u)))) < 119.5n) ? ((floor((ceil(((360n) - 5p) / (10u))) / 2.0) * (((((60n) - 0) + 60n) * 120n) + (((360n) / (ceil(((360n) - 5p) / (10u)))) * 100n))) + ((((ceil(((360n) - 5p) / (10u))) / 2) - floor((ceil(((360n) - 5p) / (10u))) / 2) != 0) ? (((50n > (((60n) - 0) + 60n) ? 50n : (((60n) - 0) + 60n)) * 120n) + (((360n) / (ceil(((360n) - 5p) / (10u)))) * 50n)) : 0)) / 1 : ((floor((ceil(((360n) - 5p) / (10u))) / 2.0) * ((60n > (((60n) - 0) + 50n) ? 60n : (((60n) - 0) + 50n)) * ((360n) / (ceil(((360n) - 5p) / (10u)))))) + ((((ceil(((360n) - 5p) / (10u))) / 2) - floor((ceil(((360n) - 5p) / (10u))) / 2) != 0) ? ((100n > (((60n) - 0) + 80n) ? 100n : (((60n) - 0) + 80n)) * ((360n) / (ceil(((360n) - 5p) / (10u))))) : 0)) / 1           ps=(((360n) / (ceil(((360n) - 5p) / (10u)))) < 119.5n) ? (((2 * (50n > (((60n) - 0) + 60n) ? 50n : (((60n) - 0) + 60n))) + 340n) + (floor(((ceil(((360n) - 5p) / (10u))) - 1) / 2.0) * ((2 * (((60n) - 0) + 60n)) + 440n)) + ((((ceil(((360n) - 5p) / (10u))) / 2) - floor((ceil(((360n) - 5p) / (10u))) / 2) == 0) ? ((2 * (50n > (((60n) - 0) + 60n) ? 50n : (((60n) - 0) + 60n))) + 340n) : 0)) / 1 : (((2 * (100n > (((60n) - 0) + 80n) ? 100n : (((60n) - 0) + 80n))) + (2 * ((360n) / (ceil(((360n) - 5p) / (10u)))))) + (floor(((ceil(((360n) - 5p) / (10u))) - 1) / 2.0) * ((2 * (60n > (((60n) - 0) + 50n) ? 60n : (((60n) - 0) + 50n))) + (2 * ((360n) / (ceil(((360n) - 5p) / (10u))))))) + ((((ceil(((360n) - 5p) / (10u))) / 2) - floor((ceil(((360n) - 5p) / (10u))) / 2) == 0) ? ((2 * (100n > (((60n) - 0) + 80n) ? 100n : (((60n) - 0) + 80n))) + (2 * ((360n) / (ceil(((360n) - 5p) / (10u)))))) : 0)) / 1           pd=(((360n) / (ceil(((360n) - 5p) / (10u)))) < 119.5n) ? ((floor((ceil(((360n) - 5p) / (10u))) / 2.0) * ((2 * (((60n) - 0) + 60n)) + 440n)) + ((((ceil(((360n) - 5p) / (10u))) / 2) - floor((ceil(((360n) - 5p) / (10u))) / 2) != 0) ? ((2 * (50n > (((60n) - 0) + 60n) ? 50n : (((60n) - 0) + 60n))) + 340n) : 0)) / 1 : ((floor((ceil(((360n) - 5p) / (10u))) / 2.0) * ((2 * (60n > (((60n) - 0) + 50n) ? 60n : (((60n) - 0) + 50n))) + (2 * ((360n) / (ceil(((360n) - 5p) / (10u))))))) + ((((ceil(((360n) - 5p) / (10u))) / 2) - floor((ceil(((360n) - 5p) / (10u))) / 2) != 0) ? ((2 * (100n > (((60n) - 0) + 80n) ? 100n : (((60n) - 0) + 80n))) + (2 * ((360n) / (ceil(((360n) - 5p) / (10u)))))) : 0)) / 1           nrd=(((360n) / (ceil(((360n) - 5p) / (10u)))) < 119.5n) ? ((floor((ceil(((360n) - 5p) / (10u))) / 2.0) * (((((60n) - 0) + 60n) * 120n) + (((360n) / (ceil(((360n) - 5p) / (10u)))) * 100n))) + ((((ceil(((360n) - 5p) / (10u))) / 2) - floor((ceil(((360n) - 5p) / (10u))) / 2) != 0) ? (((50n > (((60n) - 0) + 60n) ? 50n : (((60n) - 0) + 60n)) * 120n) + (((360n) / (ceil(((360n) - 5p) / (10u)))) * 50n)) : 0)) / 1 : ((floor((ceil(((360n) - 5p) / (10u))) / 2.0) * ((60n > (((60n) - 0) + 50n) ? 60n : (((60n) - 0) + 50n)) * ((360n) / (ceil(((360n) - 5p) / (10u)))))) + ((((ceil(((360n) - 5p) / (10u))) / 2) - floor((ceil(((360n) - 5p) / (10u))) / 2) != 0) ? ((100n > (((60n) - 0) + 80n) ? 100n : (((60n) - 0) + 80n)) * ((360n) / (ceil(((360n) - 5p) / (10u))))) : 0)) / 1 / (((360n) / (ceil(((360n) - 5p) / (10u)))) * (ceil(((360n) - 5p) / (10u))) * ((360n) / (ceil(((360n) - 5p) / (10u)))) * (ceil(((360n) - 5p) / (10u))))           nrs=(((360n) / (ceil(((360n) - 5p) / (10u)))) < 119.5n) ? ((((50n > (((60n) - 0) + 60n) ? 50n : (((60n) - 0) + 60n)) * 120n) + (((360n) / (ceil(((360n) - 5p) / (10u)))) * 50n)) + (floor(((ceil(((360n) - 5p) / (10u))) - 1) / 2.0) * (((((60n) - 0) + 60n) * 120n) + (((360n) / (ceil(((360n) - 5p) / (10u)))) * 100n))) + ((((ceil(((360n) - 5p) / (10u))) / 2) - floor((ceil(((360n) - 5p) / (10u))) / 2) == 0) ? (((50n > (((60n) - 0) + 60n) ? 50n : (((60n) - 0) + 60n)) * 120n) + (((360n) / (ceil(((360n) - 5p) / (10u)))) * 50n)) : 0)) / 1 : (((100n > (((60n) - 0) + 80n) ? 100n : (((60n) - 0) + 80n)) * ((360n) / (ceil(((360n) - 5p) / (10u))))) + (floor(((ceil(((360n) - 5p) / (10u))) - 1) / 2.0) * ((60n > (((60n) - 0) + 50n) ? 60n : (((60n) - 0) + 50n)) * ((360n) / (ceil(((360n) - 5p) / (10u)))))) + ((((ceil(((360n) - 5p) / (10u))) / 2) - floor((ceil(((360n) - 5p) / (10u))) / 2) == 0) ? ((100n > (((60n) - 0) + 80n) ? 100n : (((60n) - 0) + 80n)) * ((360n) / (ceil(((360n) - 5p) / (10u))))) : 0)) / 1 / (((360n) / (ceil(((360n) - 5p) / (10u)))) * (ceil(((360n) - 5p) / (10u))) * ((360n) / (ceil(((360n) - 5p) / (10u)))) * (ceil(((360n) - 5p) / (10u))))           sa=(((360n) / (ceil(((360n) - 5p) / (10u)))) < 119.5n) ? (50n > (((60n) - 0) + 60n) ? 50n : (((60n) - 0) + 60n)) + 5e-08 : (100n > (((60n) - 0) + 80n) ? 100n : (((60n) - 0) + 80n))           sb=(((360n) / (ceil(((360n) - 5p) / (10u)))) < 119.5n) ? (50n > (((60n) - 0) + 60n) ? 50n : (((60n) - 0) + 60n)) + 5e-08 : (100n > (((60n) - 0) + 80n) ? 100n : (((60n) - 0) + 80n))           sd=(((360n) / (ceil(((360n) - 5p) / (10u)))) < 119.5n) ? (((60n) - 0) + 60n) + (2*5e-08) : (60n > (((60n) - 0) + 50n) ? 60n : (((60n) - 0) + 50n))           sca=(( ((360n) / (ceil(((360n) - 5p) / (10u)))) * ( (((1u) * (1u) / ((((360n) / (ceil(((360n) - 5p) / (10u)))) < 119.5n) ? (50n > (((60n) - 0) + 60n) ? 50n : (((60n) - 0) + 60n)) + 5e-08 : (100n > (((60n) - 0) + 80n) ? 100n : (((60n) - 0) + 80n))+60n)) - ((1u) * (1u) / (((((360n) / (ceil(((360n) - 5p) / (10u)))) < 119.5n) ? (50n > (((60n) - 0) + 60n) ? 50n : (((60n) - 0) + 60n)) + 5e-08 : (100n > (((60n) - 0) + 80n) ? 100n : (((60n) - 0) + 80n))+60n)+(45n)))) + ((1u) * (1u) / ((((360n) / (ceil(((360n) - 5p) / (10u)))) < 119.5n) ? (50n > (((60n) - 0) + 60n) ? 50n : (((60n) - 0) + 60n)) + 5e-08 : (100n > (((60n) - 0) + 80n) ? 100n : (((60n) - 0) + 80n))+60n)) - ((1u) * (1u)/ (((((360n) / (ceil(((360n) - 5p) / (10u)))) < 119.5n) ? (50n > (((60n) - 0) + 60n) ? 50n : (((60n) - 0) + 60n)) + 5e-08 : (100n > (((60n) - 0) + 80n) ? 100n : (((60n) - 0) + 80n))+60n)+(45n))))) + ( (45n) * ( (((1u) * (1u) / (60n)) - ((1u) * (1u) / ((60n)+((360n) / (ceil(((360n) - 5p) / (10u))))))) + ((1u) * (1u) / (60n)) - ((1u) * (1u)/ ((60n)+((360n) / (ceil(((360n) - 5p) / (10u))))))))) / (((360n) / (ceil(((360n) - 5p) / (10u)))) * (45n))           scb=((((360n) / (ceil(((360n) - 5p) / (10u)))) * ((((((360n) / (ceil(((360n) - 5p) / (10u)))) < 119.5n) ? (50n > (((60n) - 0) + 60n) ? 50n : (((60n) - 0) + 60n)) + 5e-08 : (100n > (((60n) - 0) + 80n) ? 100n : (((60n) - 0) + 80n))+60n)/10 + (1u)/100)*exp(-10 * ((((360n) / (ceil(((360n) - 5p) / (10u)))) < 119.5n) ? (50n > (((60n) - 0) + 60n) ? 50n : (((60n) - 0) + 60n)) + 5e-08 : (100n > (((60n) - 0) + 80n) ? 100n : (((60n) - 0) + 80n))+60n) / (1u)) - ((((((360n) / (ceil(((360n) - 5p) / (10u)))) < 119.5n) ? (50n > (((60n) - 0) + 60n) ? 50n : (((60n) - 0) + 60n)) + 5e-08 : (100n > (((60n) - 0) + 80n) ? 100n : (((60n) - 0) + 80n))+60n)+(45n))/10 + (1u)/100)*exp(-10 * (((((360n) / (ceil(((360n) - 5p) / (10u)))) < 119.5n) ? (50n > (((60n) - 0) + 60n) ? 50n : (((60n) - 0) + 60n)) + 5e-08 : (100n > (((60n) - 0) + 80n) ? 100n : (((60n) - 0) + 80n))+60n)+(45n)) / (1u)) + (((((360n) / (ceil(((360n) - 5p) / (10u)))) < 119.5n) ? (50n > (((60n) - 0) + 60n) ? 50n : (((60n) - 0) + 60n)) + 5e-08 : (100n > (((60n) - 0) + 80n) ? 100n : (((60n) - 0) + 80n))+60n)/10 + (1u)/100)*exp(-10 * ((((360n) / (ceil(((360n) - 5p) / (10u)))) < 119.5n) ? (50n > (((60n) - 0) + 60n) ? 50n : (((60n) - 0) + 60n)) + 5e-08 : (100n > (((60n) - 0) + 80n) ? 100n : (((60n) - 0) + 80n))+60n) / (1u)) - ((((((360n) / (ceil(((360n) - 5p) / (10u)))) < 119.5n) ? (50n > (((60n) - 0) + 60n) ? 50n : (((60n) - 0) + 60n)) + 5e-08 : (100n > (((60n) - 0) + 80n) ? 100n : (((60n) - 0) + 80n))+60n)+(45n))/10 + (1u)/100)*exp(-10 * (((((360n) / (ceil(((360n) - 5p) / (10u)))) < 119.5n) ? (50n > (((60n) - 0) + 60n) ? 50n : (((60n) - 0) + 60n)) + 5e-08 : (100n > (((60n) - 0) + 80n) ? 100n : (((60n) - 0) + 80n))+60n)+(45n)) / (1u)))) + ((45n) * (((60n)/10 + (1u)/100)*exp(-10 * (60n) / (1u)) - (((60n)+((360n) / (ceil(((360n) - 5p) / (10u)))))/10 + (1u)/100)*exp(-10 * ((60n)+((360n) / (ceil(((360n) - 5p) / (10u))))) / (1u)) + ((60n)/10 + (1u)/100)*exp(-10 * (60n) / (1u)) - (((60n)+((360n) / (ceil(((360n) - 5p) / (10u)))))/10 + (1u)/100)*exp(-10 * ((60n)+((360n) / (ceil(((360n) - 5p) / (10u))))) / (1u))))) / (((360n) / (ceil(((360n) - 5p) / (10u)))) * (45n))           scc=((((360n) / (ceil(((360n) - 5p) / (10u)))) * ((((((360n) / (ceil(((360n) - 5p) / (10u)))) < 119.5n) ? (50n > (((60n) - 0) + 60n) ? 50n : (((60n) - 0) + 60n)) + 5e-08 : (100n > (((60n) - 0) + 80n) ? 100n : (((60n) - 0) + 80n))+60n)/20 + (1u)/400)*exp(-20 * ((((360n) / (ceil(((360n) - 5p) / (10u)))) < 119.5n) ? (50n > (((60n) - 0) + 60n) ? 50n : (((60n) - 0) + 60n)) + 5e-08 : (100n > (((60n) - 0) + 80n) ? 100n : (((60n) - 0) + 80n))+60n) / (1u)) - ((((((360n) / (ceil(((360n) - 5p) / (10u)))) < 119.5n) ? (50n > (((60n) - 0) + 60n) ? 50n : (((60n) - 0) + 60n)) + 5e-08 : (100n > (((60n) - 0) + 80n) ? 100n : (((60n) - 0) + 80n))+60n)+(45n))/20 + (1u)/400)*exp(-20 * (((((360n) / (ceil(((360n) - 5p) / (10u)))) < 119.5n) ? (50n > (((60n) - 0) + 60n) ? 50n : (((60n) - 0) + 60n)) + 5e-08 : (100n > (((60n) - 0) + 80n) ? 100n : (((60n) - 0) + 80n))+60n)+(45n)) / (1u)) + (((((360n) / (ceil(((360n) - 5p) / (10u)))) < 119.5n) ? (50n > (((60n) - 0) + 60n) ? 50n : (((60n) - 0) + 60n)) + 5e-08 : (100n > (((60n) - 0) + 80n) ? 100n : (((60n) - 0) + 80n))+60n)/20 + (1u)/400)*exp(-20 * ((((360n) / (ceil(((360n) - 5p) / (10u)))) < 119.5n) ? (50n > (((60n) - 0) + 60n) ? 50n : (((60n) - 0) + 60n)) + 5e-08 : (100n > (((60n) - 0) + 80n) ? 100n : (((60n) - 0) + 80n))+60n) / (1u)) - ((((((360n) / (ceil(((360n) - 5p) / (10u)))) < 119.5n) ? (50n > (((60n) - 0) + 60n) ? 50n : (((60n) - 0) + 60n)) + 5e-08 : (100n > (((60n) - 0) + 80n) ? 100n : (((60n) - 0) + 80n))+60n)+(45n))/20 + (1u)/400)*exp(-20 * (((((360n) / (ceil(((360n) - 5p) / (10u)))) < 119.5n) ? (50n > (((60n) - 0) + 60n) ? 50n : (((60n) - 0) + 60n)) + 5e-08 : (100n > (((60n) - 0) + 80n) ? 100n : (((60n) - 0) + 80n))+60n)+(45n)) / (1u)))) + ((45n) * (((60n)/20 + (1u)/400)*exp(-20 * (60n) / (1u)) - (((60n)+((360n) / (ceil(((360n) - 5p) / (10u)))))/20 + (1u)/400)*exp(-20 * ((60n)+((360n) / (ceil(((360n) - 5p) / (10u))))) / (1u)) + ((60n)/20 + (1u)/400)*exp(-20 * (60n) / (1u)) - (((60n)+((360n) / (ceil(((360n) - 5p) / (10u)))))/20 + (1u)/400)*exp(-20 * ((60n)+((360n) / (ceil(((360n) - 5p) / (10u))))) / (1u))))) / (((360n) / (ceil(((360n) - 5p) / (10u)))) * (45n))           m=(1)
ends
subckt read_latch (D EN ENB Q VDD GND)
XINPUT (D n0 EN ENB VDD GND) tg
XI0 (n0 nb VDD GND) inv
XI1 (nb Q VDD GND) inv
XFEEDBACK (Q n0 ENB EN VDD GND) tg
ends
subckt row_decoder (R1 R0 EN WL0 WL1 WL2 WL3 VDD GND)
XI0 (R0 R0B VDD GND) inv
XI1 (R1 R1B VDD GND) inv
XR0 (R1B R0B EN WL0 VDD GND) and3
XR1 (R1B R0 EN WL1 VDD GND) and3
XR2 (R1 R0B EN WL2 VDD GND) and3
XR3 (R1 R0 EN WL3 VDD GND) and3
ends
subckt column_decoder (C2 C1 C0 CS0 CS1 CS2 CS3 CS4 CS5 VDD GND)
XI0 (C0 C0B VDD GND) inv
XI1 (C1 C1B VDD GND) inv
XI2 (C2 C2B VDD GND) inv
XC0 (C2B C1B C0B CS0 VDD GND) and3
XC1 (C2B C1B C0 CS1 VDD GND) and3
XC2 (C2B C1 C0B CS2 VDD GND) and3
XC3 (C2B C1 C0 CS3 VDD GND) and3
XC4 (C2 C1B C0B CS4 VDD GND) and3
XC5 (C2 C1B C0 CS5 VDD GND) and3
ends
subckt rw_control (CLK1 CLK2 WR RD C2 C1 WEN WENB REN RENB ROWEN PCB VDD GND)
XIRD (RD NRD VDD GND) inv
XIWR (WR NWR VDD GND) inv
XIPRE (CLK2 PCB VDD GND) inv
XBAD (C2 C1 VDD BADCOL VDD GND) and3
XVALID (BADCOL VALID VDD GND) inv
XWA (WR NRD CLK1 WA VDD GND) and3
XRA (RD NWR CLK1 RA VDD GND) and3
XWE (WA VALID PCB WEN VDD GND) and3
XRE (RA VALID PCB REN VDD GND) and3
XIWE (WEN WENB VDD GND) inv
XIRE (REN RENB VDD GND) inv
XIDLE (WENB RENB VDD IDLE VDD GND) and3
XACTIVE (IDLE ROWEN VDD GND) inv
ends
subckt write_driver (DIN WEN WENB GBL GBLB VDD GND)
XID (DIN DINB VDD GND) inv
XW0 (DIN GBL WEN WENB VDD GND) tg
XW1 (DINB GBLB WEN WENB VDD GND) tg
ends
subckt column_mux (CS0 CS1 CS2 CS3 CS4 CS5 BL0 BL1 BL2 BL3 BL4 BL5 BLB0 BLB1 BLB2 BLB3 BLB4 BLB5 GBL GBLB VDD GND)
XI0 (CS0 CSB0 VDD GND) inv
XM0P (BL0 GBL CS0 CSB0 VDD GND) tg
XM0N (BLB0 GBLB CS0 CSB0 VDD GND) tg
XI1 (CS1 CSB1 VDD GND) inv
XM1P (BL1 GBL CS1 CSB1 VDD GND) tg
XM1N (BLB1 GBLB CS1 CSB1 VDD GND) tg
XI2 (CS2 CSB2 VDD GND) inv
XM2P (BL2 GBL CS2 CSB2 VDD GND) tg
XM2N (BLB2 GBLB CS2 CSB2 VDD GND) tg
XI3 (CS3 CSB3 VDD GND) inv
XM3P (BL3 GBL CS3 CSB3 VDD GND) tg
XM3N (BLB3 GBLB CS3 CSB3 VDD GND) tg
XI4 (CS4 CSB4 VDD GND) inv
XM4P (BL4 GBL CS4 CSB4 VDD GND) tg
XM4N (BLB4 GBLB CS4 CSB4 VDD GND) tg
XI5 (CS5 CSB5 VDD GND) inv
XM5P (BL5 GBL CS5 CSB5 VDD GND) tg
XM5N (BLB5 GBLB CS5 CSB5 VDD GND) tg
ends
subckt precharge (BL0 BL1 BL2 BL3 BL4 BL5 BLB0 BLB1 BLB2 BLB3 BLB4 BLB5 PCB VDD GND)
XP0 (BL0 BLB0 PCB VDD GND) precharge_unit
XP1 (BL1 BLB1 PCB VDD GND) precharge_unit
XP2 (BL2 BLB2 PCB VDD GND) precharge_unit
XP3 (BL3 BLB3 PCB VDD GND) precharge_unit
XP4 (BL4 BLB4 PCB VDD GND) precharge_unit
XP5 (BL5 BLB5 PCB VDD GND) precharge_unit
ends
subckt bitcell (BL BL_bar WL Q Q_bar VDD GND)
PM0 (Q_bar Q VDD VDD) g45p1svt w=(120n) l=45n nf=ceil(((120n) - 5p) / (10u))           as=(((120n) / (ceil(((120n) - 5p) / (10u)))) < 119.5n) ? ((((50n > (((60n) - 0) + 60n) ? 50n : (((60n) - 0) + 60n)) * 120n) + (((120n) / (ceil(((120n) - 5p) / (10u)))) * 50n)) + (floor(((ceil(((120n) - 5p) / (10u))) - 1) / 2.0) * (((((60n) - 0) + 60n) * 120n) + (((120n) / (ceil(((120n) - 5p) / (10u)))) * 100n))) + ((((ceil(((120n) - 5p) / (10u))) / 2) - floor((ceil(((120n) - 5p) / (10u))) / 2) == 0) ? (((50n > (((60n) - 0) + 60n) ? 50n : (((60n) - 0) + 60n)) * 120n) + (((120n) / (ceil(((120n) - 5p) / (10u)))) * 50n)) : 0)) / 1 : (((100n > (((60n) - 0) + 80n) ? 100n : (((60n) - 0) + 80n)) * ((120n) / (ceil(((120n) - 5p) / (10u))))) + (floor(((ceil(((120n) - 5p) / (10u))) - 1) / 2.0) * ((60n > (((60n) - 0) + 50n) ? 60n : (((60n) - 0) + 50n)) * ((120n) / (ceil(((120n) - 5p) / (10u)))))) + ((((ceil(((120n) - 5p) / (10u))) / 2) - floor((ceil(((120n) - 5p) / (10u))) / 2) == 0) ? ((100n > (((60n) - 0) + 80n) ? 100n : (((60n) - 0) + 80n)) * ((120n) / (ceil(((120n) - 5p) / (10u))))) : 0)) / 1           ad=(((120n) / (ceil(((120n) - 5p) / (10u)))) < 119.5n) ? ((floor((ceil(((120n) - 5p) / (10u))) / 2.0) * (((((60n) - 0) + 60n) * 120n) + (((120n) / (ceil(((120n) - 5p) / (10u)))) * 100n))) + ((((ceil(((120n) - 5p) / (10u))) / 2) - floor((ceil(((120n) - 5p) / (10u))) / 2) != 0) ? (((50n > (((60n) - 0) + 60n) ? 50n : (((60n) - 0) + 60n)) * 120n) + (((120n) / (ceil(((120n) - 5p) / (10u)))) * 50n)) : 0)) / 1 : ((floor((ceil(((120n) - 5p) / (10u))) / 2.0) * ((60n > (((60n) - 0) + 50n) ? 60n : (((60n) - 0) + 50n)) * ((120n) / (ceil(((120n) - 5p) / (10u)))))) + ((((ceil(((120n) - 5p) / (10u))) / 2) - floor((ceil(((120n) - 5p) / (10u))) / 2) != 0) ? ((100n > (((60n) - 0) + 80n) ? 100n : (((60n) - 0) + 80n)) * ((120n) / (ceil(((120n) - 5p) / (10u))))) : 0)) / 1           ps=(((120n) / (ceil(((120n) - 5p) / (10u)))) < 119.5n) ? (((2 * (50n > (((60n) - 0) + 60n) ? 50n : (((60n) - 0) + 60n))) + 340n) + (floor(((ceil(((120n) - 5p) / (10u))) - 1) / 2.0) * ((2 * (((60n) - 0) + 60n)) + 440n)) + ((((ceil(((120n) - 5p) / (10u))) / 2) - floor((ceil(((120n) - 5p) / (10u))) / 2) == 0) ? ((2 * (50n > (((60n) - 0) + 60n) ? 50n : (((60n) - 0) + 60n))) + 340n) : 0)) / 1 : (((2 * (100n > (((60n) - 0) + 80n) ? 100n : (((60n) - 0) + 80n))) + (2 * ((120n) / (ceil(((120n) - 5p) / (10u)))))) + (floor(((ceil(((120n) - 5p) / (10u))) - 1) / 2.0) * ((2 * (60n > (((60n) - 0) + 50n) ? 60n : (((60n) - 0) + 50n))) + (2 * ((120n) / (ceil(((120n) - 5p) / (10u))))))) + ((((ceil(((120n) - 5p) / (10u))) / 2) - floor((ceil(((120n) - 5p) / (10u))) / 2) == 0) ? ((2 * (100n > (((60n) - 0) + 80n) ? 100n : (((60n) - 0) + 80n))) + (2 * ((120n) / (ceil(((120n) - 5p) / (10u)))))) : 0)) / 1           pd=(((120n) / (ceil(((120n) - 5p) / (10u)))) < 119.5n) ? ((floor((ceil(((120n) - 5p) / (10u))) / 2.0) * ((2 * (((60n) - 0) + 60n)) + 440n)) + ((((ceil(((120n) - 5p) / (10u))) / 2) - floor((ceil(((120n) - 5p) / (10u))) / 2) != 0) ? ((2 * (50n > (((60n) - 0) + 60n) ? 50n : (((60n) - 0) + 60n))) + 340n) : 0)) / 1 : ((floor((ceil(((120n) - 5p) / (10u))) / 2.0) * ((2 * (60n > (((60n) - 0) + 50n) ? 60n : (((60n) - 0) + 50n))) + (2 * ((120n) / (ceil(((120n) - 5p) / (10u))))))) + ((((ceil(((120n) - 5p) / (10u))) / 2) - floor((ceil(((120n) - 5p) / (10u))) / 2) != 0) ? ((2 * (100n > (((60n) - 0) + 80n) ? 100n : (((60n) - 0) + 80n))) + (2 * ((120n) / (ceil(((120n) - 5p) / (10u)))))) : 0)) / 1           nrd=(((120n) / (ceil(((120n) - 5p) / (10u)))) < 119.5n) ? ((floor((ceil(((120n) - 5p) / (10u))) / 2.0) * (((((60n) - 0) + 60n) * 120n) + (((120n) / (ceil(((120n) - 5p) / (10u)))) * 100n))) + ((((ceil(((120n) - 5p) / (10u))) / 2) - floor((ceil(((120n) - 5p) / (10u))) / 2) != 0) ? (((50n > (((60n) - 0) + 60n) ? 50n : (((60n) - 0) + 60n)) * 120n) + (((120n) / (ceil(((120n) - 5p) / (10u)))) * 50n)) : 0)) / 1 : ((floor((ceil(((120n) - 5p) / (10u))) / 2.0) * ((60n > (((60n) - 0) + 50n) ? 60n : (((60n) - 0) + 50n)) * ((120n) / (ceil(((120n) - 5p) / (10u)))))) + ((((ceil(((120n) - 5p) / (10u))) / 2) - floor((ceil(((120n) - 5p) / (10u))) / 2) != 0) ? ((100n > (((60n) - 0) + 80n) ? 100n : (((60n) - 0) + 80n)) * ((120n) / (ceil(((120n) - 5p) / (10u))))) : 0)) / 1 / (((120n) / (ceil(((120n) - 5p) / (10u)))) * (ceil(((120n) - 5p) / (10u))) * ((120n) / (ceil(((120n) - 5p) / (10u)))) * (ceil(((120n) - 5p) / (10u))))           nrs=(((120n) / (ceil(((120n) - 5p) / (10u)))) < 119.5n) ? ((((50n > (((60n) - 0) + 60n) ? 50n : (((60n) - 0) + 60n)) * 120n) + (((120n) / (ceil(((120n) - 5p) / (10u)))) * 50n)) + (floor(((ceil(((120n) - 5p) / (10u))) - 1) / 2.0) * (((((60n) - 0) + 60n) * 120n) + (((120n) / (ceil(((120n) - 5p) / (10u)))) * 100n))) + ((((ceil(((120n) - 5p) / (10u))) / 2) - floor((ceil(((120n) - 5p) / (10u))) / 2) == 0) ? (((50n > (((60n) - 0) + 60n) ? 50n : (((60n) - 0) + 60n)) * 120n) + (((120n) / (ceil(((120n) - 5p) / (10u)))) * 50n)) : 0)) / 1 : (((100n > (((60n) - 0) + 80n) ? 100n : (((60n) - 0) + 80n)) * ((120n) / (ceil(((120n) - 5p) / (10u))))) + (floor(((ceil(((120n) - 5p) / (10u))) - 1) / 2.0) * ((60n > (((60n) - 0) + 50n) ? 60n : (((60n) - 0) + 50n)) * ((120n) / (ceil(((120n) - 5p) / (10u)))))) + ((((ceil(((120n) - 5p) / (10u))) / 2) - floor((ceil(((120n) - 5p) / (10u))) / 2) == 0) ? ((100n > (((60n) - 0) + 80n) ? 100n : (((60n) - 0) + 80n)) * ((120n) / (ceil(((120n) - 5p) / (10u))))) : 0)) / 1 / (((120n) / (ceil(((120n) - 5p) / (10u)))) * (ceil(((120n) - 5p) / (10u))) * ((120n) / (ceil(((120n) - 5p) / (10u)))) * (ceil(((120n) - 5p) / (10u))))           sa=(((120n) / (ceil(((120n) - 5p) / (10u)))) < 119.5n) ? (50n > (((60n) - 0) + 60n) ? 50n : (((60n) - 0) + 60n)) + 5e-08 : (100n > (((60n) - 0) + 80n) ? 100n : (((60n) - 0) + 80n))           sb=(((120n) / (ceil(((120n) - 5p) / (10u)))) < 119.5n) ? (50n > (((60n) - 0) + 60n) ? 50n : (((60n) - 0) + 60n)) + 5e-08 : (100n > (((60n) - 0) + 80n) ? 100n : (((60n) - 0) + 80n))           sd=(((120n) / (ceil(((120n) - 5p) / (10u)))) < 119.5n) ? (((60n) - 0) + 60n) + (2*5e-08) : (60n > (((60n) - 0) + 50n) ? 60n : (((60n) - 0) + 50n))           sca=(( ((120n) / (ceil(((120n) - 5p) / (10u)))) * ( (((1u) * (1u) / ((((120n) / (ceil(((120n) - 5p) / (10u)))) < 119.5n) ? (50n > (((60n) - 0) + 60n) ? 50n : (((60n) - 0) + 60n)) + 5e-08 : (100n > (((60n) - 0) + 80n) ? 100n : (((60n) - 0) + 80n))+60n)) - ((1u) * (1u) / (((((120n) / (ceil(((120n) - 5p) / (10u)))) < 119.5n) ? (50n > (((60n) - 0) + 60n) ? 50n : (((60n) - 0) + 60n)) + 5e-08 : (100n > (((60n) - 0) + 80n) ? 100n : (((60n) - 0) + 80n))+60n)+(45n)))) + ((1u) * (1u) / ((((120n) / (ceil(((120n) - 5p) / (10u)))) < 119.5n) ? (50n > (((60n) - 0) + 60n) ? 50n : (((60n) - 0) + 60n)) + 5e-08 : (100n > (((60n) - 0) + 80n) ? 100n : (((60n) - 0) + 80n))+60n)) - ((1u) * (1u)/ (((((120n) / (ceil(((120n) - 5p) / (10u)))) < 119.5n) ? (50n > (((60n) - 0) + 60n) ? 50n : (((60n) - 0) + 60n)) + 5e-08 : (100n > (((60n) - 0) + 80n) ? 100n : (((60n) - 0) + 80n))+60n)+(45n))))) + ( (45n) * ( (((1u) * (1u) / (60n)) - ((1u) * (1u) / ((60n)+((120n) / (ceil(((120n) - 5p) / (10u))))))) + ((1u) * (1u) / (60n)) - ((1u) * (1u)/ ((60n)+((120n) / (ceil(((120n) - 5p) / (10u))))))))) / (((120n) / (ceil(((120n) - 5p) / (10u)))) * (45n))           scb=((((120n) / (ceil(((120n) - 5p) / (10u)))) * ((((((120n) / (ceil(((120n) - 5p) / (10u)))) < 119.5n) ? (50n > (((60n) - 0) + 60n) ? 50n : (((60n) - 0) + 60n)) + 5e-08 : (100n > (((60n) - 0) + 80n) ? 100n : (((60n) - 0) + 80n))+60n)/10 + (1u)/100)*exp(-10 * ((((120n) / (ceil(((120n) - 5p) / (10u)))) < 119.5n) ? (50n > (((60n) - 0) + 60n) ? 50n : (((60n) - 0) + 60n)) + 5e-08 : (100n > (((60n) - 0) + 80n) ? 100n : (((60n) - 0) + 80n))+60n) / (1u)) - ((((((120n) / (ceil(((120n) - 5p) / (10u)))) < 119.5n) ? (50n > (((60n) - 0) + 60n) ? 50n : (((60n) - 0) + 60n)) + 5e-08 : (100n > (((60n) - 0) + 80n) ? 100n : (((60n) - 0) + 80n))+60n)+(45n))/10 + (1u)/100)*exp(-10 * (((((120n) / (ceil(((120n) - 5p) / (10u)))) < 119.5n) ? (50n > (((60n) - 0) + 60n) ? 50n : (((60n) - 0) + 60n)) + 5e-08 : (100n > (((60n) - 0) + 80n) ? 100n : (((60n) - 0) + 80n))+60n)+(45n)) / (1u)) + (((((120n) / (ceil(((120n) - 5p) / (10u)))) < 119.5n) ? (50n > (((60n) - 0) + 60n) ? 50n : (((60n) - 0) + 60n)) + 5e-08 : (100n > (((60n) - 0) + 80n) ? 100n : (((60n) - 0) + 80n))+60n)/10 + (1u)/100)*exp(-10 * ((((120n) / (ceil(((120n) - 5p) / (10u)))) < 119.5n) ? (50n > (((60n) - 0) + 60n) ? 50n : (((60n) - 0) + 60n)) + 5e-08 : (100n > (((60n) - 0) + 80n) ? 100n : (((60n) - 0) + 80n))+60n) / (1u)) - ((((((120n) / (ceil(((120n) - 5p) / (10u)))) < 119.5n) ? (50n > (((60n) - 0) + 60n) ? 50n : (((60n) - 0) + 60n)) + 5e-08 : (100n > (((60n) - 0) + 80n) ? 100n : (((60n) - 0) + 80n))+60n)+(45n))/10 + (1u)/100)*exp(-10 * (((((120n) / (ceil(((120n) - 5p) / (10u)))) < 119.5n) ? (50n > (((60n) - 0) + 60n) ? 50n : (((60n) - 0) + 60n)) + 5e-08 : (100n > (((60n) - 0) + 80n) ? 100n : (((60n) - 0) + 80n))+60n)+(45n)) / (1u)))) + ((45n) * (((60n)/10 + (1u)/100)*exp(-10 * (60n) / (1u)) - (((60n)+((120n) / (ceil(((120n) - 5p) / (10u)))))/10 + (1u)/100)*exp(-10 * ((60n)+((120n) / (ceil(((120n) - 5p) / (10u))))) / (1u)) + ((60n)/10 + (1u)/100)*exp(-10 * (60n) / (1u)) - (((60n)+((120n) / (ceil(((120n) - 5p) / (10u)))))/10 + (1u)/100)*exp(-10 * ((60n)+((120n) / (ceil(((120n) - 5p) / (10u))))) / (1u))))) / (((120n) / (ceil(((120n) - 5p) / (10u)))) * (45n))           scc=((((120n) / (ceil(((120n) - 5p) / (10u)))) * ((((((120n) / (ceil(((120n) - 5p) / (10u)))) < 119.5n) ? (50n > (((60n) - 0) + 60n) ? 50n : (((60n) - 0) + 60n)) + 5e-08 : (100n > (((60n) - 0) + 80n) ? 100n : (((60n) - 0) + 80n))+60n)/20 + (1u)/400)*exp(-20 * ((((120n) / (ceil(((120n) - 5p) / (10u)))) < 119.5n) ? (50n > (((60n) - 0) + 60n) ? 50n : (((60n) - 0) + 60n)) + 5e-08 : (100n > (((60n) - 0) + 80n) ? 100n : (((60n) - 0) + 80n))+60n) / (1u)) - ((((((120n) / (ceil(((120n) - 5p) / (10u)))) < 119.5n) ? (50n > (((60n) - 0) + 60n) ? 50n : (((60n) - 0) + 60n)) + 5e-08 : (100n > (((60n) - 0) + 80n) ? 100n : (((60n) - 0) + 80n))+60n)+(45n))/20 + (1u)/400)*exp(-20 * (((((120n) / (ceil(((120n) - 5p) / (10u)))) < 119.5n) ? (50n > (((60n) - 0) + 60n) ? 50n : (((60n) - 0) + 60n)) + 5e-08 : (100n > (((60n) - 0) + 80n) ? 100n : (((60n) - 0) + 80n))+60n)+(45n)) / (1u)) + (((((120n) / (ceil(((120n) - 5p) / (10u)))) < 119.5n) ? (50n > (((60n) - 0) + 60n) ? 50n : (((60n) - 0) + 60n)) + 5e-08 : (100n > (((60n) - 0) + 80n) ? 100n : (((60n) - 0) + 80n))+60n)/20 + (1u)/400)*exp(-20 * ((((120n) / (ceil(((120n) - 5p) / (10u)))) < 119.5n) ? (50n > (((60n) - 0) + 60n) ? 50n : (((60n) - 0) + 60n)) + 5e-08 : (100n > (((60n) - 0) + 80n) ? 100n : (((60n) - 0) + 80n))+60n) / (1u)) - ((((((120n) / (ceil(((120n) - 5p) / (10u)))) < 119.5n) ? (50n > (((60n) - 0) + 60n) ? 50n : (((60n) - 0) + 60n)) + 5e-08 : (100n > (((60n) - 0) + 80n) ? 100n : (((60n) - 0) + 80n))+60n)+(45n))/20 + (1u)/400)*exp(-20 * (((((120n) / (ceil(((120n) - 5p) / (10u)))) < 119.5n) ? (50n > (((60n) - 0) + 60n) ? 50n : (((60n) - 0) + 60n)) + 5e-08 : (100n > (((60n) - 0) + 80n) ? 100n : (((60n) - 0) + 80n))+60n)+(45n)) / (1u)))) + ((45n) * (((60n)/20 + (1u)/400)*exp(-20 * (60n) / (1u)) - (((60n)+((120n) / (ceil(((120n) - 5p) / (10u)))))/20 + (1u)/400)*exp(-20 * ((60n)+((120n) / (ceil(((120n) - 5p) / (10u))))) / (1u)) + ((60n)/20 + (1u)/400)*exp(-20 * (60n) / (1u)) - (((60n)+((120n) / (ceil(((120n) - 5p) / (10u)))))/20 + (1u)/400)*exp(-20 * ((60n)+((120n) / (ceil(((120n) - 5p) / (10u))))) / (1u))))) / (((120n) / (ceil(((120n) - 5p) / (10u)))) * (45n))           m=(1)
PM1 (Q Q_bar VDD VDD) g45p1svt w=(120n) l=45n nf=ceil(((120n) - 5p) / (10u))           as=(((120n) / (ceil(((120n) - 5p) / (10u)))) < 119.5n) ? ((((50n > (((60n) - 0) + 60n) ? 50n : (((60n) - 0) + 60n)) * 120n) + (((120n) / (ceil(((120n) - 5p) / (10u)))) * 50n)) + (floor(((ceil(((120n) - 5p) / (10u))) - 1) / 2.0) * (((((60n) - 0) + 60n) * 120n) + (((120n) / (ceil(((120n) - 5p) / (10u)))) * 100n))) + ((((ceil(((120n) - 5p) / (10u))) / 2) - floor((ceil(((120n) - 5p) / (10u))) / 2) == 0) ? (((50n > (((60n) - 0) + 60n) ? 50n : (((60n) - 0) + 60n)) * 120n) + (((120n) / (ceil(((120n) - 5p) / (10u)))) * 50n)) : 0)) / 1 : (((100n > (((60n) - 0) + 80n) ? 100n : (((60n) - 0) + 80n)) * ((120n) / (ceil(((120n) - 5p) / (10u))))) + (floor(((ceil(((120n) - 5p) / (10u))) - 1) / 2.0) * ((60n > (((60n) - 0) + 50n) ? 60n : (((60n) - 0) + 50n)) * ((120n) / (ceil(((120n) - 5p) / (10u)))))) + ((((ceil(((120n) - 5p) / (10u))) / 2) - floor((ceil(((120n) - 5p) / (10u))) / 2) == 0) ? ((100n > (((60n) - 0) + 80n) ? 100n : (((60n) - 0) + 80n)) * ((120n) / (ceil(((120n) - 5p) / (10u))))) : 0)) / 1           ad=(((120n) / (ceil(((120n) - 5p) / (10u)))) < 119.5n) ? ((floor((ceil(((120n) - 5p) / (10u))) / 2.0) * (((((60n) - 0) + 60n) * 120n) + (((120n) / (ceil(((120n) - 5p) / (10u)))) * 100n))) + ((((ceil(((120n) - 5p) / (10u))) / 2) - floor((ceil(((120n) - 5p) / (10u))) / 2) != 0) ? (((50n > (((60n) - 0) + 60n) ? 50n : (((60n) - 0) + 60n)) * 120n) + (((120n) / (ceil(((120n) - 5p) / (10u)))) * 50n)) : 0)) / 1 : ((floor((ceil(((120n) - 5p) / (10u))) / 2.0) * ((60n > (((60n) - 0) + 50n) ? 60n : (((60n) - 0) + 50n)) * ((120n) / (ceil(((120n) - 5p) / (10u)))))) + ((((ceil(((120n) - 5p) / (10u))) / 2) - floor((ceil(((120n) - 5p) / (10u))) / 2) != 0) ? ((100n > (((60n) - 0) + 80n) ? 100n : (((60n) - 0) + 80n)) * ((120n) / (ceil(((120n) - 5p) / (10u))))) : 0)) / 1           ps=(((120n) / (ceil(((120n) - 5p) / (10u)))) < 119.5n) ? (((2 * (50n > (((60n) - 0) + 60n) ? 50n : (((60n) - 0) + 60n))) + 340n) + (floor(((ceil(((120n) - 5p) / (10u))) - 1) / 2.0) * ((2 * (((60n) - 0) + 60n)) + 440n)) + ((((ceil(((120n) - 5p) / (10u))) / 2) - floor((ceil(((120n) - 5p) / (10u))) / 2) == 0) ? ((2 * (50n > (((60n) - 0) + 60n) ? 50n : (((60n) - 0) + 60n))) + 340n) : 0)) / 1 : (((2 * (100n > (((60n) - 0) + 80n) ? 100n : (((60n) - 0) + 80n))) + (2 * ((120n) / (ceil(((120n) - 5p) / (10u)))))) + (floor(((ceil(((120n) - 5p) / (10u))) - 1) / 2.0) * ((2 * (60n > (((60n) - 0) + 50n) ? 60n : (((60n) - 0) + 50n))) + (2 * ((120n) / (ceil(((120n) - 5p) / (10u))))))) + ((((ceil(((120n) - 5p) / (10u))) / 2) - floor((ceil(((120n) - 5p) / (10u))) / 2) == 0) ? ((2 * (100n > (((60n) - 0) + 80n) ? 100n : (((60n) - 0) + 80n))) + (2 * ((120n) / (ceil(((120n) - 5p) / (10u)))))) : 0)) / 1           pd=(((120n) / (ceil(((120n) - 5p) / (10u)))) < 119.5n) ? ((floor((ceil(((120n) - 5p) / (10u))) / 2.0) * ((2 * (((60n) - 0) + 60n)) + 440n)) + ((((ceil(((120n) - 5p) / (10u))) / 2) - floor((ceil(((120n) - 5p) / (10u))) / 2) != 0) ? ((2 * (50n > (((60n) - 0) + 60n) ? 50n : (((60n) - 0) + 60n))) + 340n) : 0)) / 1 : ((floor((ceil(((120n) - 5p) / (10u))) / 2.0) * ((2 * (60n > (((60n) - 0) + 50n) ? 60n : (((60n) - 0) + 50n))) + (2 * ((120n) / (ceil(((120n) - 5p) / (10u))))))) + ((((ceil(((120n) - 5p) / (10u))) / 2) - floor((ceil(((120n) - 5p) / (10u))) / 2) != 0) ? ((2 * (100n > (((60n) - 0) + 80n) ? 100n : (((60n) - 0) + 80n))) + (2 * ((120n) / (ceil(((120n) - 5p) / (10u)))))) : 0)) / 1           nrd=(((120n) / (ceil(((120n) - 5p) / (10u)))) < 119.5n) ? ((floor((ceil(((120n) - 5p) / (10u))) / 2.0) * (((((60n) - 0) + 60n) * 120n) + (((120n) / (ceil(((120n) - 5p) / (10u)))) * 100n))) + ((((ceil(((120n) - 5p) / (10u))) / 2) - floor((ceil(((120n) - 5p) / (10u))) / 2) != 0) ? (((50n > (((60n) - 0) + 60n) ? 50n : (((60n) - 0) + 60n)) * 120n) + (((120n) / (ceil(((120n) - 5p) / (10u)))) * 50n)) : 0)) / 1 : ((floor((ceil(((120n) - 5p) / (10u))) / 2.0) * ((60n > (((60n) - 0) + 50n) ? 60n : (((60n) - 0) + 50n)) * ((120n) / (ceil(((120n) - 5p) / (10u)))))) + ((((ceil(((120n) - 5p) / (10u))) / 2) - floor((ceil(((120n) - 5p) / (10u))) / 2) != 0) ? ((100n > (((60n) - 0) + 80n) ? 100n : (((60n) - 0) + 80n)) * ((120n) / (ceil(((120n) - 5p) / (10u))))) : 0)) / 1 / (((120n) / (ceil(((120n) - 5p) / (10u)))) * (ceil(((120n) - 5p) / (10u))) * ((120n) / (ceil(((120n) - 5p) / (10u)))) * (ceil(((120n) - 5p) / (10u))))           nrs=(((120n) / (ceil(((120n) - 5p) / (10u)))) < 119.5n) ? ((((50n > (((60n) - 0) + 60n) ? 50n : (((60n) - 0) + 60n)) * 120n) + (((120n) / (ceil(((120n) - 5p) / (10u)))) * 50n)) + (floor(((ceil(((120n) - 5p) / (10u))) - 1) / 2.0) * (((((60n) - 0) + 60n) * 120n) + (((120n) / (ceil(((120n) - 5p) / (10u)))) * 100n))) + ((((ceil(((120n) - 5p) / (10u))) / 2) - floor((ceil(((120n) - 5p) / (10u))) / 2) == 0) ? (((50n > (((60n) - 0) + 60n) ? 50n : (((60n) - 0) + 60n)) * 120n) + (((120n) / (ceil(((120n) - 5p) / (10u)))) * 50n)) : 0)) / 1 : (((100n > (((60n) - 0) + 80n) ? 100n : (((60n) - 0) + 80n)) * ((120n) / (ceil(((120n) - 5p) / (10u))))) + (floor(((ceil(((120n) - 5p) / (10u))) - 1) / 2.0) * ((60n > (((60n) - 0) + 50n) ? 60n : (((60n) - 0) + 50n)) * ((120n) / (ceil(((120n) - 5p) / (10u)))))) + ((((ceil(((120n) - 5p) / (10u))) / 2) - floor((ceil(((120n) - 5p) / (10u))) / 2) == 0) ? ((100n > (((60n) - 0) + 80n) ? 100n : (((60n) - 0) + 80n)) * ((120n) / (ceil(((120n) - 5p) / (10u))))) : 0)) / 1 / (((120n) / (ceil(((120n) - 5p) / (10u)))) * (ceil(((120n) - 5p) / (10u))) * ((120n) / (ceil(((120n) - 5p) / (10u)))) * (ceil(((120n) - 5p) / (10u))))           sa=(((120n) / (ceil(((120n) - 5p) / (10u)))) < 119.5n) ? (50n > (((60n) - 0) + 60n) ? 50n : (((60n) - 0) + 60n)) + 5e-08 : (100n > (((60n) - 0) + 80n) ? 100n : (((60n) - 0) + 80n))           sb=(((120n) / (ceil(((120n) - 5p) / (10u)))) < 119.5n) ? (50n > (((60n) - 0) + 60n) ? 50n : (((60n) - 0) + 60n)) + 5e-08 : (100n > (((60n) - 0) + 80n) ? 100n : (((60n) - 0) + 80n))           sd=(((120n) / (ceil(((120n) - 5p) / (10u)))) < 119.5n) ? (((60n) - 0) + 60n) + (2*5e-08) : (60n > (((60n) - 0) + 50n) ? 60n : (((60n) - 0) + 50n))           sca=(( ((120n) / (ceil(((120n) - 5p) / (10u)))) * ( (((1u) * (1u) / ((((120n) / (ceil(((120n) - 5p) / (10u)))) < 119.5n) ? (50n > (((60n) - 0) + 60n) ? 50n : (((60n) - 0) + 60n)) + 5e-08 : (100n > (((60n) - 0) + 80n) ? 100n : (((60n) - 0) + 80n))+60n)) - ((1u) * (1u) / (((((120n) / (ceil(((120n) - 5p) / (10u)))) < 119.5n) ? (50n > (((60n) - 0) + 60n) ? 50n : (((60n) - 0) + 60n)) + 5e-08 : (100n > (((60n) - 0) + 80n) ? 100n : (((60n) - 0) + 80n))+60n)+(45n)))) + ((1u) * (1u) / ((((120n) / (ceil(((120n) - 5p) / (10u)))) < 119.5n) ? (50n > (((60n) - 0) + 60n) ? 50n : (((60n) - 0) + 60n)) + 5e-08 : (100n > (((60n) - 0) + 80n) ? 100n : (((60n) - 0) + 80n))+60n)) - ((1u) * (1u)/ (((((120n) / (ceil(((120n) - 5p) / (10u)))) < 119.5n) ? (50n > (((60n) - 0) + 60n) ? 50n : (((60n) - 0) + 60n)) + 5e-08 : (100n > (((60n) - 0) + 80n) ? 100n : (((60n) - 0) + 80n))+60n)+(45n))))) + ( (45n) * ( (((1u) * (1u) / (60n)) - ((1u) * (1u) / ((60n)+((120n) / (ceil(((120n) - 5p) / (10u))))))) + ((1u) * (1u) / (60n)) - ((1u) * (1u)/ ((60n)+((120n) / (ceil(((120n) - 5p) / (10u))))))))) / (((120n) / (ceil(((120n) - 5p) / (10u)))) * (45n))           scb=((((120n) / (ceil(((120n) - 5p) / (10u)))) * ((((((120n) / (ceil(((120n) - 5p) / (10u)))) < 119.5n) ? (50n > (((60n) - 0) + 60n) ? 50n : (((60n) - 0) + 60n)) + 5e-08 : (100n > (((60n) - 0) + 80n) ? 100n : (((60n) - 0) + 80n))+60n)/10 + (1u)/100)*exp(-10 * ((((120n) / (ceil(((120n) - 5p) / (10u)))) < 119.5n) ? (50n > (((60n) - 0) + 60n) ? 50n : (((60n) - 0) + 60n)) + 5e-08 : (100n > (((60n) - 0) + 80n) ? 100n : (((60n) - 0) + 80n))+60n) / (1u)) - ((((((120n) / (ceil(((120n) - 5p) / (10u)))) < 119.5n) ? (50n > (((60n) - 0) + 60n) ? 50n : (((60n) - 0) + 60n)) + 5e-08 : (100n > (((60n) - 0) + 80n) ? 100n : (((60n) - 0) + 80n))+60n)+(45n))/10 + (1u)/100)*exp(-10 * (((((120n) / (ceil(((120n) - 5p) / (10u)))) < 119.5n) ? (50n > (((60n) - 0) + 60n) ? 50n : (((60n) - 0) + 60n)) + 5e-08 : (100n > (((60n) - 0) + 80n) ? 100n : (((60n) - 0) + 80n))+60n)+(45n)) / (1u)) + (((((120n) / (ceil(((120n) - 5p) / (10u)))) < 119.5n) ? (50n > (((60n) - 0) + 60n) ? 50n : (((60n) - 0) + 60n)) + 5e-08 : (100n > (((60n) - 0) + 80n) ? 100n : (((60n) - 0) + 80n))+60n)/10 + (1u)/100)*exp(-10 * ((((120n) / (ceil(((120n) - 5p) / (10u)))) < 119.5n) ? (50n > (((60n) - 0) + 60n) ? 50n : (((60n) - 0) + 60n)) + 5e-08 : (100n > (((60n) - 0) + 80n) ? 100n : (((60n) - 0) + 80n))+60n) / (1u)) - ((((((120n) / (ceil(((120n) - 5p) / (10u)))) < 119.5n) ? (50n > (((60n) - 0) + 60n) ? 50n : (((60n) - 0) + 60n)) + 5e-08 : (100n > (((60n) - 0) + 80n) ? 100n : (((60n) - 0) + 80n))+60n)+(45n))/10 + (1u)/100)*exp(-10 * (((((120n) / (ceil(((120n) - 5p) / (10u)))) < 119.5n) ? (50n > (((60n) - 0) + 60n) ? 50n : (((60n) - 0) + 60n)) + 5e-08 : (100n > (((60n) - 0) + 80n) ? 100n : (((60n) - 0) + 80n))+60n)+(45n)) / (1u)))) + ((45n) * (((60n)/10 + (1u)/100)*exp(-10 * (60n) / (1u)) - (((60n)+((120n) / (ceil(((120n) - 5p) / (10u)))))/10 + (1u)/100)*exp(-10 * ((60n)+((120n) / (ceil(((120n) - 5p) / (10u))))) / (1u)) + ((60n)/10 + (1u)/100)*exp(-10 * (60n) / (1u)) - (((60n)+((120n) / (ceil(((120n) - 5p) / (10u)))))/10 + (1u)/100)*exp(-10 * ((60n)+((120n) / (ceil(((120n) - 5p) / (10u))))) / (1u))))) / (((120n) / (ceil(((120n) - 5p) / (10u)))) * (45n))           scc=((((120n) / (ceil(((120n) - 5p) / (10u)))) * ((((((120n) / (ceil(((120n) - 5p) / (10u)))) < 119.5n) ? (50n > (((60n) - 0) + 60n) ? 50n : (((60n) - 0) + 60n)) + 5e-08 : (100n > (((60n) - 0) + 80n) ? 100n : (((60n) - 0) + 80n))+60n)/20 + (1u)/400)*exp(-20 * ((((120n) / (ceil(((120n) - 5p) / (10u)))) < 119.5n) ? (50n > (((60n) - 0) + 60n) ? 50n : (((60n) - 0) + 60n)) + 5e-08 : (100n > (((60n) - 0) + 80n) ? 100n : (((60n) - 0) + 80n))+60n) / (1u)) - ((((((120n) / (ceil(((120n) - 5p) / (10u)))) < 119.5n) ? (50n > (((60n) - 0) + 60n) ? 50n : (((60n) - 0) + 60n)) + 5e-08 : (100n > (((60n) - 0) + 80n) ? 100n : (((60n) - 0) + 80n))+60n)+(45n))/20 + (1u)/400)*exp(-20 * (((((120n) / (ceil(((120n) - 5p) / (10u)))) < 119.5n) ? (50n > (((60n) - 0) + 60n) ? 50n : (((60n) - 0) + 60n)) + 5e-08 : (100n > (((60n) - 0) + 80n) ? 100n : (((60n) - 0) + 80n))+60n)+(45n)) / (1u)) + (((((120n) / (ceil(((120n) - 5p) / (10u)))) < 119.5n) ? (50n > (((60n) - 0) + 60n) ? 50n : (((60n) - 0) + 60n)) + 5e-08 : (100n > (((60n) - 0) + 80n) ? 100n : (((60n) - 0) + 80n))+60n)/20 + (1u)/400)*exp(-20 * ((((120n) / (ceil(((120n) - 5p) / (10u)))) < 119.5n) ? (50n > (((60n) - 0) + 60n) ? 50n : (((60n) - 0) + 60n)) + 5e-08 : (100n > (((60n) - 0) + 80n) ? 100n : (((60n) - 0) + 80n))+60n) / (1u)) - ((((((120n) / (ceil(((120n) - 5p) / (10u)))) < 119.5n) ? (50n > (((60n) - 0) + 60n) ? 50n : (((60n) - 0) + 60n)) + 5e-08 : (100n > (((60n) - 0) + 80n) ? 100n : (((60n) - 0) + 80n))+60n)+(45n))/20 + (1u)/400)*exp(-20 * (((((120n) / (ceil(((120n) - 5p) / (10u)))) < 119.5n) ? (50n > (((60n) - 0) + 60n) ? 50n : (((60n) - 0) + 60n)) + 5e-08 : (100n > (((60n) - 0) + 80n) ? 100n : (((60n) - 0) + 80n))+60n)+(45n)) / (1u)))) + ((45n) * (((60n)/20 + (1u)/400)*exp(-20 * (60n) / (1u)) - (((60n)+((120n) / (ceil(((120n) - 5p) / (10u)))))/20 + (1u)/400)*exp(-20 * ((60n)+((120n) / (ceil(((120n) - 5p) / (10u))))) / (1u)) + ((60n)/20 + (1u)/400)*exp(-20 * (60n) / (1u)) - (((60n)+((120n) / (ceil(((120n) - 5p) / (10u)))))/20 + (1u)/400)*exp(-20 * ((60n)+((120n) / (ceil(((120n) - 5p) / (10u))))) / (1u))))) / (((120n) / (ceil(((120n) - 5p) / (10u)))) * (45n))           m=(1)
NM0 (Q_bar Q GND GND) g45n1svt w=(360n) l=45n nf=ceil(((360n) - 5p) / (10u))           as=(((360n) / (ceil(((360n) - 5p) / (10u)))) < 119.5n) ? ((((50n > (((60n) - 0) + 60n) ? 50n : (((60n) - 0) + 60n)) * 120n) + (((360n) / (ceil(((360n) - 5p) / (10u)))) * 50n)) + (floor(((ceil(((360n) - 5p) / (10u))) - 1) / 2.0) * (((((60n) - 0) + 60n) * 120n) + (((360n) / (ceil(((360n) - 5p) / (10u)))) * 100n))) + ((((ceil(((360n) - 5p) / (10u))) / 2) - floor((ceil(((360n) - 5p) / (10u))) / 2) == 0) ? (((50n > (((60n) - 0) + 60n) ? 50n : (((60n) - 0) + 60n)) * 120n) + (((360n) / (ceil(((360n) - 5p) / (10u)))) * 50n)) : 0)) / 1 : (((100n > (((60n) - 0) + 80n) ? 100n : (((60n) - 0) + 80n)) * ((360n) / (ceil(((360n) - 5p) / (10u))))) + (floor(((ceil(((360n) - 5p) / (10u))) - 1) / 2.0) * ((60n > (((60n) - 0) + 50n) ? 60n : (((60n) - 0) + 50n)) * ((360n) / (ceil(((360n) - 5p) / (10u)))))) + ((((ceil(((360n) - 5p) / (10u))) / 2) - floor((ceil(((360n) - 5p) / (10u))) / 2) == 0) ? ((100n > (((60n) - 0) + 80n) ? 100n : (((60n) - 0) + 80n)) * ((360n) / (ceil(((360n) - 5p) / (10u))))) : 0)) / 1           ad=(((360n) / (ceil(((360n) - 5p) / (10u)))) < 119.5n) ? ((floor((ceil(((360n) - 5p) / (10u))) / 2.0) * (((((60n) - 0) + 60n) * 120n) + (((360n) / (ceil(((360n) - 5p) / (10u)))) * 100n))) + ((((ceil(((360n) - 5p) / (10u))) / 2) - floor((ceil(((360n) - 5p) / (10u))) / 2) != 0) ? (((50n > (((60n) - 0) + 60n) ? 50n : (((60n) - 0) + 60n)) * 120n) + (((360n) / (ceil(((360n) - 5p) / (10u)))) * 50n)) : 0)) / 1 : ((floor((ceil(((360n) - 5p) / (10u))) / 2.0) * ((60n > (((60n) - 0) + 50n) ? 60n : (((60n) - 0) + 50n)) * ((360n) / (ceil(((360n) - 5p) / (10u)))))) + ((((ceil(((360n) - 5p) / (10u))) / 2) - floor((ceil(((360n) - 5p) / (10u))) / 2) != 0) ? ((100n > (((60n) - 0) + 80n) ? 100n : (((60n) - 0) + 80n)) * ((360n) / (ceil(((360n) - 5p) / (10u))))) : 0)) / 1           ps=(((360n) / (ceil(((360n) - 5p) / (10u)))) < 119.5n) ? (((2 * (50n > (((60n) - 0) + 60n) ? 50n : (((60n) - 0) + 60n))) + 340n) + (floor(((ceil(((360n) - 5p) / (10u))) - 1) / 2.0) * ((2 * (((60n) - 0) + 60n)) + 440n)) + ((((ceil(((360n) - 5p) / (10u))) / 2) - floor((ceil(((360n) - 5p) / (10u))) / 2) == 0) ? ((2 * (50n > (((60n) - 0) + 60n) ? 50n : (((60n) - 0) + 60n))) + 340n) : 0)) / 1 : (((2 * (100n > (((60n) - 0) + 80n) ? 100n : (((60n) - 0) + 80n))) + (2 * ((360n) / (ceil(((360n) - 5p) / (10u)))))) + (floor(((ceil(((360n) - 5p) / (10u))) - 1) / 2.0) * ((2 * (60n > (((60n) - 0) + 50n) ? 60n : (((60n) - 0) + 50n))) + (2 * ((360n) / (ceil(((360n) - 5p) / (10u))))))) + ((((ceil(((360n) - 5p) / (10u))) / 2) - floor((ceil(((360n) - 5p) / (10u))) / 2) == 0) ? ((2 * (100n > (((60n) - 0) + 80n) ? 100n : (((60n) - 0) + 80n))) + (2 * ((360n) / (ceil(((360n) - 5p) / (10u)))))) : 0)) / 1           pd=(((360n) / (ceil(((360n) - 5p) / (10u)))) < 119.5n) ? ((floor((ceil(((360n) - 5p) / (10u))) / 2.0) * ((2 * (((60n) - 0) + 60n)) + 440n)) + ((((ceil(((360n) - 5p) / (10u))) / 2) - floor((ceil(((360n) - 5p) / (10u))) / 2) != 0) ? ((2 * (50n > (((60n) - 0) + 60n) ? 50n : (((60n) - 0) + 60n))) + 340n) : 0)) / 1 : ((floor((ceil(((360n) - 5p) / (10u))) / 2.0) * ((2 * (60n > (((60n) - 0) + 50n) ? 60n : (((60n) - 0) + 50n))) + (2 * ((360n) / (ceil(((360n) - 5p) / (10u))))))) + ((((ceil(((360n) - 5p) / (10u))) / 2) - floor((ceil(((360n) - 5p) / (10u))) / 2) != 0) ? ((2 * (100n > (((60n) - 0) + 80n) ? 100n : (((60n) - 0) + 80n))) + (2 * ((360n) / (ceil(((360n) - 5p) / (10u)))))) : 0)) / 1           nrd=(((360n) / (ceil(((360n) - 5p) / (10u)))) < 119.5n) ? ((floor((ceil(((360n) - 5p) / (10u))) / 2.0) * (((((60n) - 0) + 60n) * 120n) + (((360n) / (ceil(((360n) - 5p) / (10u)))) * 100n))) + ((((ceil(((360n) - 5p) / (10u))) / 2) - floor((ceil(((360n) - 5p) / (10u))) / 2) != 0) ? (((50n > (((60n) - 0) + 60n) ? 50n : (((60n) - 0) + 60n)) * 120n) + (((360n) / (ceil(((360n) - 5p) / (10u)))) * 50n)) : 0)) / 1 : ((floor((ceil(((360n) - 5p) / (10u))) / 2.0) * ((60n > (((60n) - 0) + 50n) ? 60n : (((60n) - 0) + 50n)) * ((360n) / (ceil(((360n) - 5p) / (10u)))))) + ((((ceil(((360n) - 5p) / (10u))) / 2) - floor((ceil(((360n) - 5p) / (10u))) / 2) != 0) ? ((100n > (((60n) - 0) + 80n) ? 100n : (((60n) - 0) + 80n)) * ((360n) / (ceil(((360n) - 5p) / (10u))))) : 0)) / 1 / (((360n) / (ceil(((360n) - 5p) / (10u)))) * (ceil(((360n) - 5p) / (10u))) * ((360n) / (ceil(((360n) - 5p) / (10u)))) * (ceil(((360n) - 5p) / (10u))))           nrs=(((360n) / (ceil(((360n) - 5p) / (10u)))) < 119.5n) ? ((((50n > (((60n) - 0) + 60n) ? 50n : (((60n) - 0) + 60n)) * 120n) + (((360n) / (ceil(((360n) - 5p) / (10u)))) * 50n)) + (floor(((ceil(((360n) - 5p) / (10u))) - 1) / 2.0) * (((((60n) - 0) + 60n) * 120n) + (((360n) / (ceil(((360n) - 5p) / (10u)))) * 100n))) + ((((ceil(((360n) - 5p) / (10u))) / 2) - floor((ceil(((360n) - 5p) / (10u))) / 2) == 0) ? (((50n > (((60n) - 0) + 60n) ? 50n : (((60n) - 0) + 60n)) * 120n) + (((360n) / (ceil(((360n) - 5p) / (10u)))) * 50n)) : 0)) / 1 : (((100n > (((60n) - 0) + 80n) ? 100n : (((60n) - 0) + 80n)) * ((360n) / (ceil(((360n) - 5p) / (10u))))) + (floor(((ceil(((360n) - 5p) / (10u))) - 1) / 2.0) * ((60n > (((60n) - 0) + 50n) ? 60n : (((60n) - 0) + 50n)) * ((360n) / (ceil(((360n) - 5p) / (10u)))))) + ((((ceil(((360n) - 5p) / (10u))) / 2) - floor((ceil(((360n) - 5p) / (10u))) / 2) == 0) ? ((100n > (((60n) - 0) + 80n) ? 100n : (((60n) - 0) + 80n)) * ((360n) / (ceil(((360n) - 5p) / (10u))))) : 0)) / 1 / (((360n) / (ceil(((360n) - 5p) / (10u)))) * (ceil(((360n) - 5p) / (10u))) * ((360n) / (ceil(((360n) - 5p) / (10u)))) * (ceil(((360n) - 5p) / (10u))))           sa=(((360n) / (ceil(((360n) - 5p) / (10u)))) < 119.5n) ? (50n > (((60n) - 0) + 60n) ? 50n : (((60n) - 0) + 60n)) + 5e-08 : (100n > (((60n) - 0) + 80n) ? 100n : (((60n) - 0) + 80n))           sb=(((360n) / (ceil(((360n) - 5p) / (10u)))) < 119.5n) ? (50n > (((60n) - 0) + 60n) ? 50n : (((60n) - 0) + 60n)) + 5e-08 : (100n > (((60n) - 0) + 80n) ? 100n : (((60n) - 0) + 80n))           sd=(((360n) / (ceil(((360n) - 5p) / (10u)))) < 119.5n) ? (((60n) - 0) + 60n) + (2*5e-08) : (60n > (((60n) - 0) + 50n) ? 60n : (((60n) - 0) + 50n))           sca=(( ((360n) / (ceil(((360n) - 5p) / (10u)))) * ( (((1u) * (1u) / ((((360n) / (ceil(((360n) - 5p) / (10u)))) < 119.5n) ? (50n > (((60n) - 0) + 60n) ? 50n : (((60n) - 0) + 60n)) + 5e-08 : (100n > (((60n) - 0) + 80n) ? 100n : (((60n) - 0) + 80n))+60n)) - ((1u) * (1u) / (((((360n) / (ceil(((360n) - 5p) / (10u)))) < 119.5n) ? (50n > (((60n) - 0) + 60n) ? 50n : (((60n) - 0) + 60n)) + 5e-08 : (100n > (((60n) - 0) + 80n) ? 100n : (((60n) - 0) + 80n))+60n)+(45n)))) + ((1u) * (1u) / ((((360n) / (ceil(((360n) - 5p) / (10u)))) < 119.5n) ? (50n > (((60n) - 0) + 60n) ? 50n : (((60n) - 0) + 60n)) + 5e-08 : (100n > (((60n) - 0) + 80n) ? 100n : (((60n) - 0) + 80n))+60n)) - ((1u) * (1u)/ (((((360n) / (ceil(((360n) - 5p) / (10u)))) < 119.5n) ? (50n > (((60n) - 0) + 60n) ? 50n : (((60n) - 0) + 60n)) + 5e-08 : (100n > (((60n) - 0) + 80n) ? 100n : (((60n) - 0) + 80n))+60n)+(45n))))) + ( (45n) * ( (((1u) * (1u) / (60n)) - ((1u) * (1u) / ((60n)+((360n) / (ceil(((360n) - 5p) / (10u))))))) + ((1u) * (1u) / (60n)) - ((1u) * (1u)/ ((60n)+((360n) / (ceil(((360n) - 5p) / (10u))))))))) / (((360n) / (ceil(((360n) - 5p) / (10u)))) * (45n))           scb=((((360n) / (ceil(((360n) - 5p) / (10u)))) * ((((((360n) / (ceil(((360n) - 5p) / (10u)))) < 119.5n) ? (50n > (((60n) - 0) + 60n) ? 50n : (((60n) - 0) + 60n)) + 5e-08 : (100n > (((60n) - 0) + 80n) ? 100n : (((60n) - 0) + 80n))+60n)/10 + (1u)/100)*exp(-10 * ((((360n) / (ceil(((360n) - 5p) / (10u)))) < 119.5n) ? (50n > (((60n) - 0) + 60n) ? 50n : (((60n) - 0) + 60n)) + 5e-08 : (100n > (((60n) - 0) + 80n) ? 100n : (((60n) - 0) + 80n))+60n) / (1u)) - ((((((360n) / (ceil(((360n) - 5p) / (10u)))) < 119.5n) ? (50n > (((60n) - 0) + 60n) ? 50n : (((60n) - 0) + 60n)) + 5e-08 : (100n > (((60n) - 0) + 80n) ? 100n : (((60n) - 0) + 80n))+60n)+(45n))/10 + (1u)/100)*exp(-10 * (((((360n) / (ceil(((360n) - 5p) / (10u)))) < 119.5n) ? (50n > (((60n) - 0) + 60n) ? 50n : (((60n) - 0) + 60n)) + 5e-08 : (100n > (((60n) - 0) + 80n) ? 100n : (((60n) - 0) + 80n))+60n)+(45n)) / (1u)) + (((((360n) / (ceil(((360n) - 5p) / (10u)))) < 119.5n) ? (50n > (((60n) - 0) + 60n) ? 50n : (((60n) - 0) + 60n)) + 5e-08 : (100n > (((60n) - 0) + 80n) ? 100n : (((60n) - 0) + 80n))+60n)/10 + (1u)/100)*exp(-10 * ((((360n) / (ceil(((360n) - 5p) / (10u)))) < 119.5n) ? (50n > (((60n) - 0) + 60n) ? 50n : (((60n) - 0) + 60n)) + 5e-08 : (100n > (((60n) - 0) + 80n) ? 100n : (((60n) - 0) + 80n))+60n) / (1u)) - ((((((360n) / (ceil(((360n) - 5p) / (10u)))) < 119.5n) ? (50n > (((60n) - 0) + 60n) ? 50n : (((60n) - 0) + 60n)) + 5e-08 : (100n > (((60n) - 0) + 80n) ? 100n : (((60n) - 0) + 80n))+60n)+(45n))/10 + (1u)/100)*exp(-10 * (((((360n) / (ceil(((360n) - 5p) / (10u)))) < 119.5n) ? (50n > (((60n) - 0) + 60n) ? 50n : (((60n) - 0) + 60n)) + 5e-08 : (100n > (((60n) - 0) + 80n) ? 100n : (((60n) - 0) + 80n))+60n)+(45n)) / (1u)))) + ((45n) * (((60n)/10 + (1u)/100)*exp(-10 * (60n) / (1u)) - (((60n)+((360n) / (ceil(((360n) - 5p) / (10u)))))/10 + (1u)/100)*exp(-10 * ((60n)+((360n) / (ceil(((360n) - 5p) / (10u))))) / (1u)) + ((60n)/10 + (1u)/100)*exp(-10 * (60n) / (1u)) - (((60n)+((360n) / (ceil(((360n) - 5p) / (10u)))))/10 + (1u)/100)*exp(-10 * ((60n)+((360n) / (ceil(((360n) - 5p) / (10u))))) / (1u))))) / (((360n) / (ceil(((360n) - 5p) / (10u)))) * (45n))           scc=((((360n) / (ceil(((360n) - 5p) / (10u)))) * ((((((360n) / (ceil(((360n) - 5p) / (10u)))) < 119.5n) ? (50n > (((60n) - 0) + 60n) ? 50n : (((60n) - 0) + 60n)) + 5e-08 : (100n > (((60n) - 0) + 80n) ? 100n : (((60n) - 0) + 80n))+60n)/20 + (1u)/400)*exp(-20 * ((((360n) / (ceil(((360n) - 5p) / (10u)))) < 119.5n) ? (50n > (((60n) - 0) + 60n) ? 50n : (((60n) - 0) + 60n)) + 5e-08 : (100n > (((60n) - 0) + 80n) ? 100n : (((60n) - 0) + 80n))+60n) / (1u)) - ((((((360n) / (ceil(((360n) - 5p) / (10u)))) < 119.5n) ? (50n > (((60n) - 0) + 60n) ? 50n : (((60n) - 0) + 60n)) + 5e-08 : (100n > (((60n) - 0) + 80n) ? 100n : (((60n) - 0) + 80n))+60n)+(45n))/20 + (1u)/400)*exp(-20 * (((((360n) / (ceil(((360n) - 5p) / (10u)))) < 119.5n) ? (50n > (((60n) - 0) + 60n) ? 50n : (((60n) - 0) + 60n)) + 5e-08 : (100n > (((60n) - 0) + 80n) ? 100n : (((60n) - 0) + 80n))+60n)+(45n)) / (1u)) + (((((360n) / (ceil(((360n) - 5p) / (10u)))) < 119.5n) ? (50n > (((60n) - 0) + 60n) ? 50n : (((60n) - 0) + 60n)) + 5e-08 : (100n > (((60n) - 0) + 80n) ? 100n : (((60n) - 0) + 80n))+60n)/20 + (1u)/400)*exp(-20 * ((((360n) / (ceil(((360n) - 5p) / (10u)))) < 119.5n) ? (50n > (((60n) - 0) + 60n) ? 50n : (((60n) - 0) + 60n)) + 5e-08 : (100n > (((60n) - 0) + 80n) ? 100n : (((60n) - 0) + 80n))+60n) / (1u)) - ((((((360n) / (ceil(((360n) - 5p) / (10u)))) < 119.5n) ? (50n > (((60n) - 0) + 60n) ? 50n : (((60n) - 0) + 60n)) + 5e-08 : (100n > (((60n) - 0) + 80n) ? 100n : (((60n) - 0) + 80n))+60n)+(45n))/20 + (1u)/400)*exp(-20 * (((((360n) / (ceil(((360n) - 5p) / (10u)))) < 119.5n) ? (50n > (((60n) - 0) + 60n) ? 50n : (((60n) - 0) + 60n)) + 5e-08 : (100n > (((60n) - 0) + 80n) ? 100n : (((60n) - 0) + 80n))+60n)+(45n)) / (1u)))) + ((45n) * (((60n)/20 + (1u)/400)*exp(-20 * (60n) / (1u)) - (((60n)+((360n) / (ceil(((360n) - 5p) / (10u)))))/20 + (1u)/400)*exp(-20 * ((60n)+((360n) / (ceil(((360n) - 5p) / (10u))))) / (1u)) + ((60n)/20 + (1u)/400)*exp(-20 * (60n) / (1u)) - (((60n)+((360n) / (ceil(((360n) - 5p) / (10u)))))/20 + (1u)/400)*exp(-20 * ((60n)+((360n) / (ceil(((360n) - 5p) / (10u))))) / (1u))))) / (((360n) / (ceil(((360n) - 5p) / (10u)))) * (45n))           m=(1)
NM1 (Q Q_bar GND GND) g45n1svt w=(360n) l=45n nf=ceil(((360n) - 5p) / (10u))           as=(((360n) / (ceil(((360n) - 5p) / (10u)))) < 119.5n) ? ((((50n > (((60n) - 0) + 60n) ? 50n : (((60n) - 0) + 60n)) * 120n) + (((360n) / (ceil(((360n) - 5p) / (10u)))) * 50n)) + (floor(((ceil(((360n) - 5p) / (10u))) - 1) / 2.0) * (((((60n) - 0) + 60n) * 120n) + (((360n) / (ceil(((360n) - 5p) / (10u)))) * 100n))) + ((((ceil(((360n) - 5p) / (10u))) / 2) - floor((ceil(((360n) - 5p) / (10u))) / 2) == 0) ? (((50n > (((60n) - 0) + 60n) ? 50n : (((60n) - 0) + 60n)) * 120n) + (((360n) / (ceil(((360n) - 5p) / (10u)))) * 50n)) : 0)) / 1 : (((100n > (((60n) - 0) + 80n) ? 100n : (((60n) - 0) + 80n)) * ((360n) / (ceil(((360n) - 5p) / (10u))))) + (floor(((ceil(((360n) - 5p) / (10u))) - 1) / 2.0) * ((60n > (((60n) - 0) + 50n) ? 60n : (((60n) - 0) + 50n)) * ((360n) / (ceil(((360n) - 5p) / (10u)))))) + ((((ceil(((360n) - 5p) / (10u))) / 2) - floor((ceil(((360n) - 5p) / (10u))) / 2) == 0) ? ((100n > (((60n) - 0) + 80n) ? 100n : (((60n) - 0) + 80n)) * ((360n) / (ceil(((360n) - 5p) / (10u))))) : 0)) / 1           ad=(((360n) / (ceil(((360n) - 5p) / (10u)))) < 119.5n) ? ((floor((ceil(((360n) - 5p) / (10u))) / 2.0) * (((((60n) - 0) + 60n) * 120n) + (((360n) / (ceil(((360n) - 5p) / (10u)))) * 100n))) + ((((ceil(((360n) - 5p) / (10u))) / 2) - floor((ceil(((360n) - 5p) / (10u))) / 2) != 0) ? (((50n > (((60n) - 0) + 60n) ? 50n : (((60n) - 0) + 60n)) * 120n) + (((360n) / (ceil(((360n) - 5p) / (10u)))) * 50n)) : 0)) / 1 : ((floor((ceil(((360n) - 5p) / (10u))) / 2.0) * ((60n > (((60n) - 0) + 50n) ? 60n : (((60n) - 0) + 50n)) * ((360n) / (ceil(((360n) - 5p) / (10u)))))) + ((((ceil(((360n) - 5p) / (10u))) / 2) - floor((ceil(((360n) - 5p) / (10u))) / 2) != 0) ? ((100n > (((60n) - 0) + 80n) ? 100n : (((60n) - 0) + 80n)) * ((360n) / (ceil(((360n) - 5p) / (10u))))) : 0)) / 1           ps=(((360n) / (ceil(((360n) - 5p) / (10u)))) < 119.5n) ? (((2 * (50n > (((60n) - 0) + 60n) ? 50n : (((60n) - 0) + 60n))) + 340n) + (floor(((ceil(((360n) - 5p) / (10u))) - 1) / 2.0) * ((2 * (((60n) - 0) + 60n)) + 440n)) + ((((ceil(((360n) - 5p) / (10u))) / 2) - floor((ceil(((360n) - 5p) / (10u))) / 2) == 0) ? ((2 * (50n > (((60n) - 0) + 60n) ? 50n : (((60n) - 0) + 60n))) + 340n) : 0)) / 1 : (((2 * (100n > (((60n) - 0) + 80n) ? 100n : (((60n) - 0) + 80n))) + (2 * ((360n) / (ceil(((360n) - 5p) / (10u)))))) + (floor(((ceil(((360n) - 5p) / (10u))) - 1) / 2.0) * ((2 * (60n > (((60n) - 0) + 50n) ? 60n : (((60n) - 0) + 50n))) + (2 * ((360n) / (ceil(((360n) - 5p) / (10u))))))) + ((((ceil(((360n) - 5p) / (10u))) / 2) - floor((ceil(((360n) - 5p) / (10u))) / 2) == 0) ? ((2 * (100n > (((60n) - 0) + 80n) ? 100n : (((60n) - 0) + 80n))) + (2 * ((360n) / (ceil(((360n) - 5p) / (10u)))))) : 0)) / 1           pd=(((360n) / (ceil(((360n) - 5p) / (10u)))) < 119.5n) ? ((floor((ceil(((360n) - 5p) / (10u))) / 2.0) * ((2 * (((60n) - 0) + 60n)) + 440n)) + ((((ceil(((360n) - 5p) / (10u))) / 2) - floor((ceil(((360n) - 5p) / (10u))) / 2) != 0) ? ((2 * (50n > (((60n) - 0) + 60n) ? 50n : (((60n) - 0) + 60n))) + 340n) : 0)) / 1 : ((floor((ceil(((360n) - 5p) / (10u))) / 2.0) * ((2 * (60n > (((60n) - 0) + 50n) ? 60n : (((60n) - 0) + 50n))) + (2 * ((360n) / (ceil(((360n) - 5p) / (10u))))))) + ((((ceil(((360n) - 5p) / (10u))) / 2) - floor((ceil(((360n) - 5p) / (10u))) / 2) != 0) ? ((2 * (100n > (((60n) - 0) + 80n) ? 100n : (((60n) - 0) + 80n))) + (2 * ((360n) / (ceil(((360n) - 5p) / (10u)))))) : 0)) / 1           nrd=(((360n) / (ceil(((360n) - 5p) / (10u)))) < 119.5n) ? ((floor((ceil(((360n) - 5p) / (10u))) / 2.0) * (((((60n) - 0) + 60n) * 120n) + (((360n) / (ceil(((360n) - 5p) / (10u)))) * 100n))) + ((((ceil(((360n) - 5p) / (10u))) / 2) - floor((ceil(((360n) - 5p) / (10u))) / 2) != 0) ? (((50n > (((60n) - 0) + 60n) ? 50n : (((60n) - 0) + 60n)) * 120n) + (((360n) / (ceil(((360n) - 5p) / (10u)))) * 50n)) : 0)) / 1 : ((floor((ceil(((360n) - 5p) / (10u))) / 2.0) * ((60n > (((60n) - 0) + 50n) ? 60n : (((60n) - 0) + 50n)) * ((360n) / (ceil(((360n) - 5p) / (10u)))))) + ((((ceil(((360n) - 5p) / (10u))) / 2) - floor((ceil(((360n) - 5p) / (10u))) / 2) != 0) ? ((100n > (((60n) - 0) + 80n) ? 100n : (((60n) - 0) + 80n)) * ((360n) / (ceil(((360n) - 5p) / (10u))))) : 0)) / 1 / (((360n) / (ceil(((360n) - 5p) / (10u)))) * (ceil(((360n) - 5p) / (10u))) * ((360n) / (ceil(((360n) - 5p) / (10u)))) * (ceil(((360n) - 5p) / (10u))))           nrs=(((360n) / (ceil(((360n) - 5p) / (10u)))) < 119.5n) ? ((((50n > (((60n) - 0) + 60n) ? 50n : (((60n) - 0) + 60n)) * 120n) + (((360n) / (ceil(((360n) - 5p) / (10u)))) * 50n)) + (floor(((ceil(((360n) - 5p) / (10u))) - 1) / 2.0) * (((((60n) - 0) + 60n) * 120n) + (((360n) / (ceil(((360n) - 5p) / (10u)))) * 100n))) + ((((ceil(((360n) - 5p) / (10u))) / 2) - floor((ceil(((360n) - 5p) / (10u))) / 2) == 0) ? (((50n > (((60n) - 0) + 60n) ? 50n : (((60n) - 0) + 60n)) * 120n) + (((360n) / (ceil(((360n) - 5p) / (10u)))) * 50n)) : 0)) / 1 : (((100n > (((60n) - 0) + 80n) ? 100n : (((60n) - 0) + 80n)) * ((360n) / (ceil(((360n) - 5p) / (10u))))) + (floor(((ceil(((360n) - 5p) / (10u))) - 1) / 2.0) * ((60n > (((60n) - 0) + 50n) ? 60n : (((60n) - 0) + 50n)) * ((360n) / (ceil(((360n) - 5p) / (10u)))))) + ((((ceil(((360n) - 5p) / (10u))) / 2) - floor((ceil(((360n) - 5p) / (10u))) / 2) == 0) ? ((100n > (((60n) - 0) + 80n) ? 100n : (((60n) - 0) + 80n)) * ((360n) / (ceil(((360n) - 5p) / (10u))))) : 0)) / 1 / (((360n) / (ceil(((360n) - 5p) / (10u)))) * (ceil(((360n) - 5p) / (10u))) * ((360n) / (ceil(((360n) - 5p) / (10u)))) * (ceil(((360n) - 5p) / (10u))))           sa=(((360n) / (ceil(((360n) - 5p) / (10u)))) < 119.5n) ? (50n > (((60n) - 0) + 60n) ? 50n : (((60n) - 0) + 60n)) + 5e-08 : (100n > (((60n) - 0) + 80n) ? 100n : (((60n) - 0) + 80n))           sb=(((360n) / (ceil(((360n) - 5p) / (10u)))) < 119.5n) ? (50n > (((60n) - 0) + 60n) ? 50n : (((60n) - 0) + 60n)) + 5e-08 : (100n > (((60n) - 0) + 80n) ? 100n : (((60n) - 0) + 80n))           sd=(((360n) / (ceil(((360n) - 5p) / (10u)))) < 119.5n) ? (((60n) - 0) + 60n) + (2*5e-08) : (60n > (((60n) - 0) + 50n) ? 60n : (((60n) - 0) + 50n))           sca=(( ((360n) / (ceil(((360n) - 5p) / (10u)))) * ( (((1u) * (1u) / ((((360n) / (ceil(((360n) - 5p) / (10u)))) < 119.5n) ? (50n > (((60n) - 0) + 60n) ? 50n : (((60n) - 0) + 60n)) + 5e-08 : (100n > (((60n) - 0) + 80n) ? 100n : (((60n) - 0) + 80n))+60n)) - ((1u) * (1u) / (((((360n) / (ceil(((360n) - 5p) / (10u)))) < 119.5n) ? (50n > (((60n) - 0) + 60n) ? 50n : (((60n) - 0) + 60n)) + 5e-08 : (100n > (((60n) - 0) + 80n) ? 100n : (((60n) - 0) + 80n))+60n)+(45n)))) + ((1u) * (1u) / ((((360n) / (ceil(((360n) - 5p) / (10u)))) < 119.5n) ? (50n > (((60n) - 0) + 60n) ? 50n : (((60n) - 0) + 60n)) + 5e-08 : (100n > (((60n) - 0) + 80n) ? 100n : (((60n) - 0) + 80n))+60n)) - ((1u) * (1u)/ (((((360n) / (ceil(((360n) - 5p) / (10u)))) < 119.5n) ? (50n > (((60n) - 0) + 60n) ? 50n : (((60n) - 0) + 60n)) + 5e-08 : (100n > (((60n) - 0) + 80n) ? 100n : (((60n) - 0) + 80n))+60n)+(45n))))) + ( (45n) * ( (((1u) * (1u) / (60n)) - ((1u) * (1u) / ((60n)+((360n) / (ceil(((360n) - 5p) / (10u))))))) + ((1u) * (1u) / (60n)) - ((1u) * (1u)/ ((60n)+((360n) / (ceil(((360n) - 5p) / (10u))))))))) / (((360n) / (ceil(((360n) - 5p) / (10u)))) * (45n))           scb=((((360n) / (ceil(((360n) - 5p) / (10u)))) * ((((((360n) / (ceil(((360n) - 5p) / (10u)))) < 119.5n) ? (50n > (((60n) - 0) + 60n) ? 50n : (((60n) - 0) + 60n)) + 5e-08 : (100n > (((60n) - 0) + 80n) ? 100n : (((60n) - 0) + 80n))+60n)/10 + (1u)/100)*exp(-10 * ((((360n) / (ceil(((360n) - 5p) / (10u)))) < 119.5n) ? (50n > (((60n) - 0) + 60n) ? 50n : (((60n) - 0) + 60n)) + 5e-08 : (100n > (((60n) - 0) + 80n) ? 100n : (((60n) - 0) + 80n))+60n) / (1u)) - ((((((360n) / (ceil(((360n) - 5p) / (10u)))) < 119.5n) ? (50n > (((60n) - 0) + 60n) ? 50n : (((60n) - 0) + 60n)) + 5e-08 : (100n > (((60n) - 0) + 80n) ? 100n : (((60n) - 0) + 80n))+60n)+(45n))/10 + (1u)/100)*exp(-10 * (((((360n) / (ceil(((360n) - 5p) / (10u)))) < 119.5n) ? (50n > (((60n) - 0) + 60n) ? 50n : (((60n) - 0) + 60n)) + 5e-08 : (100n > (((60n) - 0) + 80n) ? 100n : (((60n) - 0) + 80n))+60n)+(45n)) / (1u)) + (((((360n) / (ceil(((360n) - 5p) / (10u)))) < 119.5n) ? (50n > (((60n) - 0) + 60n) ? 50n : (((60n) - 0) + 60n)) + 5e-08 : (100n > (((60n) - 0) + 80n) ? 100n : (((60n) - 0) + 80n))+60n)/10 + (1u)/100)*exp(-10 * ((((360n) / (ceil(((360n) - 5p) / (10u)))) < 119.5n) ? (50n > (((60n) - 0) + 60n) ? 50n : (((60n) - 0) + 60n)) + 5e-08 : (100n > (((60n) - 0) + 80n) ? 100n : (((60n) - 0) + 80n))+60n) / (1u)) - ((((((360n) / (ceil(((360n) - 5p) / (10u)))) < 119.5n) ? (50n > (((60n) - 0) + 60n) ? 50n : (((60n) - 0) + 60n)) + 5e-08 : (100n > (((60n) - 0) + 80n) ? 100n : (((60n) - 0) + 80n))+60n)+(45n))/10 + (1u)/100)*exp(-10 * (((((360n) / (ceil(((360n) - 5p) / (10u)))) < 119.5n) ? (50n > (((60n) - 0) + 60n) ? 50n : (((60n) - 0) + 60n)) + 5e-08 : (100n > (((60n) - 0) + 80n) ? 100n : (((60n) - 0) + 80n))+60n)+(45n)) / (1u)))) + ((45n) * (((60n)/10 + (1u)/100)*exp(-10 * (60n) / (1u)) - (((60n)+((360n) / (ceil(((360n) - 5p) / (10u)))))/10 + (1u)/100)*exp(-10 * ((60n)+((360n) / (ceil(((360n) - 5p) / (10u))))) / (1u)) + ((60n)/10 + (1u)/100)*exp(-10 * (60n) / (1u)) - (((60n)+((360n) / (ceil(((360n) - 5p) / (10u)))))/10 + (1u)/100)*exp(-10 * ((60n)+((360n) / (ceil(((360n) - 5p) / (10u))))) / (1u))))) / (((360n) / (ceil(((360n) - 5p) / (10u)))) * (45n))           scc=((((360n) / (ceil(((360n) - 5p) / (10u)))) * ((((((360n) / (ceil(((360n) - 5p) / (10u)))) < 119.5n) ? (50n > (((60n) - 0) + 60n) ? 50n : (((60n) - 0) + 60n)) + 5e-08 : (100n > (((60n) - 0) + 80n) ? 100n : (((60n) - 0) + 80n))+60n)/20 + (1u)/400)*exp(-20 * ((((360n) / (ceil(((360n) - 5p) / (10u)))) < 119.5n) ? (50n > (((60n) - 0) + 60n) ? 50n : (((60n) - 0) + 60n)) + 5e-08 : (100n > (((60n) - 0) + 80n) ? 100n : (((60n) - 0) + 80n))+60n) / (1u)) - ((((((360n) / (ceil(((360n) - 5p) / (10u)))) < 119.5n) ? (50n > (((60n) - 0) + 60n) ? 50n : (((60n) - 0) + 60n)) + 5e-08 : (100n > (((60n) - 0) + 80n) ? 100n : (((60n) - 0) + 80n))+60n)+(45n))/20 + (1u)/400)*exp(-20 * (((((360n) / (ceil(((360n) - 5p) / (10u)))) < 119.5n) ? (50n > (((60n) - 0) + 60n) ? 50n : (((60n) - 0) + 60n)) + 5e-08 : (100n > (((60n) - 0) + 80n) ? 100n : (((60n) - 0) + 80n))+60n)+(45n)) / (1u)) + (((((360n) / (ceil(((360n) - 5p) / (10u)))) < 119.5n) ? (50n > (((60n) - 0) + 60n) ? 50n : (((60n) - 0) + 60n)) + 5e-08 : (100n > (((60n) - 0) + 80n) ? 100n : (((60n) - 0) + 80n))+60n)/20 + (1u)/400)*exp(-20 * ((((360n) / (ceil(((360n) - 5p) / (10u)))) < 119.5n) ? (50n > (((60n) - 0) + 60n) ? 50n : (((60n) - 0) + 60n)) + 5e-08 : (100n > (((60n) - 0) + 80n) ? 100n : (((60n) - 0) + 80n))+60n) / (1u)) - ((((((360n) / (ceil(((360n) - 5p) / (10u)))) < 119.5n) ? (50n > (((60n) - 0) + 60n) ? 50n : (((60n) - 0) + 60n)) + 5e-08 : (100n > (((60n) - 0) + 80n) ? 100n : (((60n) - 0) + 80n))+60n)+(45n))/20 + (1u)/400)*exp(-20 * (((((360n) / (ceil(((360n) - 5p) / (10u)))) < 119.5n) ? (50n > (((60n) - 0) + 60n) ? 50n : (((60n) - 0) + 60n)) + 5e-08 : (100n > (((60n) - 0) + 80n) ? 100n : (((60n) - 0) + 80n))+60n)+(45n)) / (1u)))) + ((45n) * (((60n)/20 + (1u)/400)*exp(-20 * (60n) / (1u)) - (((60n)+((360n) / (ceil(((360n) - 5p) / (10u)))))/20 + (1u)/400)*exp(-20 * ((60n)+((360n) / (ceil(((360n) - 5p) / (10u))))) / (1u)) + ((60n)/20 + (1u)/400)*exp(-20 * (60n) / (1u)) - (((60n)+((360n) / (ceil(((360n) - 5p) / (10u)))))/20 + (1u)/400)*exp(-20 * ((60n)+((360n) / (ceil(((360n) - 5p) / (10u))))) / (1u))))) / (((360n) / (ceil(((360n) - 5p) / (10u)))) * (45n))           m=(1)
NM2 (Q_bar WL BL_bar GND) g45n1svt w=(240n) l=45n nf=ceil(((240n) - 5p) / (10u))           as=(((240n) / (ceil(((240n) - 5p) / (10u)))) < 119.5n) ? ((((50n > (((60n) - 0) + 60n) ? 50n : (((60n) - 0) + 60n)) * 120n) + (((240n) / (ceil(((240n) - 5p) / (10u)))) * 50n)) + (floor(((ceil(((240n) - 5p) / (10u))) - 1) / 2.0) * (((((60n) - 0) + 60n) * 120n) + (((240n) / (ceil(((240n) - 5p) / (10u)))) * 100n))) + ((((ceil(((240n) - 5p) / (10u))) / 2) - floor((ceil(((240n) - 5p) / (10u))) / 2) == 0) ? (((50n > (((60n) - 0) + 60n) ? 50n : (((60n) - 0) + 60n)) * 120n) + (((240n) / (ceil(((240n) - 5p) / (10u)))) * 50n)) : 0)) / 1 : (((100n > (((60n) - 0) + 80n) ? 100n : (((60n) - 0) + 80n)) * ((240n) / (ceil(((240n) - 5p) / (10u))))) + (floor(((ceil(((240n) - 5p) / (10u))) - 1) / 2.0) * ((60n > (((60n) - 0) + 50n) ? 60n : (((60n) - 0) + 50n)) * ((240n) / (ceil(((240n) - 5p) / (10u)))))) + ((((ceil(((240n) - 5p) / (10u))) / 2) - floor((ceil(((240n) - 5p) / (10u))) / 2) == 0) ? ((100n > (((60n) - 0) + 80n) ? 100n : (((60n) - 0) + 80n)) * ((240n) / (ceil(((240n) - 5p) / (10u))))) : 0)) / 1           ad=(((240n) / (ceil(((240n) - 5p) / (10u)))) < 119.5n) ? ((floor((ceil(((240n) - 5p) / (10u))) / 2.0) * (((((60n) - 0) + 60n) * 120n) + (((240n) / (ceil(((240n) - 5p) / (10u)))) * 100n))) + ((((ceil(((240n) - 5p) / (10u))) / 2) - floor((ceil(((240n) - 5p) / (10u))) / 2) != 0) ? (((50n > (((60n) - 0) + 60n) ? 50n : (((60n) - 0) + 60n)) * 120n) + (((240n) / (ceil(((240n) - 5p) / (10u)))) * 50n)) : 0)) / 1 : ((floor((ceil(((240n) - 5p) / (10u))) / 2.0) * ((60n > (((60n) - 0) + 50n) ? 60n : (((60n) - 0) + 50n)) * ((240n) / (ceil(((240n) - 5p) / (10u)))))) + ((((ceil(((240n) - 5p) / (10u))) / 2) - floor((ceil(((240n) - 5p) / (10u))) / 2) != 0) ? ((100n > (((60n) - 0) + 80n) ? 100n : (((60n) - 0) + 80n)) * ((240n) / (ceil(((240n) - 5p) / (10u))))) : 0)) / 1           ps=(((240n) / (ceil(((240n) - 5p) / (10u)))) < 119.5n) ? (((2 * (50n > (((60n) - 0) + 60n) ? 50n : (((60n) - 0) + 60n))) + 340n) + (floor(((ceil(((240n) - 5p) / (10u))) - 1) / 2.0) * ((2 * (((60n) - 0) + 60n)) + 440n)) + ((((ceil(((240n) - 5p) / (10u))) / 2) - floor((ceil(((240n) - 5p) / (10u))) / 2) == 0) ? ((2 * (50n > (((60n) - 0) + 60n) ? 50n : (((60n) - 0) + 60n))) + 340n) : 0)) / 1 : (((2 * (100n > (((60n) - 0) + 80n) ? 100n : (((60n) - 0) + 80n))) + (2 * ((240n) / (ceil(((240n) - 5p) / (10u)))))) + (floor(((ceil(((240n) - 5p) / (10u))) - 1) / 2.0) * ((2 * (60n > (((60n) - 0) + 50n) ? 60n : (((60n) - 0) + 50n))) + (2 * ((240n) / (ceil(((240n) - 5p) / (10u))))))) + ((((ceil(((240n) - 5p) / (10u))) / 2) - floor((ceil(((240n) - 5p) / (10u))) / 2) == 0) ? ((2 * (100n > (((60n) - 0) + 80n) ? 100n : (((60n) - 0) + 80n))) + (2 * ((240n) / (ceil(((240n) - 5p) / (10u)))))) : 0)) / 1           pd=(((240n) / (ceil(((240n) - 5p) / (10u)))) < 119.5n) ? ((floor((ceil(((240n) - 5p) / (10u))) / 2.0) * ((2 * (((60n) - 0) + 60n)) + 440n)) + ((((ceil(((240n) - 5p) / (10u))) / 2) - floor((ceil(((240n) - 5p) / (10u))) / 2) != 0) ? ((2 * (50n > (((60n) - 0) + 60n) ? 50n : (((60n) - 0) + 60n))) + 340n) : 0)) / 1 : ((floor((ceil(((240n) - 5p) / (10u))) / 2.0) * ((2 * (60n > (((60n) - 0) + 50n) ? 60n : (((60n) - 0) + 50n))) + (2 * ((240n) / (ceil(((240n) - 5p) / (10u))))))) + ((((ceil(((240n) - 5p) / (10u))) / 2) - floor((ceil(((240n) - 5p) / (10u))) / 2) != 0) ? ((2 * (100n > (((60n) - 0) + 80n) ? 100n : (((60n) - 0) + 80n))) + (2 * ((240n) / (ceil(((240n) - 5p) / (10u)))))) : 0)) / 1           nrd=(((240n) / (ceil(((240n) - 5p) / (10u)))) < 119.5n) ? ((floor((ceil(((240n) - 5p) / (10u))) / 2.0) * (((((60n) - 0) + 60n) * 120n) + (((240n) / (ceil(((240n) - 5p) / (10u)))) * 100n))) + ((((ceil(((240n) - 5p) / (10u))) / 2) - floor((ceil(((240n) - 5p) / (10u))) / 2) != 0) ? (((50n > (((60n) - 0) + 60n) ? 50n : (((60n) - 0) + 60n)) * 120n) + (((240n) / (ceil(((240n) - 5p) / (10u)))) * 50n)) : 0)) / 1 : ((floor((ceil(((240n) - 5p) / (10u))) / 2.0) * ((60n > (((60n) - 0) + 50n) ? 60n : (((60n) - 0) + 50n)) * ((240n) / (ceil(((240n) - 5p) / (10u)))))) + ((((ceil(((240n) - 5p) / (10u))) / 2) - floor((ceil(((240n) - 5p) / (10u))) / 2) != 0) ? ((100n > (((60n) - 0) + 80n) ? 100n : (((60n) - 0) + 80n)) * ((240n) / (ceil(((240n) - 5p) / (10u))))) : 0)) / 1 / (((240n) / (ceil(((240n) - 5p) / (10u)))) * (ceil(((240n) - 5p) / (10u))) * ((240n) / (ceil(((240n) - 5p) / (10u)))) * (ceil(((240n) - 5p) / (10u))))           nrs=(((240n) / (ceil(((240n) - 5p) / (10u)))) < 119.5n) ? ((((50n > (((60n) - 0) + 60n) ? 50n : (((60n) - 0) + 60n)) * 120n) + (((240n) / (ceil(((240n) - 5p) / (10u)))) * 50n)) + (floor(((ceil(((240n) - 5p) / (10u))) - 1) / 2.0) * (((((60n) - 0) + 60n) * 120n) + (((240n) / (ceil(((240n) - 5p) / (10u)))) * 100n))) + ((((ceil(((240n) - 5p) / (10u))) / 2) - floor((ceil(((240n) - 5p) / (10u))) / 2) == 0) ? (((50n > (((60n) - 0) + 60n) ? 50n : (((60n) - 0) + 60n)) * 120n) + (((240n) / (ceil(((240n) - 5p) / (10u)))) * 50n)) : 0)) / 1 : (((100n > (((60n) - 0) + 80n) ? 100n : (((60n) - 0) + 80n)) * ((240n) / (ceil(((240n) - 5p) / (10u))))) + (floor(((ceil(((240n) - 5p) / (10u))) - 1) / 2.0) * ((60n > (((60n) - 0) + 50n) ? 60n : (((60n) - 0) + 50n)) * ((240n) / (ceil(((240n) - 5p) / (10u)))))) + ((((ceil(((240n) - 5p) / (10u))) / 2) - floor((ceil(((240n) - 5p) / (10u))) / 2) == 0) ? ((100n > (((60n) - 0) + 80n) ? 100n : (((60n) - 0) + 80n)) * ((240n) / (ceil(((240n) - 5p) / (10u))))) : 0)) / 1 / (((240n) / (ceil(((240n) - 5p) / (10u)))) * (ceil(((240n) - 5p) / (10u))) * ((240n) / (ceil(((240n) - 5p) / (10u)))) * (ceil(((240n) - 5p) / (10u))))           sa=(((240n) / (ceil(((240n) - 5p) / (10u)))) < 119.5n) ? (50n > (((60n) - 0) + 60n) ? 50n : (((60n) - 0) + 60n)) + 5e-08 : (100n > (((60n) - 0) + 80n) ? 100n : (((60n) - 0) + 80n))           sb=(((240n) / (ceil(((240n) - 5p) / (10u)))) < 119.5n) ? (50n > (((60n) - 0) + 60n) ? 50n : (((60n) - 0) + 60n)) + 5e-08 : (100n > (((60n) - 0) + 80n) ? 100n : (((60n) - 0) + 80n))           sd=(((240n) / (ceil(((240n) - 5p) / (10u)))) < 119.5n) ? (((60n) - 0) + 60n) + (2*5e-08) : (60n > (((60n) - 0) + 50n) ? 60n : (((60n) - 0) + 50n))           sca=(( ((240n) / (ceil(((240n) - 5p) / (10u)))) * ( (((1u) * (1u) / ((((240n) / (ceil(((240n) - 5p) / (10u)))) < 119.5n) ? (50n > (((60n) - 0) + 60n) ? 50n : (((60n) - 0) + 60n)) + 5e-08 : (100n > (((60n) - 0) + 80n) ? 100n : (((60n) - 0) + 80n))+60n)) - ((1u) * (1u) / (((((240n) / (ceil(((240n) - 5p) / (10u)))) < 119.5n) ? (50n > (((60n) - 0) + 60n) ? 50n : (((60n) - 0) + 60n)) + 5e-08 : (100n > (((60n) - 0) + 80n) ? 100n : (((60n) - 0) + 80n))+60n)+(45n)))) + ((1u) * (1u) / ((((240n) / (ceil(((240n) - 5p) / (10u)))) < 119.5n) ? (50n > (((60n) - 0) + 60n) ? 50n : (((60n) - 0) + 60n)) + 5e-08 : (100n > (((60n) - 0) + 80n) ? 100n : (((60n) - 0) + 80n))+60n)) - ((1u) * (1u)/ (((((240n) / (ceil(((240n) - 5p) / (10u)))) < 119.5n) ? (50n > (((60n) - 0) + 60n) ? 50n : (((60n) - 0) + 60n)) + 5e-08 : (100n > (((60n) - 0) + 80n) ? 100n : (((60n) - 0) + 80n))+60n)+(45n))))) + ( (45n) * ( (((1u) * (1u) / (60n)) - ((1u) * (1u) / ((60n)+((240n) / (ceil(((240n) - 5p) / (10u))))))) + ((1u) * (1u) / (60n)) - ((1u) * (1u)/ ((60n)+((240n) / (ceil(((240n) - 5p) / (10u))))))))) / (((240n) / (ceil(((240n) - 5p) / (10u)))) * (45n))           scb=((((240n) / (ceil(((240n) - 5p) / (10u)))) * ((((((240n) / (ceil(((240n) - 5p) / (10u)))) < 119.5n) ? (50n > (((60n) - 0) + 60n) ? 50n : (((60n) - 0) + 60n)) + 5e-08 : (100n > (((60n) - 0) + 80n) ? 100n : (((60n) - 0) + 80n))+60n)/10 + (1u)/100)*exp(-10 * ((((240n) / (ceil(((240n) - 5p) / (10u)))) < 119.5n) ? (50n > (((60n) - 0) + 60n) ? 50n : (((60n) - 0) + 60n)) + 5e-08 : (100n > (((60n) - 0) + 80n) ? 100n : (((60n) - 0) + 80n))+60n) / (1u)) - ((((((240n) / (ceil(((240n) - 5p) / (10u)))) < 119.5n) ? (50n > (((60n) - 0) + 60n) ? 50n : (((60n) - 0) + 60n)) + 5e-08 : (100n > (((60n) - 0) + 80n) ? 100n : (((60n) - 0) + 80n))+60n)+(45n))/10 + (1u)/100)*exp(-10 * (((((240n) / (ceil(((240n) - 5p) / (10u)))) < 119.5n) ? (50n > (((60n) - 0) + 60n) ? 50n : (((60n) - 0) + 60n)) + 5e-08 : (100n > (((60n) - 0) + 80n) ? 100n : (((60n) - 0) + 80n))+60n)+(45n)) / (1u)) + (((((240n) / (ceil(((240n) - 5p) / (10u)))) < 119.5n) ? (50n > (((60n) - 0) + 60n) ? 50n : (((60n) - 0) + 60n)) + 5e-08 : (100n > (((60n) - 0) + 80n) ? 100n : (((60n) - 0) + 80n))+60n)/10 + (1u)/100)*exp(-10 * ((((240n) / (ceil(((240n) - 5p) / (10u)))) < 119.5n) ? (50n > (((60n) - 0) + 60n) ? 50n : (((60n) - 0) + 60n)) + 5e-08 : (100n > (((60n) - 0) + 80n) ? 100n : (((60n) - 0) + 80n))+60n) / (1u)) - ((((((240n) / (ceil(((240n) - 5p) / (10u)))) < 119.5n) ? (50n > (((60n) - 0) + 60n) ? 50n : (((60n) - 0) + 60n)) + 5e-08 : (100n > (((60n) - 0) + 80n) ? 100n : (((60n) - 0) + 80n))+60n)+(45n))/10 + (1u)/100)*exp(-10 * (((((240n) / (ceil(((240n) - 5p) / (10u)))) < 119.5n) ? (50n > (((60n) - 0) + 60n) ? 50n : (((60n) - 0) + 60n)) + 5e-08 : (100n > (((60n) - 0) + 80n) ? 100n : (((60n) - 0) + 80n))+60n)+(45n)) / (1u)))) + ((45n) * (((60n)/10 + (1u)/100)*exp(-10 * (60n) / (1u)) - (((60n)+((240n) / (ceil(((240n) - 5p) / (10u)))))/10 + (1u)/100)*exp(-10 * ((60n)+((240n) / (ceil(((240n) - 5p) / (10u))))) / (1u)) + ((60n)/10 + (1u)/100)*exp(-10 * (60n) / (1u)) - (((60n)+((240n) / (ceil(((240n) - 5p) / (10u)))))/10 + (1u)/100)*exp(-10 * ((60n)+((240n) / (ceil(((240n) - 5p) / (10u))))) / (1u))))) / (((240n) / (ceil(((240n) - 5p) / (10u)))) * (45n))           scc=((((240n) / (ceil(((240n) - 5p) / (10u)))) * ((((((240n) / (ceil(((240n) - 5p) / (10u)))) < 119.5n) ? (50n > (((60n) - 0) + 60n) ? 50n : (((60n) - 0) + 60n)) + 5e-08 : (100n > (((60n) - 0) + 80n) ? 100n : (((60n) - 0) + 80n))+60n)/20 + (1u)/400)*exp(-20 * ((((240n) / (ceil(((240n) - 5p) / (10u)))) < 119.5n) ? (50n > (((60n) - 0) + 60n) ? 50n : (((60n) - 0) + 60n)) + 5e-08 : (100n > (((60n) - 0) + 80n) ? 100n : (((60n) - 0) + 80n))+60n) / (1u)) - ((((((240n) / (ceil(((240n) - 5p) / (10u)))) < 119.5n) ? (50n > (((60n) - 0) + 60n) ? 50n : (((60n) - 0) + 60n)) + 5e-08 : (100n > (((60n) - 0) + 80n) ? 100n : (((60n) - 0) + 80n))+60n)+(45n))/20 + (1u)/400)*exp(-20 * (((((240n) / (ceil(((240n) - 5p) / (10u)))) < 119.5n) ? (50n > (((60n) - 0) + 60n) ? 50n : (((60n) - 0) + 60n)) + 5e-08 : (100n > (((60n) - 0) + 80n) ? 100n : (((60n) - 0) + 80n))+60n)+(45n)) / (1u)) + (((((240n) / (ceil(((240n) - 5p) / (10u)))) < 119.5n) ? (50n > (((60n) - 0) + 60n) ? 50n : (((60n) - 0) + 60n)) + 5e-08 : (100n > (((60n) - 0) + 80n) ? 100n : (((60n) - 0) + 80n))+60n)/20 + (1u)/400)*exp(-20 * ((((240n) / (ceil(((240n) - 5p) / (10u)))) < 119.5n) ? (50n > (((60n) - 0) + 60n) ? 50n : (((60n) - 0) + 60n)) + 5e-08 : (100n > (((60n) - 0) + 80n) ? 100n : (((60n) - 0) + 80n))+60n) / (1u)) - ((((((240n) / (ceil(((240n) - 5p) / (10u)))) < 119.5n) ? (50n > (((60n) - 0) + 60n) ? 50n : (((60n) - 0) + 60n)) + 5e-08 : (100n > (((60n) - 0) + 80n) ? 100n : (((60n) - 0) + 80n))+60n)+(45n))/20 + (1u)/400)*exp(-20 * (((((240n) / (ceil(((240n) - 5p) / (10u)))) < 119.5n) ? (50n > (((60n) - 0) + 60n) ? 50n : (((60n) - 0) + 60n)) + 5e-08 : (100n > (((60n) - 0) + 80n) ? 100n : (((60n) - 0) + 80n))+60n)+(45n)) / (1u)))) + ((45n) * (((60n)/20 + (1u)/400)*exp(-20 * (60n) / (1u)) - (((60n)+((240n) / (ceil(((240n) - 5p) / (10u)))))/20 + (1u)/400)*exp(-20 * ((60n)+((240n) / (ceil(((240n) - 5p) / (10u))))) / (1u)) + ((60n)/20 + (1u)/400)*exp(-20 * (60n) / (1u)) - (((60n)+((240n) / (ceil(((240n) - 5p) / (10u)))))/20 + (1u)/400)*exp(-20 * ((60n)+((240n) / (ceil(((240n) - 5p) / (10u))))) / (1u))))) / (((240n) / (ceil(((240n) - 5p) / (10u)))) * (45n))           m=(1)
NM3 (BL WL Q GND) g45n1svt w=(240n) l=45n nf=ceil(((240n) - 5p) / (10u))           as=(((240n) / (ceil(((240n) - 5p) / (10u)))) < 119.5n) ? ((((50n > (((60n) - 0) + 60n) ? 50n : (((60n) - 0) + 60n)) * 120n) + (((240n) / (ceil(((240n) - 5p) / (10u)))) * 50n)) + (floor(((ceil(((240n) - 5p) / (10u))) - 1) / 2.0) * (((((60n) - 0) + 60n) * 120n) + (((240n) / (ceil(((240n) - 5p) / (10u)))) * 100n))) + ((((ceil(((240n) - 5p) / (10u))) / 2) - floor((ceil(((240n) - 5p) / (10u))) / 2) == 0) ? (((50n > (((60n) - 0) + 60n) ? 50n : (((60n) - 0) + 60n)) * 120n) + (((240n) / (ceil(((240n) - 5p) / (10u)))) * 50n)) : 0)) / 1 : (((100n > (((60n) - 0) + 80n) ? 100n : (((60n) - 0) + 80n)) * ((240n) / (ceil(((240n) - 5p) / (10u))))) + (floor(((ceil(((240n) - 5p) / (10u))) - 1) / 2.0) * ((60n > (((60n) - 0) + 50n) ? 60n : (((60n) - 0) + 50n)) * ((240n) / (ceil(((240n) - 5p) / (10u)))))) + ((((ceil(((240n) - 5p) / (10u))) / 2) - floor((ceil(((240n) - 5p) / (10u))) / 2) == 0) ? ((100n > (((60n) - 0) + 80n) ? 100n : (((60n) - 0) + 80n)) * ((240n) / (ceil(((240n) - 5p) / (10u))))) : 0)) / 1           ad=(((240n) / (ceil(((240n) - 5p) / (10u)))) < 119.5n) ? ((floor((ceil(((240n) - 5p) / (10u))) / 2.0) * (((((60n) - 0) + 60n) * 120n) + (((240n) / (ceil(((240n) - 5p) / (10u)))) * 100n))) + ((((ceil(((240n) - 5p) / (10u))) / 2) - floor((ceil(((240n) - 5p) / (10u))) / 2) != 0) ? (((50n > (((60n) - 0) + 60n) ? 50n : (((60n) - 0) + 60n)) * 120n) + (((240n) / (ceil(((240n) - 5p) / (10u)))) * 50n)) : 0)) / 1 : ((floor((ceil(((240n) - 5p) / (10u))) / 2.0) * ((60n > (((60n) - 0) + 50n) ? 60n : (((60n) - 0) + 50n)) * ((240n) / (ceil(((240n) - 5p) / (10u)))))) + ((((ceil(((240n) - 5p) / (10u))) / 2) - floor((ceil(((240n) - 5p) / (10u))) / 2) != 0) ? ((100n > (((60n) - 0) + 80n) ? 100n : (((60n) - 0) + 80n)) * ((240n) / (ceil(((240n) - 5p) / (10u))))) : 0)) / 1           ps=(((240n) / (ceil(((240n) - 5p) / (10u)))) < 119.5n) ? (((2 * (50n > (((60n) - 0) + 60n) ? 50n : (((60n) - 0) + 60n))) + 340n) + (floor(((ceil(((240n) - 5p) / (10u))) - 1) / 2.0) * ((2 * (((60n) - 0) + 60n)) + 440n)) + ((((ceil(((240n) - 5p) / (10u))) / 2) - floor((ceil(((240n) - 5p) / (10u))) / 2) == 0) ? ((2 * (50n > (((60n) - 0) + 60n) ? 50n : (((60n) - 0) + 60n))) + 340n) : 0)) / 1 : (((2 * (100n > (((60n) - 0) + 80n) ? 100n : (((60n) - 0) + 80n))) + (2 * ((240n) / (ceil(((240n) - 5p) / (10u)))))) + (floor(((ceil(((240n) - 5p) / (10u))) - 1) / 2.0) * ((2 * (60n > (((60n) - 0) + 50n) ? 60n : (((60n) - 0) + 50n))) + (2 * ((240n) / (ceil(((240n) - 5p) / (10u))))))) + ((((ceil(((240n) - 5p) / (10u))) / 2) - floor((ceil(((240n) - 5p) / (10u))) / 2) == 0) ? ((2 * (100n > (((60n) - 0) + 80n) ? 100n : (((60n) - 0) + 80n))) + (2 * ((240n) / (ceil(((240n) - 5p) / (10u)))))) : 0)) / 1           pd=(((240n) / (ceil(((240n) - 5p) / (10u)))) < 119.5n) ? ((floor((ceil(((240n) - 5p) / (10u))) / 2.0) * ((2 * (((60n) - 0) + 60n)) + 440n)) + ((((ceil(((240n) - 5p) / (10u))) / 2) - floor((ceil(((240n) - 5p) / (10u))) / 2) != 0) ? ((2 * (50n > (((60n) - 0) + 60n) ? 50n : (((60n) - 0) + 60n))) + 340n) : 0)) / 1 : ((floor((ceil(((240n) - 5p) / (10u))) / 2.0) * ((2 * (60n > (((60n) - 0) + 50n) ? 60n : (((60n) - 0) + 50n))) + (2 * ((240n) / (ceil(((240n) - 5p) / (10u))))))) + ((((ceil(((240n) - 5p) / (10u))) / 2) - floor((ceil(((240n) - 5p) / (10u))) / 2) != 0) ? ((2 * (100n > (((60n) - 0) + 80n) ? 100n : (((60n) - 0) + 80n))) + (2 * ((240n) / (ceil(((240n) - 5p) / (10u)))))) : 0)) / 1           nrd=(((240n) / (ceil(((240n) - 5p) / (10u)))) < 119.5n) ? ((floor((ceil(((240n) - 5p) / (10u))) / 2.0) * (((((60n) - 0) + 60n) * 120n) + (((240n) / (ceil(((240n) - 5p) / (10u)))) * 100n))) + ((((ceil(((240n) - 5p) / (10u))) / 2) - floor((ceil(((240n) - 5p) / (10u))) / 2) != 0) ? (((50n > (((60n) - 0) + 60n) ? 50n : (((60n) - 0) + 60n)) * 120n) + (((240n) / (ceil(((240n) - 5p) / (10u)))) * 50n)) : 0)) / 1 : ((floor((ceil(((240n) - 5p) / (10u))) / 2.0) * ((60n > (((60n) - 0) + 50n) ? 60n : (((60n) - 0) + 50n)) * ((240n) / (ceil(((240n) - 5p) / (10u)))))) + ((((ceil(((240n) - 5p) / (10u))) / 2) - floor((ceil(((240n) - 5p) / (10u))) / 2) != 0) ? ((100n > (((60n) - 0) + 80n) ? 100n : (((60n) - 0) + 80n)) * ((240n) / (ceil(((240n) - 5p) / (10u))))) : 0)) / 1 / (((240n) / (ceil(((240n) - 5p) / (10u)))) * (ceil(((240n) - 5p) / (10u))) * ((240n) / (ceil(((240n) - 5p) / (10u)))) * (ceil(((240n) - 5p) / (10u))))           nrs=(((240n) / (ceil(((240n) - 5p) / (10u)))) < 119.5n) ? ((((50n > (((60n) - 0) + 60n) ? 50n : (((60n) - 0) + 60n)) * 120n) + (((240n) / (ceil(((240n) - 5p) / (10u)))) * 50n)) + (floor(((ceil(((240n) - 5p) / (10u))) - 1) / 2.0) * (((((60n) - 0) + 60n) * 120n) + (((240n) / (ceil(((240n) - 5p) / (10u)))) * 100n))) + ((((ceil(((240n) - 5p) / (10u))) / 2) - floor((ceil(((240n) - 5p) / (10u))) / 2) == 0) ? (((50n > (((60n) - 0) + 60n) ? 50n : (((60n) - 0) + 60n)) * 120n) + (((240n) / (ceil(((240n) - 5p) / (10u)))) * 50n)) : 0)) / 1 : (((100n > (((60n) - 0) + 80n) ? 100n : (((60n) - 0) + 80n)) * ((240n) / (ceil(((240n) - 5p) / (10u))))) + (floor(((ceil(((240n) - 5p) / (10u))) - 1) / 2.0) * ((60n > (((60n) - 0) + 50n) ? 60n : (((60n) - 0) + 50n)) * ((240n) / (ceil(((240n) - 5p) / (10u)))))) + ((((ceil(((240n) - 5p) / (10u))) / 2) - floor((ceil(((240n) - 5p) / (10u))) / 2) == 0) ? ((100n > (((60n) - 0) + 80n) ? 100n : (((60n) - 0) + 80n)) * ((240n) / (ceil(((240n) - 5p) / (10u))))) : 0)) / 1 / (((240n) / (ceil(((240n) - 5p) / (10u)))) * (ceil(((240n) - 5p) / (10u))) * ((240n) / (ceil(((240n) - 5p) / (10u)))) * (ceil(((240n) - 5p) / (10u))))           sa=(((240n) / (ceil(((240n) - 5p) / (10u)))) < 119.5n) ? (50n > (((60n) - 0) + 60n) ? 50n : (((60n) - 0) + 60n)) + 5e-08 : (100n > (((60n) - 0) + 80n) ? 100n : (((60n) - 0) + 80n))           sb=(((240n) / (ceil(((240n) - 5p) / (10u)))) < 119.5n) ? (50n > (((60n) - 0) + 60n) ? 50n : (((60n) - 0) + 60n)) + 5e-08 : (100n > (((60n) - 0) + 80n) ? 100n : (((60n) - 0) + 80n))           sd=(((240n) / (ceil(((240n) - 5p) / (10u)))) < 119.5n) ? (((60n) - 0) + 60n) + (2*5e-08) : (60n > (((60n) - 0) + 50n) ? 60n : (((60n) - 0) + 50n))           sca=(( ((240n) / (ceil(((240n) - 5p) / (10u)))) * ( (((1u) * (1u) / ((((240n) / (ceil(((240n) - 5p) / (10u)))) < 119.5n) ? (50n > (((60n) - 0) + 60n) ? 50n : (((60n) - 0) + 60n)) + 5e-08 : (100n > (((60n) - 0) + 80n) ? 100n : (((60n) - 0) + 80n))+60n)) - ((1u) * (1u) / (((((240n) / (ceil(((240n) - 5p) / (10u)))) < 119.5n) ? (50n > (((60n) - 0) + 60n) ? 50n : (((60n) - 0) + 60n)) + 5e-08 : (100n > (((60n) - 0) + 80n) ? 100n : (((60n) - 0) + 80n))+60n)+(45n)))) + ((1u) * (1u) / ((((240n) / (ceil(((240n) - 5p) / (10u)))) < 119.5n) ? (50n > (((60n) - 0) + 60n) ? 50n : (((60n) - 0) + 60n)) + 5e-08 : (100n > (((60n) - 0) + 80n) ? 100n : (((60n) - 0) + 80n))+60n)) - ((1u) * (1u)/ (((((240n) / (ceil(((240n) - 5p) / (10u)))) < 119.5n) ? (50n > (((60n) - 0) + 60n) ? 50n : (((60n) - 0) + 60n)) + 5e-08 : (100n > (((60n) - 0) + 80n) ? 100n : (((60n) - 0) + 80n))+60n)+(45n))))) + ( (45n) * ( (((1u) * (1u) / (60n)) - ((1u) * (1u) / ((60n)+((240n) / (ceil(((240n) - 5p) / (10u))))))) + ((1u) * (1u) / (60n)) - ((1u) * (1u)/ ((60n)+((240n) / (ceil(((240n) - 5p) / (10u))))))))) / (((240n) / (ceil(((240n) - 5p) / (10u)))) * (45n))           scb=((((240n) / (ceil(((240n) - 5p) / (10u)))) * ((((((240n) / (ceil(((240n) - 5p) / (10u)))) < 119.5n) ? (50n > (((60n) - 0) + 60n) ? 50n : (((60n) - 0) + 60n)) + 5e-08 : (100n > (((60n) - 0) + 80n) ? 100n : (((60n) - 0) + 80n))+60n)/10 + (1u)/100)*exp(-10 * ((((240n) / (ceil(((240n) - 5p) / (10u)))) < 119.5n) ? (50n > (((60n) - 0) + 60n) ? 50n : (((60n) - 0) + 60n)) + 5e-08 : (100n > (((60n) - 0) + 80n) ? 100n : (((60n) - 0) + 80n))+60n) / (1u)) - ((((((240n) / (ceil(((240n) - 5p) / (10u)))) < 119.5n) ? (50n > (((60n) - 0) + 60n) ? 50n : (((60n) - 0) + 60n)) + 5e-08 : (100n > (((60n) - 0) + 80n) ? 100n : (((60n) - 0) + 80n))+60n)+(45n))/10 + (1u)/100)*exp(-10 * (((((240n) / (ceil(((240n) - 5p) / (10u)))) < 119.5n) ? (50n > (((60n) - 0) + 60n) ? 50n : (((60n) - 0) + 60n)) + 5e-08 : (100n > (((60n) - 0) + 80n) ? 100n : (((60n) - 0) + 80n))+60n)+(45n)) / (1u)) + (((((240n) / (ceil(((240n) - 5p) / (10u)))) < 119.5n) ? (50n > (((60n) - 0) + 60n) ? 50n : (((60n) - 0) + 60n)) + 5e-08 : (100n > (((60n) - 0) + 80n) ? 100n : (((60n) - 0) + 80n))+60n)/10 + (1u)/100)*exp(-10 * ((((240n) / (ceil(((240n) - 5p) / (10u)))) < 119.5n) ? (50n > (((60n) - 0) + 60n) ? 50n : (((60n) - 0) + 60n)) + 5e-08 : (100n > (((60n) - 0) + 80n) ? 100n : (((60n) - 0) + 80n))+60n) / (1u)) - ((((((240n) / (ceil(((240n) - 5p) / (10u)))) < 119.5n) ? (50n > (((60n) - 0) + 60n) ? 50n : (((60n) - 0) + 60n)) + 5e-08 : (100n > (((60n) - 0) + 80n) ? 100n : (((60n) - 0) + 80n))+60n)+(45n))/10 + (1u)/100)*exp(-10 * (((((240n) / (ceil(((240n) - 5p) / (10u)))) < 119.5n) ? (50n > (((60n) - 0) + 60n) ? 50n : (((60n) - 0) + 60n)) + 5e-08 : (100n > (((60n) - 0) + 80n) ? 100n : (((60n) - 0) + 80n))+60n)+(45n)) / (1u)))) + ((45n) * (((60n)/10 + (1u)/100)*exp(-10 * (60n) / (1u)) - (((60n)+((240n) / (ceil(((240n) - 5p) / (10u)))))/10 + (1u)/100)*exp(-10 * ((60n)+((240n) / (ceil(((240n) - 5p) / (10u))))) / (1u)) + ((60n)/10 + (1u)/100)*exp(-10 * (60n) / (1u)) - (((60n)+((240n) / (ceil(((240n) - 5p) / (10u)))))/10 + (1u)/100)*exp(-10 * ((60n)+((240n) / (ceil(((240n) - 5p) / (10u))))) / (1u))))) / (((240n) / (ceil(((240n) - 5p) / (10u)))) * (45n))           scc=((((240n) / (ceil(((240n) - 5p) / (10u)))) * ((((((240n) / (ceil(((240n) - 5p) / (10u)))) < 119.5n) ? (50n > (((60n) - 0) + 60n) ? 50n : (((60n) - 0) + 60n)) + 5e-08 : (100n > (((60n) - 0) + 80n) ? 100n : (((60n) - 0) + 80n))+60n)/20 + (1u)/400)*exp(-20 * ((((240n) / (ceil(((240n) - 5p) / (10u)))) < 119.5n) ? (50n > (((60n) - 0) + 60n) ? 50n : (((60n) - 0) + 60n)) + 5e-08 : (100n > (((60n) - 0) + 80n) ? 100n : (((60n) - 0) + 80n))+60n) / (1u)) - ((((((240n) / (ceil(((240n) - 5p) / (10u)))) < 119.5n) ? (50n > (((60n) - 0) + 60n) ? 50n : (((60n) - 0) + 60n)) + 5e-08 : (100n > (((60n) - 0) + 80n) ? 100n : (((60n) - 0) + 80n))+60n)+(45n))/20 + (1u)/400)*exp(-20 * (((((240n) / (ceil(((240n) - 5p) / (10u)))) < 119.5n) ? (50n > (((60n) - 0) + 60n) ? 50n : (((60n) - 0) + 60n)) + 5e-08 : (100n > (((60n) - 0) + 80n) ? 100n : (((60n) - 0) + 80n))+60n)+(45n)) / (1u)) + (((((240n) / (ceil(((240n) - 5p) / (10u)))) < 119.5n) ? (50n > (((60n) - 0) + 60n) ? 50n : (((60n) - 0) + 60n)) + 5e-08 : (100n > (((60n) - 0) + 80n) ? 100n : (((60n) - 0) + 80n))+60n)/20 + (1u)/400)*exp(-20 * ((((240n) / (ceil(((240n) - 5p) / (10u)))) < 119.5n) ? (50n > (((60n) - 0) + 60n) ? 50n : (((60n) - 0) + 60n)) + 5e-08 : (100n > (((60n) - 0) + 80n) ? 100n : (((60n) - 0) + 80n))+60n) / (1u)) - ((((((240n) / (ceil(((240n) - 5p) / (10u)))) < 119.5n) ? (50n > (((60n) - 0) + 60n) ? 50n : (((60n) - 0) + 60n)) + 5e-08 : (100n > (((60n) - 0) + 80n) ? 100n : (((60n) - 0) + 80n))+60n)+(45n))/20 + (1u)/400)*exp(-20 * (((((240n) / (ceil(((240n) - 5p) / (10u)))) < 119.5n) ? (50n > (((60n) - 0) + 60n) ? 50n : (((60n) - 0) + 60n)) + 5e-08 : (100n > (((60n) - 0) + 80n) ? 100n : (((60n) - 0) + 80n))+60n)+(45n)) / (1u)))) + ((45n) * (((60n)/20 + (1u)/400)*exp(-20 * (60n) / (1u)) - (((60n)+((240n) / (ceil(((240n) - 5p) / (10u)))))/20 + (1u)/400)*exp(-20 * ((60n)+((240n) / (ceil(((240n) - 5p) / (10u))))) / (1u)) + ((60n)/20 + (1u)/400)*exp(-20 * (60n) / (1u)) - (((60n)+((240n) / (ceil(((240n) - 5p) / (10u)))))/20 + (1u)/400)*exp(-20 * ((60n)+((240n) / (ceil(((240n) - 5p) / (10u))))) / (1u))))) / (((240n) / (ceil(((240n) - 5p) / (10u)))) * (45n))           m=(1)
ends
subckt bit_array (WL0 WL1 WL2 WL3 BL0 BL1 BL2 BL3 BL4 BL5 BLB0 BLB1 BLB2 BLB3 BLB4 BLB5 VDD GND)
XB0_0 (BL0 BLB0 WL0 Q0_0 QB0_0 VDD GND) bitcell
XB0_1 (BL1 BLB1 WL0 Q0_1 QB0_1 VDD GND) bitcell
XB0_2 (BL2 BLB2 WL0 Q0_2 QB0_2 VDD GND) bitcell
XB0_3 (BL3 BLB3 WL0 Q0_3 QB0_3 VDD GND) bitcell
XB0_4 (BL4 BLB4 WL0 Q0_4 QB0_4 VDD GND) bitcell
XB0_5 (BL5 BLB5 WL0 Q0_5 QB0_5 VDD GND) bitcell
XB1_0 (BL0 BLB0 WL1 Q1_0 QB1_0 VDD GND) bitcell
XB1_1 (BL1 BLB1 WL1 Q1_1 QB1_1 VDD GND) bitcell
XB1_2 (BL2 BLB2 WL1 Q1_2 QB1_2 VDD GND) bitcell
XB1_3 (BL3 BLB3 WL1 Q1_3 QB1_3 VDD GND) bitcell
XB1_4 (BL4 BLB4 WL1 Q1_4 QB1_4 VDD GND) bitcell
XB1_5 (BL5 BLB5 WL1 Q1_5 QB1_5 VDD GND) bitcell
XB2_0 (BL0 BLB0 WL2 Q2_0 QB2_0 VDD GND) bitcell
XB2_1 (BL1 BLB1 WL2 Q2_1 QB2_1 VDD GND) bitcell
XB2_2 (BL2 BLB2 WL2 Q2_2 QB2_2 VDD GND) bitcell
XB2_3 (BL3 BLB3 WL2 Q2_3 QB2_3 VDD GND) bitcell
XB2_4 (BL4 BLB4 WL2 Q2_4 QB2_4 VDD GND) bitcell
XB2_5 (BL5 BLB5 WL2 Q2_5 QB2_5 VDD GND) bitcell
XB3_0 (BL0 BLB0 WL3 Q3_0 QB3_0 VDD GND) bitcell
XB3_1 (BL1 BLB1 WL3 Q3_1 QB3_1 VDD GND) bitcell
XB3_2 (BL2 BLB2 WL3 Q3_2 QB3_2 VDD GND) bitcell
XB3_3 (BL3 BLB3 WL3 Q3_3 QB3_3 VDD GND) bitcell
XB3_4 (BL4 BLB4 WL3 Q3_4 QB3_4 VDD GND) bitcell
XB3_5 (BL5 BLB5 WL3 Q3_5 QB3_5 VDD GND) bitcell
ends
subckt sram_4x6 (R1 R0 C2 C1 C0 CLK1 CLK2 WR RD DIN DOUT VDD GND)
XCTRL (CLK1 CLK2 WR RD C2 C1 WEN WENB REN RENB ROWEN PCB VDD GND) rw_control
XROW (R1 R0 ROWEN WL0 WL1 WL2 WL3 VDD GND) row_decoder
XCOL (C2 C1 C0 CS0 CS1 CS2 CS3 CS4 CS5 VDD GND) column_decoder
XPRE (BL0 BL1 BL2 BL3 BL4 BL5 BLB0 BLB1 BLB2 BLB3 BLB4 BLB5 PCB VDD GND) precharge
XMUX (CS0 CS1 CS2 CS3 CS4 CS5 BL0 BL1 BL2 BL3 BL4 BL5 BLB0 BLB1 BLB2 BLB3 BLB4 BLB5 GBL GBLB VDD GND) column_mux
XWRITE (DIN WEN WENB GBL GBLB VDD GND) write_driver
XMEM (WL0 WL1 WL2 WL3 BL0 BL1 BL2 BL3 BL4 BL5 BLB0 BLB1 BLB2 BLB3 BLB4 BLB5 VDD GND) bit_array
XSENSE (GBL GBLB REN VDD GND SENSE) sense_amp
XLATCH (SENSE REN RENB DOUT VDD GND) read_latch
ends
