simulator lang=spectre
include "/ecel/UFAD/ymahmud/vlsi_sram_project/Project Instruction Files/gpdk045_mos.scs" section=tt
include "/ecel/UFAD/ymahmud/vlsi_sram_project/project_file/full_array/netlists/design.scs"
parameters vdd=1.1
simOptions options temp=27 reltol=1e-3 vabstol=1e-7 iabstol=1e-14 gmin=1e-14
VDD (VDD 0) vsource dc=vdd
VR1 (R1 0) vsource type=pwl wave=[0n (0*vdd) 600.2n (0*vdd) 600.3n (1*vdd) 1200.2n (1*vdd) 1200.3n (0*vdd) 1800.2n (0*vdd) 1800.3n (1*vdd) 2400.2n (1*vdd) 2400.3n (0*vdd) 3000.2n (0*vdd) 3000.3n (1*vdd) 3600.2n (1*vdd) 3600.3n (0*vdd) 4200.2n (0*vdd) 4200.3n (1*vdd) 4800.2n (1*vdd) 4800.3n (0*vdd) 5400.2n (0*vdd) 5400.3n (1*vdd) 6000.2n (1*vdd) 6000.3n (0*vdd) 6600.2n (0*vdd) 6600.3n (1*vdd) 7200.2n (1*vdd) 7200.3n (0*vdd) 7800.2n (0*vdd) 7800.3n (1*vdd) 8400.2n (1*vdd) 8400.3n (0*vdd) 9000.2n (0*vdd) 9000.3n (1*vdd) 9600.2n (1*vdd) 9600.3n (0*vdd) 10200.2n (0*vdd) 10200.3n (1*vdd) 10800.2n (1*vdd) 10800.3n (0*vdd) 11200.2n (0*vdd) 11200.3n (1*vdd) 11600.2n (1*vdd) 11600.3n (0*vdd) 12200n (0*vdd)]
VR0 (R0 0) vsource type=pwl wave=[0n (0*vdd) 300.2n (0*vdd) 300.3n (1*vdd) 600.2n (1*vdd) 600.3n (0*vdd) 900.2n (0*vdd) 900.3n (1*vdd) 1200.2n (1*vdd) 1200.3n (0*vdd) 1500.2n (0*vdd) 1500.3n (1*vdd) 1800.2n (1*vdd) 1800.3n (0*vdd) 2100.2n (0*vdd) 2100.3n (1*vdd) 2400.2n (1*vdd) 2400.3n (0*vdd) 2700.2n (0*vdd) 2700.3n (1*vdd) 3000.2n (1*vdd) 3000.3n (0*vdd) 3300.2n (0*vdd) 3300.3n (1*vdd) 3600.2n (1*vdd) 3600.3n (0*vdd) 3900.2n (0*vdd) 3900.3n (1*vdd) 4200.2n (1*vdd) 4200.3n (0*vdd) 4500.2n (0*vdd) 4500.3n (1*vdd) 4800.2n (1*vdd) 4800.3n (0*vdd) 5100.2n (0*vdd) 5100.3n (1*vdd) 5400.2n (1*vdd) 5400.3n (0*vdd) 5700.2n (0*vdd) 5700.3n (1*vdd) 6000.2n (1*vdd) 6000.3n (0*vdd) 6300.2n (0*vdd) 6300.3n (1*vdd) 6600.2n (1*vdd) 6600.3n (0*vdd) 6900.2n (0*vdd) 6900.3n (1*vdd) 7200.2n (1*vdd) 7200.3n (0*vdd) 7500.2n (0*vdd) 7500.3n (1*vdd) 7800.2n (1*vdd) 7800.3n (0*vdd) 8100.2n (0*vdd) 8100.3n (1*vdd) 8400.2n (1*vdd) 8400.3n (0*vdd) 8700.2n (0*vdd) 8700.3n (1*vdd) 9000.2n (1*vdd) 9000.3n (0*vdd) 9300.2n (0*vdd) 9300.3n (1*vdd) 9600.2n (1*vdd) 9600.3n (0*vdd) 9900.2n (0*vdd) 9900.3n (1*vdd) 10200.2n (1*vdd) 10200.3n (0*vdd) 10500.2n (0*vdd) 10500.3n (1*vdd) 10800.2n (1*vdd) 10800.3n (0*vdd) 11000.2n (0*vdd) 11000.3n (1*vdd) 11200.2n (1*vdd) 11200.3n (0*vdd) 11400.2n (0*vdd) 11400.3n (1*vdd) 11600.2n (1*vdd) 11600.3n (0*vdd) 11900.2n (0*vdd) 11900.3n (1*vdd) 12000.2n (1*vdd) 12000.3n (0*vdd) 12200n (0*vdd)]
VC2 (C2 0) vsource type=pwl wave=[0n (0*vdd) 200.2n (0*vdd) 200.3n (1*vdd) 300.2n (1*vdd) 300.3n (0*vdd) 500.2n (0*vdd) 500.3n (1*vdd) 600.2n (1*vdd) 600.3n (0*vdd) 800.2n (0*vdd) 800.3n (1*vdd) 900.2n (1*vdd) 900.3n (0*vdd) 1100.2n (0*vdd) 1100.3n (1*vdd) 1200.2n (1*vdd) 1200.3n (0*vdd) 1400.2n (0*vdd) 1400.3n (1*vdd) 1500.2n (1*vdd) 1500.3n (0*vdd) 1700.2n (0*vdd) 1700.3n (1*vdd) 1800.2n (1*vdd) 1800.3n (0*vdd) 2000.2n (0*vdd) 2000.3n (1*vdd) 2100.2n (1*vdd) 2100.3n (0*vdd) 2300.2n (0*vdd) 2300.3n (1*vdd) 2400.2n (1*vdd) 2400.3n (0*vdd) 2600.2n (0*vdd) 2600.3n (1*vdd) 2700.2n (1*vdd) 2700.3n (0*vdd) 2900.2n (0*vdd) 2900.3n (1*vdd) 3000.2n (1*vdd) 3000.3n (0*vdd) 3200.2n (0*vdd) 3200.3n (1*vdd) 3300.2n (1*vdd) 3300.3n (0*vdd) 3500.2n (0*vdd) 3500.3n (1*vdd) 3600.2n (1*vdd) 3600.3n (0*vdd) 3800.2n (0*vdd) 3800.3n (1*vdd) 3900.2n (1*vdd) 3900.3n (0*vdd) 4100.2n (0*vdd) 4100.3n (1*vdd) 4200.2n (1*vdd) 4200.3n (0*vdd) 4400.2n (0*vdd) 4400.3n (1*vdd) 4500.2n (1*vdd) 4500.3n (0*vdd) 4700.2n (0*vdd) 4700.3n (1*vdd) 4800.2n (1*vdd) 4800.3n (0*vdd) 5000.2n (0*vdd) 5000.3n (1*vdd) 5100.2n (1*vdd) 5100.3n (0*vdd) 5300.2n (0*vdd) 5300.3n (1*vdd) 5400.2n (1*vdd) 5400.3n (0*vdd) 5600.2n (0*vdd) 5600.3n (1*vdd) 5700.2n (1*vdd) 5700.3n (0*vdd) 5900.2n (0*vdd) 5900.3n (1*vdd) 6000.2n (1*vdd) 6000.3n (0*vdd) 6200.2n (0*vdd) 6200.3n (1*vdd) 6300.2n (1*vdd) 6300.3n (0*vdd) 6500.2n (0*vdd) 6500.3n (1*vdd) 6600.2n (1*vdd) 6600.3n (0*vdd) 6800.2n (0*vdd) 6800.3n (1*vdd) 6900.2n (1*vdd) 6900.3n (0*vdd) 7100.2n (0*vdd) 7100.3n (1*vdd) 7200.2n (1*vdd) 7200.3n (0*vdd) 7400.2n (0*vdd) 7400.3n (1*vdd) 7500.2n (1*vdd) 7500.3n (0*vdd) 7700.2n (0*vdd) 7700.3n (1*vdd) 7800.2n (1*vdd) 7800.3n (0*vdd) 8000.2n (0*vdd) 8000.3n (1*vdd) 8100.2n (1*vdd) 8100.3n (0*vdd) 8300.2n (0*vdd) 8300.3n (1*vdd) 8400.2n (1*vdd) 8400.3n (0*vdd) 8600.2n (0*vdd) 8600.3n (1*vdd) 8700.2n (1*vdd) 8700.3n (0*vdd) 8900.2n (0*vdd) 8900.3n (1*vdd) 9000.2n (1*vdd) 9000.3n (0*vdd) 9200.2n (0*vdd) 9200.3n (1*vdd) 9300.2n (1*vdd) 9300.3n (0*vdd) 9500.2n (0*vdd) 9500.3n (1*vdd) 9600.2n (1*vdd) 9600.3n (0*vdd) 9800.2n (0*vdd) 9800.3n (1*vdd) 9900.2n (1*vdd) 9900.3n (0*vdd) 10100.2n (0*vdd) 10100.3n (1*vdd) 10200.2n (1*vdd) 10200.3n (0*vdd) 10400.2n (0*vdd) 10400.3n (1*vdd) 10500.2n (1*vdd) 10500.3n (0*vdd) 10700.2n (0*vdd) 10700.3n (1*vdd) 11600.2n (1*vdd) 11600.3n (0*vdd) 11800.2n (0*vdd) 11800.3n (1*vdd) 11900.2n (1*vdd) 11900.3n (0*vdd) 12200n (0*vdd)]
VC1 (C1 0) vsource type=pwl wave=[0n (0*vdd) 100.2n (0*vdd) 100.3n (1*vdd) 200.2n (1*vdd) 200.3n (0*vdd) 400.2n (0*vdd) 400.3n (1*vdd) 500.2n (1*vdd) 500.3n (0*vdd) 700.2n (0*vdd) 700.3n (1*vdd) 800.2n (1*vdd) 800.3n (0*vdd) 1000.2n (0*vdd) 1000.3n (1*vdd) 1100.2n (1*vdd) 1100.3n (0*vdd) 1300.2n (0*vdd) 1300.3n (1*vdd) 1400.2n (1*vdd) 1400.3n (0*vdd) 1600.2n (0*vdd) 1600.3n (1*vdd) 1700.2n (1*vdd) 1700.3n (0*vdd) 1900.2n (0*vdd) 1900.3n (1*vdd) 2000.2n (1*vdd) 2000.3n (0*vdd) 2200.2n (0*vdd) 2200.3n (1*vdd) 2300.2n (1*vdd) 2300.3n (0*vdd) 2500.2n (0*vdd) 2500.3n (1*vdd) 2600.2n (1*vdd) 2600.3n (0*vdd) 2800.2n (0*vdd) 2800.3n (1*vdd) 2900.2n (1*vdd) 2900.3n (0*vdd) 3100.2n (0*vdd) 3100.3n (1*vdd) 3200.2n (1*vdd) 3200.3n (0*vdd) 3400.2n (0*vdd) 3400.3n (1*vdd) 3500.2n (1*vdd) 3500.3n (0*vdd) 3700.2n (0*vdd) 3700.3n (1*vdd) 3800.2n (1*vdd) 3800.3n (0*vdd) 4000.2n (0*vdd) 4000.3n (1*vdd) 4100.2n (1*vdd) 4100.3n (0*vdd) 4300.2n (0*vdd) 4300.3n (1*vdd) 4400.2n (1*vdd) 4400.3n (0*vdd) 4600.2n (0*vdd) 4600.3n (1*vdd) 4700.2n (1*vdd) 4700.3n (0*vdd) 4900.2n (0*vdd) 4900.3n (1*vdd) 5000.2n (1*vdd) 5000.3n (0*vdd) 5200.2n (0*vdd) 5200.3n (1*vdd) 5300.2n (1*vdd) 5300.3n (0*vdd) 5500.2n (0*vdd) 5500.3n (1*vdd) 5600.2n (1*vdd) 5600.3n (0*vdd) 5800.2n (0*vdd) 5800.3n (1*vdd) 5900.2n (1*vdd) 5900.3n (0*vdd) 6100.2n (0*vdd) 6100.3n (1*vdd) 6200.2n (1*vdd) 6200.3n (0*vdd) 6400.2n (0*vdd) 6400.3n (1*vdd) 6500.2n (1*vdd) 6500.3n (0*vdd) 6700.2n (0*vdd) 6700.3n (1*vdd) 6800.2n (1*vdd) 6800.3n (0*vdd) 7000.2n (0*vdd) 7000.3n (1*vdd) 7100.2n (1*vdd) 7100.3n (0*vdd) 7300.2n (0*vdd) 7300.3n (1*vdd) 7400.2n (1*vdd) 7400.3n (0*vdd) 7600.2n (0*vdd) 7600.3n (1*vdd) 7700.2n (1*vdd) 7700.3n (0*vdd) 7900.2n (0*vdd) 7900.3n (1*vdd) 8000.2n (1*vdd) 8000.3n (0*vdd) 8200.2n (0*vdd) 8200.3n (1*vdd) 8300.2n (1*vdd) 8300.3n (0*vdd) 8500.2n (0*vdd) 8500.3n (1*vdd) 8600.2n (1*vdd) 8600.3n (0*vdd) 8800.2n (0*vdd) 8800.3n (1*vdd) 8900.2n (1*vdd) 8900.3n (0*vdd) 9100.2n (0*vdd) 9100.3n (1*vdd) 9200.2n (1*vdd) 9200.3n (0*vdd) 9400.2n (0*vdd) 9400.3n (1*vdd) 9500.2n (1*vdd) 9500.3n (0*vdd) 9700.2n (0*vdd) 9700.3n (1*vdd) 9800.2n (1*vdd) 9800.3n (0*vdd) 10000.2n (0*vdd) 10000.3n (1*vdd) 10100.2n (1*vdd) 10100.3n (0*vdd) 10300.2n (0*vdd) 10300.3n (1*vdd) 10400.2n (1*vdd) 10400.3n (0*vdd) 10600.2n (0*vdd) 10600.3n (1*vdd) 10700.2n (1*vdd) 10700.3n (0*vdd) 10800.2n (0*vdd) 10800.3n (1*vdd) 11600.2n (1*vdd) 11600.3n (0*vdd) 11700.2n (0*vdd) 11700.3n (1*vdd) 11800.2n (1*vdd) 11800.3n (0*vdd) 12100.2n (0*vdd) 12100.3n (1*vdd) 12200n (1*vdd)]
VC0 (C0 0) vsource type=pwl wave=[0n (0*vdd) 50.2n (0*vdd) 50.3n (1*vdd) 100.2n (1*vdd) 100.3n (0*vdd) 150.2n (0*vdd) 150.3n (1*vdd) 200.2n (1*vdd) 200.3n (0*vdd) 250.2n (0*vdd) 250.3n (1*vdd) 300.2n (1*vdd) 300.3n (0*vdd) 350.2n (0*vdd) 350.3n (1*vdd) 400.2n (1*vdd) 400.3n (0*vdd) 450.2n (0*vdd) 450.3n (1*vdd) 500.2n (1*vdd) 500.3n (0*vdd) 550.2n (0*vdd) 550.3n (1*vdd) 600.2n (1*vdd) 600.3n (0*vdd) 650.2n (0*vdd) 650.3n (1*vdd) 700.2n (1*vdd) 700.3n (0*vdd) 750.2n (0*vdd) 750.3n (1*vdd) 800.2n (1*vdd) 800.3n (0*vdd) 850.2n (0*vdd) 850.3n (1*vdd) 900.2n (1*vdd) 900.3n (0*vdd) 950.2n (0*vdd) 950.3n (1*vdd) 1000.2n (1*vdd) 1000.3n (0*vdd) 1050.2n (0*vdd) 1050.3n (1*vdd) 1100.2n (1*vdd) 1100.3n (0*vdd) 1150.2n (0*vdd) 1150.3n (1*vdd) 1200.2n (1*vdd) 1200.3n (0*vdd) 1250.2n (0*vdd) 1250.3n (1*vdd) 1300.2n (1*vdd) 1300.3n (0*vdd) 1350.2n (0*vdd) 1350.3n (1*vdd) 1400.2n (1*vdd) 1400.3n (0*vdd) 1450.2n (0*vdd) 1450.3n (1*vdd) 1500.2n (1*vdd) 1500.3n (0*vdd) 1550.2n (0*vdd) 1550.3n (1*vdd) 1600.2n (1*vdd) 1600.3n (0*vdd) 1650.2n (0*vdd) 1650.3n (1*vdd) 1700.2n (1*vdd) 1700.3n (0*vdd) 1750.2n (0*vdd) 1750.3n (1*vdd) 1800.2n (1*vdd) 1800.3n (0*vdd) 1850.2n (0*vdd) 1850.3n (1*vdd) 1900.2n (1*vdd) 1900.3n (0*vdd) 1950.2n (0*vdd) 1950.3n (1*vdd) 2000.2n (1*vdd) 2000.3n (0*vdd) 2050.2n (0*vdd) 2050.3n (1*vdd) 2100.2n (1*vdd) 2100.3n (0*vdd) 2150.2n (0*vdd) 2150.3n (1*vdd) 2200.2n (1*vdd) 2200.3n (0*vdd) 2250.2n (0*vdd) 2250.3n (1*vdd) 2300.2n (1*vdd) 2300.3n (0*vdd) 2350.2n (0*vdd) 2350.3n (1*vdd) 2400.2n (1*vdd) 2400.3n (0*vdd) 2450.2n (0*vdd) 2450.3n (1*vdd) 2500.2n (1*vdd) 2500.3n (0*vdd) 2550.2n (0*vdd) 2550.3n (1*vdd) 2600.2n (1*vdd) 2600.3n (0*vdd) 2650.2n (0*vdd) 2650.3n (1*vdd) 2700.2n (1*vdd) 2700.3n (0*vdd) 2750.2n (0*vdd) 2750.3n (1*vdd) 2800.2n (1*vdd) 2800.3n (0*vdd) 2850.2n (0*vdd) 2850.3n (1*vdd) 2900.2n (1*vdd) 2900.3n (0*vdd) 2950.2n (0*vdd) 2950.3n (1*vdd) 3000.2n (1*vdd) 3000.3n (0*vdd) 3050.2n (0*vdd) 3050.3n (1*vdd) 3100.2n (1*vdd) 3100.3n (0*vdd) 3150.2n (0*vdd) 3150.3n (1*vdd) 3200.2n (1*vdd) 3200.3n (0*vdd) 3250.2n (0*vdd) 3250.3n (1*vdd) 3300.2n (1*vdd) 3300.3n (0*vdd) 3350.2n (0*vdd) 3350.3n (1*vdd) 3400.2n (1*vdd) 3400.3n (0*vdd) 3450.2n (0*vdd) 3450.3n (1*vdd) 3500.2n (1*vdd) 3500.3n (0*vdd) 3550.2n (0*vdd) 3550.3n (1*vdd) 3600.2n (1*vdd) 3600.3n (0*vdd) 3650.2n (0*vdd) 3650.3n (1*vdd) 3700.2n (1*vdd) 3700.3n (0*vdd) 3750.2n (0*vdd) 3750.3n (1*vdd) 3800.2n (1*vdd) 3800.3n (0*vdd) 3850.2n (0*vdd) 3850.3n (1*vdd) 3900.2n (1*vdd) 3900.3n (0*vdd) 3950.2n (0*vdd) 3950.3n (1*vdd) 4000.2n (1*vdd) 4000.3n (0*vdd) 4050.2n (0*vdd) 4050.3n (1*vdd) 4100.2n (1*vdd) 4100.3n (0*vdd) 4150.2n (0*vdd) 4150.3n (1*vdd) 4200.2n (1*vdd) 4200.3n (0*vdd) 4250.2n (0*vdd) 4250.3n (1*vdd) 4300.2n (1*vdd) 4300.3n (0*vdd) 4350.2n (0*vdd) 4350.3n (1*vdd) 4400.2n (1*vdd) 4400.3n (0*vdd) 4450.2n (0*vdd) 4450.3n (1*vdd) 4500.2n (1*vdd) 4500.3n (0*vdd) 4550.2n (0*vdd) 4550.3n (1*vdd) 4600.2n (1*vdd) 4600.3n (0*vdd) 4650.2n (0*vdd) 4650.3n (1*vdd) 4700.2n (1*vdd) 4700.3n (0*vdd) 4750.2n (0*vdd) 4750.3n (1*vdd) 4800.2n (1*vdd) 4800.3n (0*vdd) 4850.2n (0*vdd) 4850.3n (1*vdd) 4900.2n (1*vdd) 4900.3n (0*vdd) 4950.2n (0*vdd) 4950.3n (1*vdd) 5000.2n (1*vdd) 5000.3n (0*vdd) 5050.2n (0*vdd) 5050.3n (1*vdd) 5100.2n (1*vdd) 5100.3n (0*vdd) 5150.2n (0*vdd) 5150.3n (1*vdd) 5200.2n (1*vdd) 5200.3n (0*vdd) 5250.2n (0*vdd) 5250.3n (1*vdd) 5300.2n (1*vdd) 5300.3n (0*vdd) 5350.2n (0*vdd) 5350.3n (1*vdd) 5400.2n (1*vdd) 5400.3n (0*vdd) 5450.2n (0*vdd) 5450.3n (1*vdd) 5500.2n (1*vdd) 5500.3n (0*vdd) 5550.2n (0*vdd) 5550.3n (1*vdd) 5600.2n (1*vdd) 5600.3n (0*vdd) 5650.2n (0*vdd) 5650.3n (1*vdd) 5700.2n (1*vdd) 5700.3n (0*vdd) 5750.2n (0*vdd) 5750.3n (1*vdd) 5800.2n (1*vdd) 5800.3n (0*vdd) 5850.2n (0*vdd) 5850.3n (1*vdd) 5900.2n (1*vdd) 5900.3n (0*vdd) 5950.2n (0*vdd) 5950.3n (1*vdd) 6000.2n (1*vdd) 6000.3n (0*vdd) 6050.2n (0*vdd) 6050.3n (1*vdd) 6100.2n (1*vdd) 6100.3n (0*vdd) 6150.2n (0*vdd) 6150.3n (1*vdd) 6200.2n (1*vdd) 6200.3n (0*vdd) 6250.2n (0*vdd) 6250.3n (1*vdd) 6300.2n (1*vdd) 6300.3n (0*vdd) 6350.2n (0*vdd) 6350.3n (1*vdd) 6400.2n (1*vdd) 6400.3n (0*vdd) 6450.2n (0*vdd) 6450.3n (1*vdd) 6500.2n (1*vdd) 6500.3n (0*vdd) 6550.2n (0*vdd) 6550.3n (1*vdd) 6600.2n (1*vdd) 6600.3n (0*vdd) 6650.2n (0*vdd) 6650.3n (1*vdd) 6700.2n (1*vdd) 6700.3n (0*vdd) 6750.2n (0*vdd) 6750.3n (1*vdd) 6800.2n (1*vdd) 6800.3n (0*vdd) 6850.2n (0*vdd) 6850.3n (1*vdd) 6900.2n (1*vdd) 6900.3n (0*vdd) 6950.2n (0*vdd) 6950.3n (1*vdd) 7000.2n (1*vdd) 7000.3n (0*vdd) 7050.2n (0*vdd) 7050.3n (1*vdd) 7100.2n (1*vdd) 7100.3n (0*vdd) 7150.2n (0*vdd) 7150.3n (1*vdd) 7200.2n (1*vdd) 7200.3n (0*vdd) 7250.2n (0*vdd) 7250.3n (1*vdd) 7300.2n (1*vdd) 7300.3n (0*vdd) 7350.2n (0*vdd) 7350.3n (1*vdd) 7400.2n (1*vdd) 7400.3n (0*vdd) 7450.2n (0*vdd) 7450.3n (1*vdd) 7500.2n (1*vdd) 7500.3n (0*vdd) 7550.2n (0*vdd) 7550.3n (1*vdd) 7600.2n (1*vdd) 7600.3n (0*vdd) 7650.2n (0*vdd) 7650.3n (1*vdd) 7700.2n (1*vdd) 7700.3n (0*vdd) 7750.2n (0*vdd) 7750.3n (1*vdd) 7800.2n (1*vdd) 7800.3n (0*vdd) 7850.2n (0*vdd) 7850.3n (1*vdd) 7900.2n (1*vdd) 7900.3n (0*vdd) 7950.2n (0*vdd) 7950.3n (1*vdd) 8000.2n (1*vdd) 8000.3n (0*vdd) 8050.2n (0*vdd) 8050.3n (1*vdd) 8100.2n (1*vdd) 8100.3n (0*vdd) 8150.2n (0*vdd) 8150.3n (1*vdd) 8200.2n (1*vdd) 8200.3n (0*vdd) 8250.2n (0*vdd) 8250.3n (1*vdd) 8300.2n (1*vdd) 8300.3n (0*vdd) 8350.2n (0*vdd) 8350.3n (1*vdd) 8400.2n (1*vdd) 8400.3n (0*vdd) 8450.2n (0*vdd) 8450.3n (1*vdd) 8500.2n (1*vdd) 8500.3n (0*vdd) 8550.2n (0*vdd) 8550.3n (1*vdd) 8600.2n (1*vdd) 8600.3n (0*vdd) 8650.2n (0*vdd) 8650.3n (1*vdd) 8700.2n (1*vdd) 8700.3n (0*vdd) 8750.2n (0*vdd) 8750.3n (1*vdd) 8800.2n (1*vdd) 8800.3n (0*vdd) 8850.2n (0*vdd) 8850.3n (1*vdd) 8900.2n (1*vdd) 8900.3n (0*vdd) 8950.2n (0*vdd) 8950.3n (1*vdd) 9000.2n (1*vdd) 9000.3n (0*vdd) 9050.2n (0*vdd) 9050.3n (1*vdd) 9100.2n (1*vdd) 9100.3n (0*vdd) 9150.2n (0*vdd) 9150.3n (1*vdd) 9200.2n (1*vdd) 9200.3n (0*vdd) 9250.2n (0*vdd) 9250.3n (1*vdd) 9300.2n (1*vdd) 9300.3n (0*vdd) 9350.2n (0*vdd) 9350.3n (1*vdd) 9400.2n (1*vdd) 9400.3n (0*vdd) 9450.2n (0*vdd) 9450.3n (1*vdd) 9500.2n (1*vdd) 9500.3n (0*vdd) 9550.2n (0*vdd) 9550.3n (1*vdd) 9600.2n (1*vdd) 9600.3n (0*vdd) 9650.2n (0*vdd) 9650.3n (1*vdd) 9700.2n (1*vdd) 9700.3n (0*vdd) 9750.2n (0*vdd) 9750.3n (1*vdd) 9800.2n (1*vdd) 9800.3n (0*vdd) 9850.2n (0*vdd) 9850.3n (1*vdd) 9900.2n (1*vdd) 9900.3n (0*vdd) 9950.2n (0*vdd) 9950.3n (1*vdd) 10000.2n (1*vdd) 10000.3n (0*vdd) 10050.2n (0*vdd) 10050.3n (1*vdd) 10100.2n (1*vdd) 10100.3n (0*vdd) 10150.2n (0*vdd) 10150.3n (1*vdd) 10200.2n (1*vdd) 10200.3n (0*vdd) 10250.2n (0*vdd) 10250.3n (1*vdd) 10300.2n (1*vdd) 10300.3n (0*vdd) 10350.2n (0*vdd) 10350.3n (1*vdd) 10400.2n (1*vdd) 10400.3n (0*vdd) 10450.2n (0*vdd) 10450.3n (1*vdd) 10500.2n (1*vdd) 10500.3n (0*vdd) 10550.2n (0*vdd) 10550.3n (1*vdd) 10600.2n (1*vdd) 10600.3n (0*vdd) 10650.2n (0*vdd) 10650.3n (1*vdd) 10700.2n (1*vdd) 10700.3n (0*vdd) 10750.2n (0*vdd) 10750.3n (1*vdd) 10800.2n (1*vdd) 10800.3n (0*vdd) 10900.2n (0*vdd) 10900.3n (1*vdd) 11000.2n (1*vdd) 11000.3n (0*vdd) 11100.2n (0*vdd) 11100.3n (1*vdd) 11200.2n (1*vdd) 11200.3n (0*vdd) 11300.2n (0*vdd) 11300.3n (1*vdd) 11400.2n (1*vdd) 11400.3n (0*vdd) 11500.2n (0*vdd) 11500.3n (1*vdd) 11600.2n (1*vdd) 11600.3n (0*vdd) 11650.2n (0*vdd) 11650.3n (1*vdd) 11700.2n (1*vdd) 11700.3n (0*vdd) 11750.2n (0*vdd) 11750.3n (1*vdd) 11800.2n (1*vdd) 11800.3n (0*vdd) 11850.2n (0*vdd) 11850.3n (1*vdd) 11900.2n (1*vdd) 11900.3n (0*vdd) 11950.2n (0*vdd) 11950.3n (1*vdd) 12000.2n (1*vdd) 12000.3n (0*vdd) 12050.2n (0*vdd) 12050.3n (1*vdd) 12100.2n (1*vdd) 12100.3n (0*vdd) 12150.2n (0*vdd) 12150.3n (1*vdd) 12200n (1*vdd)]
VWR (WR 0) vsource type=pwl wave=[0n (0*vdd) 0.2n (0*vdd) 0.3n (1*vdd) 1200.2n (1*vdd) 1200.3n (0*vdd) 3600.2n (0*vdd) 3600.3n (1*vdd) 4800.2n (1*vdd) 4800.3n (0*vdd) 7200.2n (0*vdd) 7200.3n (1*vdd) 8400.2n (1*vdd) 8400.3n (0*vdd) 10800.2n (0*vdd) 10800.3n (1*vdd) 10850.2n (1*vdd) 10850.3n (0*vdd) 10900.2n (0*vdd) 10900.3n (1*vdd) 10950.2n (1*vdd) 10950.3n (0*vdd) 11000.2n (0*vdd) 11000.3n (1*vdd) 11050.2n (1*vdd) 11050.3n (0*vdd) 11100.2n (0*vdd) 11100.3n (1*vdd) 11150.2n (1*vdd) 11150.3n (0*vdd) 11200.2n (0*vdd) 11200.3n (1*vdd) 11250.2n (1*vdd) 11250.3n (0*vdd) 11300.2n (0*vdd) 11300.3n (1*vdd) 11350.2n (1*vdd) 11350.3n (0*vdd) 11400.2n (0*vdd) 11400.3n (1*vdd) 11450.2n (1*vdd) 11450.3n (0*vdd) 11500.2n (0*vdd) 11500.3n (1*vdd) 11550.2n (1*vdd) 11550.3n (0*vdd) 11600.2n (0*vdd) 11600.3n (1*vdd) 12200n (1*vdd)]
VRD (RD 0) vsource type=pwl wave=[0n (0*vdd) 1200.2n (0*vdd) 1200.3n (1*vdd) 3600.2n (1*vdd) 3600.3n (0*vdd) 4800.2n (0*vdd) 4800.3n (1*vdd) 7200.2n (1*vdd) 7200.3n (0*vdd) 8400.2n (0*vdd) 8400.3n (1*vdd) 10800.2n (1*vdd) 10800.3n (0*vdd) 10850.2n (0*vdd) 10850.3n (1*vdd) 10900.2n (1*vdd) 10900.3n (0*vdd) 10950.2n (0*vdd) 10950.3n (1*vdd) 11000.2n (1*vdd) 11000.3n (0*vdd) 11050.2n (0*vdd) 11050.3n (1*vdd) 11100.2n (1*vdd) 11100.3n (0*vdd) 11150.2n (0*vdd) 11150.3n (1*vdd) 11200.2n (1*vdd) 11200.3n (0*vdd) 11250.2n (0*vdd) 11250.3n (1*vdd) 11300.2n (1*vdd) 11300.3n (0*vdd) 11350.2n (0*vdd) 11350.3n (1*vdd) 11400.2n (1*vdd) 11400.3n (0*vdd) 11450.2n (0*vdd) 11450.3n (1*vdd) 11500.2n (1*vdd) 11500.3n (0*vdd) 11550.2n (0*vdd) 11550.3n (1*vdd) 12000.2n (1*vdd) 12000.3n (0*vdd) 12200n (0*vdd)]
VDIN (DIN 0) vsource type=pwl wave=[0n (0*vdd) 0.2n (0*vdd) 0.3n (1*vdd) 3600.2n (1*vdd) 3600.3n (0*vdd) 7200.2n (0*vdd) 7200.3n (1*vdd) 7250.2n (1*vdd) 7250.3n (0*vdd) 7350.2n (0*vdd) 7350.3n (1*vdd) 7450.2n (1*vdd) 7450.3n (0*vdd) 7500.2n (0*vdd) 7500.3n (1*vdd) 7550.2n (1*vdd) 7550.3n (0*vdd) 7600.2n (0*vdd) 7600.3n (1*vdd) 7650.2n (1*vdd) 7650.3n (0*vdd) 7750.2n (0*vdd) 7750.3n (1*vdd) 7800.2n (1*vdd) 7800.3n (0*vdd) 7850.2n (0*vdd) 7850.3n (1*vdd) 7950.2n (1*vdd) 7950.3n (0*vdd) 8050.2n (0*vdd) 8050.3n (1*vdd) 8200.2n (1*vdd) 8200.3n (0*vdd) 8300.2n (0*vdd) 8300.3n (1*vdd) 8350.2n (1*vdd) 8350.3n (0*vdd) 8400.2n (0*vdd) 8400.3n (1*vdd) 8450.2n (1*vdd) 8450.3n (0*vdd) 8550.2n (0*vdd) 8550.3n (1*vdd) 8650.2n (1*vdd) 8650.3n (0*vdd) 8700.2n (0*vdd) 8700.3n (1*vdd) 8750.2n (1*vdd) 8750.3n (0*vdd) 8800.2n (0*vdd) 8800.3n (1*vdd) 8850.2n (1*vdd) 8850.3n (0*vdd) 8950.2n (0*vdd) 8950.3n (1*vdd) 9000.2n (1*vdd) 9000.3n (0*vdd) 9050.2n (0*vdd) 9050.3n (1*vdd) 9150.2n (1*vdd) 9150.3n (0*vdd) 9250.2n (0*vdd) 9250.3n (1*vdd) 9400.2n (1*vdd) 9400.3n (0*vdd) 9500.2n (0*vdd) 9500.3n (1*vdd) 9550.2n (1*vdd) 9550.3n (0*vdd) 9600.2n (0*vdd) 9600.3n (1*vdd) 9650.2n (1*vdd) 9650.3n (0*vdd) 9750.2n (0*vdd) 9750.3n (1*vdd) 9850.2n (1*vdd) 9850.3n (0*vdd) 9900.2n (0*vdd) 9900.3n (1*vdd) 9950.2n (1*vdd) 9950.3n (0*vdd) 10000.2n (0*vdd) 10000.3n (1*vdd) 10050.2n (1*vdd) 10050.3n (0*vdd) 10150.2n (0*vdd) 10150.3n (1*vdd) 10200.2n (1*vdd) 10200.3n (0*vdd) 10250.2n (0*vdd) 10250.3n (1*vdd) 10350.2n (1*vdd) 10350.3n (0*vdd) 10450.2n (0*vdd) 10450.3n (1*vdd) 10600.2n (1*vdd) 10600.3n (0*vdd) 10700.2n (0*vdd) 10700.3n (1*vdd) 10750.2n (1*vdd) 10750.3n (0*vdd) 10800.2n (0*vdd) 10800.3n (1*vdd) 12200n (1*vdd)]
VCLK1 (CLK1 0) vsource type=pwl wave=[0n (0*vdd) 20n (0*vdd) 20.1n (1*vdd) 40n (1*vdd) 40.1n (0*vdd) 70n (0*vdd) 70.1n (1*vdd) 90n (1*vdd) 90.1n (0*vdd) 120n (0*vdd) 120.1n (1*vdd) 140n (1*vdd) 140.1n (0*vdd) 170n (0*vdd) 170.1n (1*vdd) 190n (1*vdd) 190.1n (0*vdd) 220n (0*vdd) 220.1n (1*vdd) 240n (1*vdd) 240.1n (0*vdd) 270n (0*vdd) 270.1n (1*vdd) 290n (1*vdd) 290.1n (0*vdd) 320n (0*vdd) 320.1n (1*vdd) 340n (1*vdd) 340.1n (0*vdd) 370n (0*vdd) 370.1n (1*vdd) 390n (1*vdd) 390.1n (0*vdd) 420n (0*vdd) 420.1n (1*vdd) 440n (1*vdd) 440.1n (0*vdd) 470n (0*vdd) 470.1n (1*vdd) 490n (1*vdd) 490.1n (0*vdd) 520n (0*vdd) 520.1n (1*vdd) 540n (1*vdd) 540.1n (0*vdd) 570n (0*vdd) 570.1n (1*vdd) 590n (1*vdd) 590.1n (0*vdd) 620n (0*vdd) 620.1n (1*vdd) 640n (1*vdd) 640.1n (0*vdd) 670n (0*vdd) 670.1n (1*vdd) 690n (1*vdd) 690.1n (0*vdd) 720n (0*vdd) 720.1n (1*vdd) 740n (1*vdd) 740.1n (0*vdd) 770n (0*vdd) 770.1n (1*vdd) 790n (1*vdd) 790.1n (0*vdd) 820n (0*vdd) 820.1n (1*vdd) 840n (1*vdd) 840.1n (0*vdd) 870n (0*vdd) 870.1n (1*vdd) 890n (1*vdd) 890.1n (0*vdd) 920n (0*vdd) 920.1n (1*vdd) 940n (1*vdd) 940.1n (0*vdd) 970n (0*vdd) 970.1n (1*vdd) 990n (1*vdd) 990.1n (0*vdd) 1020n (0*vdd) 1020.1n (1*vdd) 1040n (1*vdd) 1040.1n (0*vdd) 1070n (0*vdd) 1070.1n (1*vdd) 1090n (1*vdd) 1090.1n (0*vdd) 1120n (0*vdd) 1120.1n (1*vdd) 1140n (1*vdd) 1140.1n (0*vdd) 1170n (0*vdd) 1170.1n (1*vdd) 1190n (1*vdd) 1190.1n (0*vdd) 1220n (0*vdd) 1220.1n (1*vdd) 1240n (1*vdd) 1240.1n (0*vdd) 1270n (0*vdd) 1270.1n (1*vdd) 1290n (1*vdd) 1290.1n (0*vdd) 1320n (0*vdd) 1320.1n (1*vdd) 1340n (1*vdd) 1340.1n (0*vdd) 1370n (0*vdd) 1370.1n (1*vdd) 1390n (1*vdd) 1390.1n (0*vdd) 1420n (0*vdd) 1420.1n (1*vdd) 1440n (1*vdd) 1440.1n (0*vdd) 1470n (0*vdd) 1470.1n (1*vdd) 1490n (1*vdd) 1490.1n (0*vdd) 1520n (0*vdd) 1520.1n (1*vdd) 1540n (1*vdd) 1540.1n (0*vdd) 1570n (0*vdd) 1570.1n (1*vdd) 1590n (1*vdd) 1590.1n (0*vdd) 1620n (0*vdd) 1620.1n (1*vdd) 1640n (1*vdd) 1640.1n (0*vdd) 1670n (0*vdd) 1670.1n (1*vdd) 1690n (1*vdd) 1690.1n (0*vdd) 1720n (0*vdd) 1720.1n (1*vdd) 1740n (1*vdd) 1740.1n (0*vdd) 1770n (0*vdd) 1770.1n (1*vdd) 1790n (1*vdd) 1790.1n (0*vdd) 1820n (0*vdd) 1820.1n (1*vdd) 1840n (1*vdd) 1840.1n (0*vdd) 1870n (0*vdd) 1870.1n (1*vdd) 1890n (1*vdd) 1890.1n (0*vdd) 1920n (0*vdd) 1920.1n (1*vdd) 1940n (1*vdd) 1940.1n (0*vdd) 1970n (0*vdd) 1970.1n (1*vdd) 1990n (1*vdd) 1990.1n (0*vdd) 2020n (0*vdd) 2020.1n (1*vdd) 2040n (1*vdd) 2040.1n (0*vdd) 2070n (0*vdd) 2070.1n (1*vdd) 2090n (1*vdd) 2090.1n (0*vdd) 2120n (0*vdd) 2120.1n (1*vdd) 2140n (1*vdd) 2140.1n (0*vdd) 2170n (0*vdd) 2170.1n (1*vdd) 2190n (1*vdd) 2190.1n (0*vdd) 2220n (0*vdd) 2220.1n (1*vdd) 2240n (1*vdd) 2240.1n (0*vdd) 2270n (0*vdd) 2270.1n (1*vdd) 2290n (1*vdd) 2290.1n (0*vdd) 2320n (0*vdd) 2320.1n (1*vdd) 2340n (1*vdd) 2340.1n (0*vdd) 2370n (0*vdd) 2370.1n (1*vdd) 2390n (1*vdd) 2390.1n (0*vdd) 2420n (0*vdd) 2420.1n (1*vdd) 2440n (1*vdd) 2440.1n (0*vdd) 2470n (0*vdd) 2470.1n (1*vdd) 2490n (1*vdd) 2490.1n (0*vdd) 2520n (0*vdd) 2520.1n (1*vdd) 2540n (1*vdd) 2540.1n (0*vdd) 2570n (0*vdd) 2570.1n (1*vdd) 2590n (1*vdd) 2590.1n (0*vdd) 2620n (0*vdd) 2620.1n (1*vdd) 2640n (1*vdd) 2640.1n (0*vdd) 2670n (0*vdd) 2670.1n (1*vdd) 2690n (1*vdd) 2690.1n (0*vdd) 2720n (0*vdd) 2720.1n (1*vdd) 2740n (1*vdd) 2740.1n (0*vdd) 2770n (0*vdd) 2770.1n (1*vdd) 2790n (1*vdd) 2790.1n (0*vdd) 2820n (0*vdd) 2820.1n (1*vdd) 2840n (1*vdd) 2840.1n (0*vdd) 2870n (0*vdd) 2870.1n (1*vdd) 2890n (1*vdd) 2890.1n (0*vdd) 2920n (0*vdd) 2920.1n (1*vdd) 2940n (1*vdd) 2940.1n (0*vdd) 2970n (0*vdd) 2970.1n (1*vdd) 2990n (1*vdd) 2990.1n (0*vdd) 3020n (0*vdd) 3020.1n (1*vdd) 3040n (1*vdd) 3040.1n (0*vdd) 3070n (0*vdd) 3070.1n (1*vdd) 3090n (1*vdd) 3090.1n (0*vdd) 3120n (0*vdd) 3120.1n (1*vdd) 3140n (1*vdd) 3140.1n (0*vdd) 3170n (0*vdd) 3170.1n (1*vdd) 3190n (1*vdd) 3190.1n (0*vdd) 3220n (0*vdd) 3220.1n (1*vdd) 3240n (1*vdd) 3240.1n (0*vdd) 3270n (0*vdd) 3270.1n (1*vdd) 3290n (1*vdd) 3290.1n (0*vdd) 3320n (0*vdd) 3320.1n (1*vdd) 3340n (1*vdd) 3340.1n (0*vdd) 3370n (0*vdd) 3370.1n (1*vdd) 3390n (1*vdd) 3390.1n (0*vdd) 3420n (0*vdd) 3420.1n (1*vdd) 3440n (1*vdd) 3440.1n (0*vdd) 3470n (0*vdd) 3470.1n (1*vdd) 3490n (1*vdd) 3490.1n (0*vdd) 3520n (0*vdd) 3520.1n (1*vdd) 3540n (1*vdd) 3540.1n (0*vdd) 3570n (0*vdd) 3570.1n (1*vdd) 3590n (1*vdd) 3590.1n (0*vdd) 3620n (0*vdd) 3620.1n (1*vdd) 3640n (1*vdd) 3640.1n (0*vdd) 3670n (0*vdd) 3670.1n (1*vdd) 3690n (1*vdd) 3690.1n (0*vdd) 3720n (0*vdd) 3720.1n (1*vdd) 3740n (1*vdd) 3740.1n (0*vdd) 3770n (0*vdd) 3770.1n (1*vdd) 3790n (1*vdd) 3790.1n (0*vdd) 3820n (0*vdd) 3820.1n (1*vdd) 3840n (1*vdd) 3840.1n (0*vdd) 3870n (0*vdd) 3870.1n (1*vdd) 3890n (1*vdd) 3890.1n (0*vdd) 3920n (0*vdd) 3920.1n (1*vdd) 3940n (1*vdd) 3940.1n (0*vdd) 3970n (0*vdd) 3970.1n (1*vdd) 3990n (1*vdd) 3990.1n (0*vdd) 4020n (0*vdd) 4020.1n (1*vdd) 4040n (1*vdd) 4040.1n (0*vdd) 4070n (0*vdd) 4070.1n (1*vdd) 4090n (1*vdd) 4090.1n (0*vdd) 4120n (0*vdd) 4120.1n (1*vdd) 4140n (1*vdd) 4140.1n (0*vdd) 4170n (0*vdd) 4170.1n (1*vdd) 4190n (1*vdd) 4190.1n (0*vdd) 4220n (0*vdd) 4220.1n (1*vdd) 4240n (1*vdd) 4240.1n (0*vdd) 4270n (0*vdd) 4270.1n (1*vdd) 4290n (1*vdd) 4290.1n (0*vdd) 4320n (0*vdd) 4320.1n (1*vdd) 4340n (1*vdd) 4340.1n (0*vdd) 4370n (0*vdd) 4370.1n (1*vdd) 4390n (1*vdd) 4390.1n (0*vdd) 4420n (0*vdd) 4420.1n (1*vdd) 4440n (1*vdd) 4440.1n (0*vdd) 4470n (0*vdd) 4470.1n (1*vdd) 4490n (1*vdd) 4490.1n (0*vdd) 4520n (0*vdd) 4520.1n (1*vdd) 4540n (1*vdd) 4540.1n (0*vdd) 4570n (0*vdd) 4570.1n (1*vdd) 4590n (1*vdd) 4590.1n (0*vdd) 4620n (0*vdd) 4620.1n (1*vdd) 4640n (1*vdd) 4640.1n (0*vdd) 4670n (0*vdd) 4670.1n (1*vdd) 4690n (1*vdd) 4690.1n (0*vdd) 4720n (0*vdd) 4720.1n (1*vdd) 4740n (1*vdd) 4740.1n (0*vdd) 4770n (0*vdd) 4770.1n (1*vdd) 4790n (1*vdd) 4790.1n (0*vdd) 4820n (0*vdd) 4820.1n (1*vdd) 4840n (1*vdd) 4840.1n (0*vdd) 4870n (0*vdd) 4870.1n (1*vdd) 4890n (1*vdd) 4890.1n (0*vdd) 4920n (0*vdd) 4920.1n (1*vdd) 4940n (1*vdd) 4940.1n (0*vdd) 4970n (0*vdd) 4970.1n (1*vdd) 4990n (1*vdd) 4990.1n (0*vdd) 5020n (0*vdd) 5020.1n (1*vdd) 5040n (1*vdd) 5040.1n (0*vdd) 5070n (0*vdd) 5070.1n (1*vdd) 5090n (1*vdd) 5090.1n (0*vdd) 5120n (0*vdd) 5120.1n (1*vdd) 5140n (1*vdd) 5140.1n (0*vdd) 5170n (0*vdd) 5170.1n (1*vdd) 5190n (1*vdd) 5190.1n (0*vdd) 5220n (0*vdd) 5220.1n (1*vdd) 5240n (1*vdd) 5240.1n (0*vdd) 5270n (0*vdd) 5270.1n (1*vdd) 5290n (1*vdd) 5290.1n (0*vdd) 5320n (0*vdd) 5320.1n (1*vdd) 5340n (1*vdd) 5340.1n (0*vdd) 5370n (0*vdd) 5370.1n (1*vdd) 5390n (1*vdd) 5390.1n (0*vdd) 5420n (0*vdd) 5420.1n (1*vdd) 5440n (1*vdd) 5440.1n (0*vdd) 5470n (0*vdd) 5470.1n (1*vdd) 5490n (1*vdd) 5490.1n (0*vdd) 5520n (0*vdd) 5520.1n (1*vdd) 5540n (1*vdd) 5540.1n (0*vdd) 5570n (0*vdd) 5570.1n (1*vdd) 5590n (1*vdd) 5590.1n (0*vdd) 5620n (0*vdd) 5620.1n (1*vdd) 5640n (1*vdd) 5640.1n (0*vdd) 5670n (0*vdd) 5670.1n (1*vdd) 5690n (1*vdd) 5690.1n (0*vdd) 5720n (0*vdd) 5720.1n (1*vdd) 5740n (1*vdd) 5740.1n (0*vdd) 5770n (0*vdd) 5770.1n (1*vdd) 5790n (1*vdd) 5790.1n (0*vdd) 5820n (0*vdd) 5820.1n (1*vdd) 5840n (1*vdd) 5840.1n (0*vdd) 5870n (0*vdd) 5870.1n (1*vdd) 5890n (1*vdd) 5890.1n (0*vdd) 5920n (0*vdd) 5920.1n (1*vdd) 5940n (1*vdd) 5940.1n (0*vdd) 5970n (0*vdd) 5970.1n (1*vdd) 5990n (1*vdd) 5990.1n (0*vdd) 6020n (0*vdd) 6020.1n (1*vdd) 6040n (1*vdd) 6040.1n (0*vdd) 6070n (0*vdd) 6070.1n (1*vdd) 6090n (1*vdd) 6090.1n (0*vdd) 6120n (0*vdd) 6120.1n (1*vdd) 6140n (1*vdd) 6140.1n (0*vdd) 6170n (0*vdd) 6170.1n (1*vdd) 6190n (1*vdd) 6190.1n (0*vdd) 6220n (0*vdd) 6220.1n (1*vdd) 6240n (1*vdd) 6240.1n (0*vdd) 6270n (0*vdd) 6270.1n (1*vdd) 6290n (1*vdd) 6290.1n (0*vdd) 6320n (0*vdd) 6320.1n (1*vdd) 6340n (1*vdd) 6340.1n (0*vdd) 6370n (0*vdd) 6370.1n (1*vdd) 6390n (1*vdd) 6390.1n (0*vdd) 6420n (0*vdd) 6420.1n (1*vdd) 6440n (1*vdd) 6440.1n (0*vdd) 6470n (0*vdd) 6470.1n (1*vdd) 6490n (1*vdd) 6490.1n (0*vdd) 6520n (0*vdd) 6520.1n (1*vdd) 6540n (1*vdd) 6540.1n (0*vdd) 6570n (0*vdd) 6570.1n (1*vdd) 6590n (1*vdd) 6590.1n (0*vdd) 6620n (0*vdd) 6620.1n (1*vdd) 6640n (1*vdd) 6640.1n (0*vdd) 6670n (0*vdd) 6670.1n (1*vdd) 6690n (1*vdd) 6690.1n (0*vdd) 6720n (0*vdd) 6720.1n (1*vdd) 6740n (1*vdd) 6740.1n (0*vdd) 6770n (0*vdd) 6770.1n (1*vdd) 6790n (1*vdd) 6790.1n (0*vdd) 6820n (0*vdd) 6820.1n (1*vdd) 6840n (1*vdd) 6840.1n (0*vdd) 6870n (0*vdd) 6870.1n (1*vdd) 6890n (1*vdd) 6890.1n (0*vdd) 6920n (0*vdd) 6920.1n (1*vdd) 6940n (1*vdd) 6940.1n (0*vdd) 6970n (0*vdd) 6970.1n (1*vdd) 6990n (1*vdd) 6990.1n (0*vdd) 7020n (0*vdd) 7020.1n (1*vdd) 7040n (1*vdd) 7040.1n (0*vdd) 7070n (0*vdd) 7070.1n (1*vdd) 7090n (1*vdd) 7090.1n (0*vdd) 7120n (0*vdd) 7120.1n (1*vdd) 7140n (1*vdd) 7140.1n (0*vdd) 7170n (0*vdd) 7170.1n (1*vdd) 7190n (1*vdd) 7190.1n (0*vdd) 7220n (0*vdd) 7220.1n (1*vdd) 7240n (1*vdd) 7240.1n (0*vdd) 7270n (0*vdd) 7270.1n (1*vdd) 7290n (1*vdd) 7290.1n (0*vdd) 7320n (0*vdd) 7320.1n (1*vdd) 7340n (1*vdd) 7340.1n (0*vdd) 7370n (0*vdd) 7370.1n (1*vdd) 7390n (1*vdd) 7390.1n (0*vdd) 7420n (0*vdd) 7420.1n (1*vdd) 7440n (1*vdd) 7440.1n (0*vdd) 7470n (0*vdd) 7470.1n (1*vdd) 7490n (1*vdd) 7490.1n (0*vdd) 7520n (0*vdd) 7520.1n (1*vdd) 7540n (1*vdd) 7540.1n (0*vdd) 7570n (0*vdd) 7570.1n (1*vdd) 7590n (1*vdd) 7590.1n (0*vdd) 7620n (0*vdd) 7620.1n (1*vdd) 7640n (1*vdd) 7640.1n (0*vdd) 7670n (0*vdd) 7670.1n (1*vdd) 7690n (1*vdd) 7690.1n (0*vdd) 7720n (0*vdd) 7720.1n (1*vdd) 7740n (1*vdd) 7740.1n (0*vdd) 7770n (0*vdd) 7770.1n (1*vdd) 7790n (1*vdd) 7790.1n (0*vdd) 7820n (0*vdd) 7820.1n (1*vdd) 7840n (1*vdd) 7840.1n (0*vdd) 7870n (0*vdd) 7870.1n (1*vdd) 7890n (1*vdd) 7890.1n (0*vdd) 7920n (0*vdd) 7920.1n (1*vdd) 7940n (1*vdd) 7940.1n (0*vdd) 7970n (0*vdd) 7970.1n (1*vdd) 7990n (1*vdd) 7990.1n (0*vdd) 8020n (0*vdd) 8020.1n (1*vdd) 8040n (1*vdd) 8040.1n (0*vdd) 8070n (0*vdd) 8070.1n (1*vdd) 8090n (1*vdd) 8090.1n (0*vdd) 8120n (0*vdd) 8120.1n (1*vdd) 8140n (1*vdd) 8140.1n (0*vdd) 8170n (0*vdd) 8170.1n (1*vdd) 8190n (1*vdd) 8190.1n (0*vdd) 8220n (0*vdd) 8220.1n (1*vdd) 8240n (1*vdd) 8240.1n (0*vdd) 8270n (0*vdd) 8270.1n (1*vdd) 8290n (1*vdd) 8290.1n (0*vdd) 8320n (0*vdd) 8320.1n (1*vdd) 8340n (1*vdd) 8340.1n (0*vdd) 8370n (0*vdd) 8370.1n (1*vdd) 8390n (1*vdd) 8390.1n (0*vdd) 8420n (0*vdd) 8420.1n (1*vdd) 8440n (1*vdd) 8440.1n (0*vdd) 8470n (0*vdd) 8470.1n (1*vdd) 8490n (1*vdd) 8490.1n (0*vdd) 8520n (0*vdd) 8520.1n (1*vdd) 8540n (1*vdd) 8540.1n (0*vdd) 8570n (0*vdd) 8570.1n (1*vdd) 8590n (1*vdd) 8590.1n (0*vdd) 8620n (0*vdd) 8620.1n (1*vdd) 8640n (1*vdd) 8640.1n (0*vdd) 8670n (0*vdd) 8670.1n (1*vdd) 8690n (1*vdd) 8690.1n (0*vdd) 8720n (0*vdd) 8720.1n (1*vdd) 8740n (1*vdd) 8740.1n (0*vdd) 8770n (0*vdd) 8770.1n (1*vdd) 8790n (1*vdd) 8790.1n (0*vdd) 8820n (0*vdd) 8820.1n (1*vdd) 8840n (1*vdd) 8840.1n (0*vdd) 8870n (0*vdd) 8870.1n (1*vdd) 8890n (1*vdd) 8890.1n (0*vdd) 8920n (0*vdd) 8920.1n (1*vdd) 8940n (1*vdd) 8940.1n (0*vdd) 8970n (0*vdd) 8970.1n (1*vdd) 8990n (1*vdd) 8990.1n (0*vdd) 9020n (0*vdd) 9020.1n (1*vdd) 9040n (1*vdd) 9040.1n (0*vdd) 9070n (0*vdd) 9070.1n (1*vdd) 9090n (1*vdd) 9090.1n (0*vdd) 9120n (0*vdd) 9120.1n (1*vdd) 9140n (1*vdd) 9140.1n (0*vdd) 9170n (0*vdd) 9170.1n (1*vdd) 9190n (1*vdd) 9190.1n (0*vdd) 9220n (0*vdd) 9220.1n (1*vdd) 9240n (1*vdd) 9240.1n (0*vdd) 9270n (0*vdd) 9270.1n (1*vdd) 9290n (1*vdd) 9290.1n (0*vdd) 9320n (0*vdd) 9320.1n (1*vdd) 9340n (1*vdd) 9340.1n (0*vdd) 9370n (0*vdd) 9370.1n (1*vdd) 9390n (1*vdd) 9390.1n (0*vdd) 9420n (0*vdd) 9420.1n (1*vdd) 9440n (1*vdd) 9440.1n (0*vdd) 9470n (0*vdd) 9470.1n (1*vdd) 9490n (1*vdd) 9490.1n (0*vdd) 9520n (0*vdd) 9520.1n (1*vdd) 9540n (1*vdd) 9540.1n (0*vdd) 9570n (0*vdd) 9570.1n (1*vdd) 9590n (1*vdd) 9590.1n (0*vdd) 9620n (0*vdd) 9620.1n (1*vdd) 9640n (1*vdd) 9640.1n (0*vdd) 9670n (0*vdd) 9670.1n (1*vdd) 9690n (1*vdd) 9690.1n (0*vdd) 9720n (0*vdd) 9720.1n (1*vdd) 9740n (1*vdd) 9740.1n (0*vdd) 9770n (0*vdd) 9770.1n (1*vdd) 9790n (1*vdd) 9790.1n (0*vdd) 9820n (0*vdd) 9820.1n (1*vdd) 9840n (1*vdd) 9840.1n (0*vdd) 9870n (0*vdd) 9870.1n (1*vdd) 9890n (1*vdd) 9890.1n (0*vdd) 9920n (0*vdd) 9920.1n (1*vdd) 9940n (1*vdd) 9940.1n (0*vdd) 9970n (0*vdd) 9970.1n (1*vdd) 9990n (1*vdd) 9990.1n (0*vdd) 10020n (0*vdd) 10020.1n (1*vdd) 10040n (1*vdd) 10040.1n (0*vdd) 10070n (0*vdd) 10070.1n (1*vdd) 10090n (1*vdd) 10090.1n (0*vdd) 10120n (0*vdd) 10120.1n (1*vdd) 10140n (1*vdd) 10140.1n (0*vdd) 10170n (0*vdd) 10170.1n (1*vdd) 10190n (1*vdd) 10190.1n (0*vdd) 10220n (0*vdd) 10220.1n (1*vdd) 10240n (1*vdd) 10240.1n (0*vdd) 10270n (0*vdd) 10270.1n (1*vdd) 10290n (1*vdd) 10290.1n (0*vdd) 10320n (0*vdd) 10320.1n (1*vdd) 10340n (1*vdd) 10340.1n (0*vdd) 10370n (0*vdd) 10370.1n (1*vdd) 10390n (1*vdd) 10390.1n (0*vdd) 10420n (0*vdd) 10420.1n (1*vdd) 10440n (1*vdd) 10440.1n (0*vdd) 10470n (0*vdd) 10470.1n (1*vdd) 10490n (1*vdd) 10490.1n (0*vdd) 10520n (0*vdd) 10520.1n (1*vdd) 10540n (1*vdd) 10540.1n (0*vdd) 10570n (0*vdd) 10570.1n (1*vdd) 10590n (1*vdd) 10590.1n (0*vdd) 10620n (0*vdd) 10620.1n (1*vdd) 10640n (1*vdd) 10640.1n (0*vdd) 10670n (0*vdd) 10670.1n (1*vdd) 10690n (1*vdd) 10690.1n (0*vdd) 10720n (0*vdd) 10720.1n (1*vdd) 10740n (1*vdd) 10740.1n (0*vdd) 10770n (0*vdd) 10770.1n (1*vdd) 10790n (1*vdd) 10790.1n (0*vdd) 10820n (0*vdd) 10820.1n (1*vdd) 10840n (1*vdd) 10840.1n (0*vdd) 10870n (0*vdd) 10870.1n (1*vdd) 10890n (1*vdd) 10890.1n (0*vdd) 10920n (0*vdd) 10920.1n (1*vdd) 10940n (1*vdd) 10940.1n (0*vdd) 10970n (0*vdd) 10970.1n (1*vdd) 10990n (1*vdd) 10990.1n (0*vdd) 11020n (0*vdd) 11020.1n (1*vdd) 11040n (1*vdd) 11040.1n (0*vdd) 11070n (0*vdd) 11070.1n (1*vdd) 11090n (1*vdd) 11090.1n (0*vdd) 11120n (0*vdd) 11120.1n (1*vdd) 11140n (1*vdd) 11140.1n (0*vdd) 11170n (0*vdd) 11170.1n (1*vdd) 11190n (1*vdd) 11190.1n (0*vdd) 11220n (0*vdd) 11220.1n (1*vdd) 11240n (1*vdd) 11240.1n (0*vdd) 11270n (0*vdd) 11270.1n (1*vdd) 11290n (1*vdd) 11290.1n (0*vdd) 11320n (0*vdd) 11320.1n (1*vdd) 11340n (1*vdd) 11340.1n (0*vdd) 11370n (0*vdd) 11370.1n (1*vdd) 11390n (1*vdd) 11390.1n (0*vdd) 11420n (0*vdd) 11420.1n (1*vdd) 11440n (1*vdd) 11440.1n (0*vdd) 11470n (0*vdd) 11470.1n (1*vdd) 11490n (1*vdd) 11490.1n (0*vdd) 11520n (0*vdd) 11520.1n (1*vdd) 11540n (1*vdd) 11540.1n (0*vdd) 11570n (0*vdd) 11570.1n (1*vdd) 11590n (1*vdd) 11590.1n (0*vdd) 11620n (0*vdd) 11620.1n (1*vdd) 11640n (1*vdd) 11640.1n (0*vdd) 11670n (0*vdd) 11670.1n (1*vdd) 11690n (1*vdd) 11690.1n (0*vdd) 11720n (0*vdd) 11720.1n (1*vdd) 11740n (1*vdd) 11740.1n (0*vdd) 11770n (0*vdd) 11770.1n (1*vdd) 11790n (1*vdd) 11790.1n (0*vdd) 11820n (0*vdd) 11820.1n (1*vdd) 11840n (1*vdd) 11840.1n (0*vdd) 11870n (0*vdd) 11870.1n (1*vdd) 11890n (1*vdd) 11890.1n (0*vdd) 11920n (0*vdd) 11920.1n (1*vdd) 11940n (1*vdd) 11940.1n (0*vdd) 11970n (0*vdd) 11970.1n (1*vdd) 11990n (1*vdd) 11990.1n (0*vdd) 12020n (0*vdd) 12020.1n (1*vdd) 12040n (1*vdd) 12040.1n (0*vdd) 12070n (0*vdd) 12070.1n (1*vdd) 12090n (1*vdd) 12090.1n (0*vdd) 12120n (0*vdd) 12120.1n (1*vdd) 12140n (1*vdd) 12140.1n (0*vdd) 12170n (0*vdd) 12170.1n (1*vdd) 12190n (1*vdd) 12190.1n (0*vdd) 12200n (0*vdd)]
VCLK2 (CLK2 0) vsource type=pwl wave=[0n (0*vdd) 2n (0*vdd) 2.1n (1*vdd) 12n (1*vdd) 12.1n (0*vdd) 52n (0*vdd) 52.1n (1*vdd) 62n (1*vdd) 62.1n (0*vdd) 102n (0*vdd) 102.1n (1*vdd) 112n (1*vdd) 112.1n (0*vdd) 152n (0*vdd) 152.1n (1*vdd) 162n (1*vdd) 162.1n (0*vdd) 202n (0*vdd) 202.1n (1*vdd) 212n (1*vdd) 212.1n (0*vdd) 252n (0*vdd) 252.1n (1*vdd) 262n (1*vdd) 262.1n (0*vdd) 302n (0*vdd) 302.1n (1*vdd) 312n (1*vdd) 312.1n (0*vdd) 352n (0*vdd) 352.1n (1*vdd) 362n (1*vdd) 362.1n (0*vdd) 402n (0*vdd) 402.1n (1*vdd) 412n (1*vdd) 412.1n (0*vdd) 452n (0*vdd) 452.1n (1*vdd) 462n (1*vdd) 462.1n (0*vdd) 502n (0*vdd) 502.1n (1*vdd) 512n (1*vdd) 512.1n (0*vdd) 552n (0*vdd) 552.1n (1*vdd) 562n (1*vdd) 562.1n (0*vdd) 602n (0*vdd) 602.1n (1*vdd) 612n (1*vdd) 612.1n (0*vdd) 652n (0*vdd) 652.1n (1*vdd) 662n (1*vdd) 662.1n (0*vdd) 702n (0*vdd) 702.1n (1*vdd) 712n (1*vdd) 712.1n (0*vdd) 752n (0*vdd) 752.1n (1*vdd) 762n (1*vdd) 762.1n (0*vdd) 802n (0*vdd) 802.1n (1*vdd) 812n (1*vdd) 812.1n (0*vdd) 852n (0*vdd) 852.1n (1*vdd) 862n (1*vdd) 862.1n (0*vdd) 902n (0*vdd) 902.1n (1*vdd) 912n (1*vdd) 912.1n (0*vdd) 952n (0*vdd) 952.1n (1*vdd) 962n (1*vdd) 962.1n (0*vdd) 1002n (0*vdd) 1002.1n (1*vdd) 1012n (1*vdd) 1012.1n (0*vdd) 1052n (0*vdd) 1052.1n (1*vdd) 1062n (1*vdd) 1062.1n (0*vdd) 1102n (0*vdd) 1102.1n (1*vdd) 1112n (1*vdd) 1112.1n (0*vdd) 1152n (0*vdd) 1152.1n (1*vdd) 1162n (1*vdd) 1162.1n (0*vdd) 1202n (0*vdd) 1202.1n (1*vdd) 1212n (1*vdd) 1212.1n (0*vdd) 1252n (0*vdd) 1252.1n (1*vdd) 1262n (1*vdd) 1262.1n (0*vdd) 1302n (0*vdd) 1302.1n (1*vdd) 1312n (1*vdd) 1312.1n (0*vdd) 1352n (0*vdd) 1352.1n (1*vdd) 1362n (1*vdd) 1362.1n (0*vdd) 1402n (0*vdd) 1402.1n (1*vdd) 1412n (1*vdd) 1412.1n (0*vdd) 1452n (0*vdd) 1452.1n (1*vdd) 1462n (1*vdd) 1462.1n (0*vdd) 1502n (0*vdd) 1502.1n (1*vdd) 1512n (1*vdd) 1512.1n (0*vdd) 1552n (0*vdd) 1552.1n (1*vdd) 1562n (1*vdd) 1562.1n (0*vdd) 1602n (0*vdd) 1602.1n (1*vdd) 1612n (1*vdd) 1612.1n (0*vdd) 1652n (0*vdd) 1652.1n (1*vdd) 1662n (1*vdd) 1662.1n (0*vdd) 1702n (0*vdd) 1702.1n (1*vdd) 1712n (1*vdd) 1712.1n (0*vdd) 1752n (0*vdd) 1752.1n (1*vdd) 1762n (1*vdd) 1762.1n (0*vdd) 1802n (0*vdd) 1802.1n (1*vdd) 1812n (1*vdd) 1812.1n (0*vdd) 1852n (0*vdd) 1852.1n (1*vdd) 1862n (1*vdd) 1862.1n (0*vdd) 1902n (0*vdd) 1902.1n (1*vdd) 1912n (1*vdd) 1912.1n (0*vdd) 1952n (0*vdd) 1952.1n (1*vdd) 1962n (1*vdd) 1962.1n (0*vdd) 2002n (0*vdd) 2002.1n (1*vdd) 2012n (1*vdd) 2012.1n (0*vdd) 2052n (0*vdd) 2052.1n (1*vdd) 2062n (1*vdd) 2062.1n (0*vdd) 2102n (0*vdd) 2102.1n (1*vdd) 2112n (1*vdd) 2112.1n (0*vdd) 2152n (0*vdd) 2152.1n (1*vdd) 2162n (1*vdd) 2162.1n (0*vdd) 2202n (0*vdd) 2202.1n (1*vdd) 2212n (1*vdd) 2212.1n (0*vdd) 2252n (0*vdd) 2252.1n (1*vdd) 2262n (1*vdd) 2262.1n (0*vdd) 2302n (0*vdd) 2302.1n (1*vdd) 2312n (1*vdd) 2312.1n (0*vdd) 2352n (0*vdd) 2352.1n (1*vdd) 2362n (1*vdd) 2362.1n (0*vdd) 2402n (0*vdd) 2402.1n (1*vdd) 2412n (1*vdd) 2412.1n (0*vdd) 2452n (0*vdd) 2452.1n (1*vdd) 2462n (1*vdd) 2462.1n (0*vdd) 2502n (0*vdd) 2502.1n (1*vdd) 2512n (1*vdd) 2512.1n (0*vdd) 2552n (0*vdd) 2552.1n (1*vdd) 2562n (1*vdd) 2562.1n (0*vdd) 2602n (0*vdd) 2602.1n (1*vdd) 2612n (1*vdd) 2612.1n (0*vdd) 2652n (0*vdd) 2652.1n (1*vdd) 2662n (1*vdd) 2662.1n (0*vdd) 2702n (0*vdd) 2702.1n (1*vdd) 2712n (1*vdd) 2712.1n (0*vdd) 2752n (0*vdd) 2752.1n (1*vdd) 2762n (1*vdd) 2762.1n (0*vdd) 2802n (0*vdd) 2802.1n (1*vdd) 2812n (1*vdd) 2812.1n (0*vdd) 2852n (0*vdd) 2852.1n (1*vdd) 2862n (1*vdd) 2862.1n (0*vdd) 2902n (0*vdd) 2902.1n (1*vdd) 2912n (1*vdd) 2912.1n (0*vdd) 2952n (0*vdd) 2952.1n (1*vdd) 2962n (1*vdd) 2962.1n (0*vdd) 3002n (0*vdd) 3002.1n (1*vdd) 3012n (1*vdd) 3012.1n (0*vdd) 3052n (0*vdd) 3052.1n (1*vdd) 3062n (1*vdd) 3062.1n (0*vdd) 3102n (0*vdd) 3102.1n (1*vdd) 3112n (1*vdd) 3112.1n (0*vdd) 3152n (0*vdd) 3152.1n (1*vdd) 3162n (1*vdd) 3162.1n (0*vdd) 3202n (0*vdd) 3202.1n (1*vdd) 3212n (1*vdd) 3212.1n (0*vdd) 3252n (0*vdd) 3252.1n (1*vdd) 3262n (1*vdd) 3262.1n (0*vdd) 3302n (0*vdd) 3302.1n (1*vdd) 3312n (1*vdd) 3312.1n (0*vdd) 3352n (0*vdd) 3352.1n (1*vdd) 3362n (1*vdd) 3362.1n (0*vdd) 3402n (0*vdd) 3402.1n (1*vdd) 3412n (1*vdd) 3412.1n (0*vdd) 3452n (0*vdd) 3452.1n (1*vdd) 3462n (1*vdd) 3462.1n (0*vdd) 3502n (0*vdd) 3502.1n (1*vdd) 3512n (1*vdd) 3512.1n (0*vdd) 3552n (0*vdd) 3552.1n (1*vdd) 3562n (1*vdd) 3562.1n (0*vdd) 3602n (0*vdd) 3602.1n (1*vdd) 3612n (1*vdd) 3612.1n (0*vdd) 3652n (0*vdd) 3652.1n (1*vdd) 3662n (1*vdd) 3662.1n (0*vdd) 3702n (0*vdd) 3702.1n (1*vdd) 3712n (1*vdd) 3712.1n (0*vdd) 3752n (0*vdd) 3752.1n (1*vdd) 3762n (1*vdd) 3762.1n (0*vdd) 3802n (0*vdd) 3802.1n (1*vdd) 3812n (1*vdd) 3812.1n (0*vdd) 3852n (0*vdd) 3852.1n (1*vdd) 3862n (1*vdd) 3862.1n (0*vdd) 3902n (0*vdd) 3902.1n (1*vdd) 3912n (1*vdd) 3912.1n (0*vdd) 3952n (0*vdd) 3952.1n (1*vdd) 3962n (1*vdd) 3962.1n (0*vdd) 4002n (0*vdd) 4002.1n (1*vdd) 4012n (1*vdd) 4012.1n (0*vdd) 4052n (0*vdd) 4052.1n (1*vdd) 4062n (1*vdd) 4062.1n (0*vdd) 4102n (0*vdd) 4102.1n (1*vdd) 4112n (1*vdd) 4112.1n (0*vdd) 4152n (0*vdd) 4152.1n (1*vdd) 4162n (1*vdd) 4162.1n (0*vdd) 4202n (0*vdd) 4202.1n (1*vdd) 4212n (1*vdd) 4212.1n (0*vdd) 4252n (0*vdd) 4252.1n (1*vdd) 4262n (1*vdd) 4262.1n (0*vdd) 4302n (0*vdd) 4302.1n (1*vdd) 4312n (1*vdd) 4312.1n (0*vdd) 4352n (0*vdd) 4352.1n (1*vdd) 4362n (1*vdd) 4362.1n (0*vdd) 4402n (0*vdd) 4402.1n (1*vdd) 4412n (1*vdd) 4412.1n (0*vdd) 4452n (0*vdd) 4452.1n (1*vdd) 4462n (1*vdd) 4462.1n (0*vdd) 4502n (0*vdd) 4502.1n (1*vdd) 4512n (1*vdd) 4512.1n (0*vdd) 4552n (0*vdd) 4552.1n (1*vdd) 4562n (1*vdd) 4562.1n (0*vdd) 4602n (0*vdd) 4602.1n (1*vdd) 4612n (1*vdd) 4612.1n (0*vdd) 4652n (0*vdd) 4652.1n (1*vdd) 4662n (1*vdd) 4662.1n (0*vdd) 4702n (0*vdd) 4702.1n (1*vdd) 4712n (1*vdd) 4712.1n (0*vdd) 4752n (0*vdd) 4752.1n (1*vdd) 4762n (1*vdd) 4762.1n (0*vdd) 4802n (0*vdd) 4802.1n (1*vdd) 4812n (1*vdd) 4812.1n (0*vdd) 4852n (0*vdd) 4852.1n (1*vdd) 4862n (1*vdd) 4862.1n (0*vdd) 4902n (0*vdd) 4902.1n (1*vdd) 4912n (1*vdd) 4912.1n (0*vdd) 4952n (0*vdd) 4952.1n (1*vdd) 4962n (1*vdd) 4962.1n (0*vdd) 5002n (0*vdd) 5002.1n (1*vdd) 5012n (1*vdd) 5012.1n (0*vdd) 5052n (0*vdd) 5052.1n (1*vdd) 5062n (1*vdd) 5062.1n (0*vdd) 5102n (0*vdd) 5102.1n (1*vdd) 5112n (1*vdd) 5112.1n (0*vdd) 5152n (0*vdd) 5152.1n (1*vdd) 5162n (1*vdd) 5162.1n (0*vdd) 5202n (0*vdd) 5202.1n (1*vdd) 5212n (1*vdd) 5212.1n (0*vdd) 5252n (0*vdd) 5252.1n (1*vdd) 5262n (1*vdd) 5262.1n (0*vdd) 5302n (0*vdd) 5302.1n (1*vdd) 5312n (1*vdd) 5312.1n (0*vdd) 5352n (0*vdd) 5352.1n (1*vdd) 5362n (1*vdd) 5362.1n (0*vdd) 5402n (0*vdd) 5402.1n (1*vdd) 5412n (1*vdd) 5412.1n (0*vdd) 5452n (0*vdd) 5452.1n (1*vdd) 5462n (1*vdd) 5462.1n (0*vdd) 5502n (0*vdd) 5502.1n (1*vdd) 5512n (1*vdd) 5512.1n (0*vdd) 5552n (0*vdd) 5552.1n (1*vdd) 5562n (1*vdd) 5562.1n (0*vdd) 5602n (0*vdd) 5602.1n (1*vdd) 5612n (1*vdd) 5612.1n (0*vdd) 5652n (0*vdd) 5652.1n (1*vdd) 5662n (1*vdd) 5662.1n (0*vdd) 5702n (0*vdd) 5702.1n (1*vdd) 5712n (1*vdd) 5712.1n (0*vdd) 5752n (0*vdd) 5752.1n (1*vdd) 5762n (1*vdd) 5762.1n (0*vdd) 5802n (0*vdd) 5802.1n (1*vdd) 5812n (1*vdd) 5812.1n (0*vdd) 5852n (0*vdd) 5852.1n (1*vdd) 5862n (1*vdd) 5862.1n (0*vdd) 5902n (0*vdd) 5902.1n (1*vdd) 5912n (1*vdd) 5912.1n (0*vdd) 5952n (0*vdd) 5952.1n (1*vdd) 5962n (1*vdd) 5962.1n (0*vdd) 6002n (0*vdd) 6002.1n (1*vdd) 6012n (1*vdd) 6012.1n (0*vdd) 6052n (0*vdd) 6052.1n (1*vdd) 6062n (1*vdd) 6062.1n (0*vdd) 6102n (0*vdd) 6102.1n (1*vdd) 6112n (1*vdd) 6112.1n (0*vdd) 6152n (0*vdd) 6152.1n (1*vdd) 6162n (1*vdd) 6162.1n (0*vdd) 6202n (0*vdd) 6202.1n (1*vdd) 6212n (1*vdd) 6212.1n (0*vdd) 6252n (0*vdd) 6252.1n (1*vdd) 6262n (1*vdd) 6262.1n (0*vdd) 6302n (0*vdd) 6302.1n (1*vdd) 6312n (1*vdd) 6312.1n (0*vdd) 6352n (0*vdd) 6352.1n (1*vdd) 6362n (1*vdd) 6362.1n (0*vdd) 6402n (0*vdd) 6402.1n (1*vdd) 6412n (1*vdd) 6412.1n (0*vdd) 6452n (0*vdd) 6452.1n (1*vdd) 6462n (1*vdd) 6462.1n (0*vdd) 6502n (0*vdd) 6502.1n (1*vdd) 6512n (1*vdd) 6512.1n (0*vdd) 6552n (0*vdd) 6552.1n (1*vdd) 6562n (1*vdd) 6562.1n (0*vdd) 6602n (0*vdd) 6602.1n (1*vdd) 6612n (1*vdd) 6612.1n (0*vdd) 6652n (0*vdd) 6652.1n (1*vdd) 6662n (1*vdd) 6662.1n (0*vdd) 6702n (0*vdd) 6702.1n (1*vdd) 6712n (1*vdd) 6712.1n (0*vdd) 6752n (0*vdd) 6752.1n (1*vdd) 6762n (1*vdd) 6762.1n (0*vdd) 6802n (0*vdd) 6802.1n (1*vdd) 6812n (1*vdd) 6812.1n (0*vdd) 6852n (0*vdd) 6852.1n (1*vdd) 6862n (1*vdd) 6862.1n (0*vdd) 6902n (0*vdd) 6902.1n (1*vdd) 6912n (1*vdd) 6912.1n (0*vdd) 6952n (0*vdd) 6952.1n (1*vdd) 6962n (1*vdd) 6962.1n (0*vdd) 7002n (0*vdd) 7002.1n (1*vdd) 7012n (1*vdd) 7012.1n (0*vdd) 7052n (0*vdd) 7052.1n (1*vdd) 7062n (1*vdd) 7062.1n (0*vdd) 7102n (0*vdd) 7102.1n (1*vdd) 7112n (1*vdd) 7112.1n (0*vdd) 7152n (0*vdd) 7152.1n (1*vdd) 7162n (1*vdd) 7162.1n (0*vdd) 7202n (0*vdd) 7202.1n (1*vdd) 7212n (1*vdd) 7212.1n (0*vdd) 7252n (0*vdd) 7252.1n (1*vdd) 7262n (1*vdd) 7262.1n (0*vdd) 7302n (0*vdd) 7302.1n (1*vdd) 7312n (1*vdd) 7312.1n (0*vdd) 7352n (0*vdd) 7352.1n (1*vdd) 7362n (1*vdd) 7362.1n (0*vdd) 7402n (0*vdd) 7402.1n (1*vdd) 7412n (1*vdd) 7412.1n (0*vdd) 7452n (0*vdd) 7452.1n (1*vdd) 7462n (1*vdd) 7462.1n (0*vdd) 7502n (0*vdd) 7502.1n (1*vdd) 7512n (1*vdd) 7512.1n (0*vdd) 7552n (0*vdd) 7552.1n (1*vdd) 7562n (1*vdd) 7562.1n (0*vdd) 7602n (0*vdd) 7602.1n (1*vdd) 7612n (1*vdd) 7612.1n (0*vdd) 7652n (0*vdd) 7652.1n (1*vdd) 7662n (1*vdd) 7662.1n (0*vdd) 7702n (0*vdd) 7702.1n (1*vdd) 7712n (1*vdd) 7712.1n (0*vdd) 7752n (0*vdd) 7752.1n (1*vdd) 7762n (1*vdd) 7762.1n (0*vdd) 7802n (0*vdd) 7802.1n (1*vdd) 7812n (1*vdd) 7812.1n (0*vdd) 7852n (0*vdd) 7852.1n (1*vdd) 7862n (1*vdd) 7862.1n (0*vdd) 7902n (0*vdd) 7902.1n (1*vdd) 7912n (1*vdd) 7912.1n (0*vdd) 7952n (0*vdd) 7952.1n (1*vdd) 7962n (1*vdd) 7962.1n (0*vdd) 8002n (0*vdd) 8002.1n (1*vdd) 8012n (1*vdd) 8012.1n (0*vdd) 8052n (0*vdd) 8052.1n (1*vdd) 8062n (1*vdd) 8062.1n (0*vdd) 8102n (0*vdd) 8102.1n (1*vdd) 8112n (1*vdd) 8112.1n (0*vdd) 8152n (0*vdd) 8152.1n (1*vdd) 8162n (1*vdd) 8162.1n (0*vdd) 8202n (0*vdd) 8202.1n (1*vdd) 8212n (1*vdd) 8212.1n (0*vdd) 8252n (0*vdd) 8252.1n (1*vdd) 8262n (1*vdd) 8262.1n (0*vdd) 8302n (0*vdd) 8302.1n (1*vdd) 8312n (1*vdd) 8312.1n (0*vdd) 8352n (0*vdd) 8352.1n (1*vdd) 8362n (1*vdd) 8362.1n (0*vdd) 8402n (0*vdd) 8402.1n (1*vdd) 8412n (1*vdd) 8412.1n (0*vdd) 8452n (0*vdd) 8452.1n (1*vdd) 8462n (1*vdd) 8462.1n (0*vdd) 8502n (0*vdd) 8502.1n (1*vdd) 8512n (1*vdd) 8512.1n (0*vdd) 8552n (0*vdd) 8552.1n (1*vdd) 8562n (1*vdd) 8562.1n (0*vdd) 8602n (0*vdd) 8602.1n (1*vdd) 8612n (1*vdd) 8612.1n (0*vdd) 8652n (0*vdd) 8652.1n (1*vdd) 8662n (1*vdd) 8662.1n (0*vdd) 8702n (0*vdd) 8702.1n (1*vdd) 8712n (1*vdd) 8712.1n (0*vdd) 8752n (0*vdd) 8752.1n (1*vdd) 8762n (1*vdd) 8762.1n (0*vdd) 8802n (0*vdd) 8802.1n (1*vdd) 8812n (1*vdd) 8812.1n (0*vdd) 8852n (0*vdd) 8852.1n (1*vdd) 8862n (1*vdd) 8862.1n (0*vdd) 8902n (0*vdd) 8902.1n (1*vdd) 8912n (1*vdd) 8912.1n (0*vdd) 8952n (0*vdd) 8952.1n (1*vdd) 8962n (1*vdd) 8962.1n (0*vdd) 9002n (0*vdd) 9002.1n (1*vdd) 9012n (1*vdd) 9012.1n (0*vdd) 9052n (0*vdd) 9052.1n (1*vdd) 9062n (1*vdd) 9062.1n (0*vdd) 9102n (0*vdd) 9102.1n (1*vdd) 9112n (1*vdd) 9112.1n (0*vdd) 9152n (0*vdd) 9152.1n (1*vdd) 9162n (1*vdd) 9162.1n (0*vdd) 9202n (0*vdd) 9202.1n (1*vdd) 9212n (1*vdd) 9212.1n (0*vdd) 9252n (0*vdd) 9252.1n (1*vdd) 9262n (1*vdd) 9262.1n (0*vdd) 9302n (0*vdd) 9302.1n (1*vdd) 9312n (1*vdd) 9312.1n (0*vdd) 9352n (0*vdd) 9352.1n (1*vdd) 9362n (1*vdd) 9362.1n (0*vdd) 9402n (0*vdd) 9402.1n (1*vdd) 9412n (1*vdd) 9412.1n (0*vdd) 9452n (0*vdd) 9452.1n (1*vdd) 9462n (1*vdd) 9462.1n (0*vdd) 9502n (0*vdd) 9502.1n (1*vdd) 9512n (1*vdd) 9512.1n (0*vdd) 9552n (0*vdd) 9552.1n (1*vdd) 9562n (1*vdd) 9562.1n (0*vdd) 9602n (0*vdd) 9602.1n (1*vdd) 9612n (1*vdd) 9612.1n (0*vdd) 9652n (0*vdd) 9652.1n (1*vdd) 9662n (1*vdd) 9662.1n (0*vdd) 9702n (0*vdd) 9702.1n (1*vdd) 9712n (1*vdd) 9712.1n (0*vdd) 9752n (0*vdd) 9752.1n (1*vdd) 9762n (1*vdd) 9762.1n (0*vdd) 9802n (0*vdd) 9802.1n (1*vdd) 9812n (1*vdd) 9812.1n (0*vdd) 9852n (0*vdd) 9852.1n (1*vdd) 9862n (1*vdd) 9862.1n (0*vdd) 9902n (0*vdd) 9902.1n (1*vdd) 9912n (1*vdd) 9912.1n (0*vdd) 9952n (0*vdd) 9952.1n (1*vdd) 9962n (1*vdd) 9962.1n (0*vdd) 10002n (0*vdd) 10002.1n (1*vdd) 10012n (1*vdd) 10012.1n (0*vdd) 10052n (0*vdd) 10052.1n (1*vdd) 10062n (1*vdd) 10062.1n (0*vdd) 10102n (0*vdd) 10102.1n (1*vdd) 10112n (1*vdd) 10112.1n (0*vdd) 10152n (0*vdd) 10152.1n (1*vdd) 10162n (1*vdd) 10162.1n (0*vdd) 10202n (0*vdd) 10202.1n (1*vdd) 10212n (1*vdd) 10212.1n (0*vdd) 10252n (0*vdd) 10252.1n (1*vdd) 10262n (1*vdd) 10262.1n (0*vdd) 10302n (0*vdd) 10302.1n (1*vdd) 10312n (1*vdd) 10312.1n (0*vdd) 10352n (0*vdd) 10352.1n (1*vdd) 10362n (1*vdd) 10362.1n (0*vdd) 10402n (0*vdd) 10402.1n (1*vdd) 10412n (1*vdd) 10412.1n (0*vdd) 10452n (0*vdd) 10452.1n (1*vdd) 10462n (1*vdd) 10462.1n (0*vdd) 10502n (0*vdd) 10502.1n (1*vdd) 10512n (1*vdd) 10512.1n (0*vdd) 10552n (0*vdd) 10552.1n (1*vdd) 10562n (1*vdd) 10562.1n (0*vdd) 10602n (0*vdd) 10602.1n (1*vdd) 10612n (1*vdd) 10612.1n (0*vdd) 10652n (0*vdd) 10652.1n (1*vdd) 10662n (1*vdd) 10662.1n (0*vdd) 10702n (0*vdd) 10702.1n (1*vdd) 10712n (1*vdd) 10712.1n (0*vdd) 10752n (0*vdd) 10752.1n (1*vdd) 10762n (1*vdd) 10762.1n (0*vdd) 10802n (0*vdd) 10802.1n (1*vdd) 10812n (1*vdd) 10812.1n (0*vdd) 10852n (0*vdd) 10852.1n (1*vdd) 10862n (1*vdd) 10862.1n (0*vdd) 10902n (0*vdd) 10902.1n (1*vdd) 10912n (1*vdd) 10912.1n (0*vdd) 10952n (0*vdd) 10952.1n (1*vdd) 10962n (1*vdd) 10962.1n (0*vdd) 11002n (0*vdd) 11002.1n (1*vdd) 11012n (1*vdd) 11012.1n (0*vdd) 11052n (0*vdd) 11052.1n (1*vdd) 11062n (1*vdd) 11062.1n (0*vdd) 11102n (0*vdd) 11102.1n (1*vdd) 11112n (1*vdd) 11112.1n (0*vdd) 11152n (0*vdd) 11152.1n (1*vdd) 11162n (1*vdd) 11162.1n (0*vdd) 11202n (0*vdd) 11202.1n (1*vdd) 11212n (1*vdd) 11212.1n (0*vdd) 11252n (0*vdd) 11252.1n (1*vdd) 11262n (1*vdd) 11262.1n (0*vdd) 11302n (0*vdd) 11302.1n (1*vdd) 11312n (1*vdd) 11312.1n (0*vdd) 11352n (0*vdd) 11352.1n (1*vdd) 11362n (1*vdd) 11362.1n (0*vdd) 11402n (0*vdd) 11402.1n (1*vdd) 11412n (1*vdd) 11412.1n (0*vdd) 11452n (0*vdd) 11452.1n (1*vdd) 11462n (1*vdd) 11462.1n (0*vdd) 11502n (0*vdd) 11502.1n (1*vdd) 11512n (1*vdd) 11512.1n (0*vdd) 11552n (0*vdd) 11552.1n (1*vdd) 11562n (1*vdd) 11562.1n (0*vdd) 11602n (0*vdd) 11602.1n (1*vdd) 11612n (1*vdd) 11612.1n (0*vdd) 11652n (0*vdd) 11652.1n (1*vdd) 11662n (1*vdd) 11662.1n (0*vdd) 11702n (0*vdd) 11702.1n (1*vdd) 11712n (1*vdd) 11712.1n (0*vdd) 11752n (0*vdd) 11752.1n (1*vdd) 11762n (1*vdd) 11762.1n (0*vdd) 11802n (0*vdd) 11802.1n (1*vdd) 11812n (1*vdd) 11812.1n (0*vdd) 11852n (0*vdd) 11852.1n (1*vdd) 11862n (1*vdd) 11862.1n (0*vdd) 11902n (0*vdd) 11902.1n (1*vdd) 11912n (1*vdd) 11912.1n (0*vdd) 11952n (0*vdd) 11952.1n (1*vdd) 11962n (1*vdd) 11962.1n (0*vdd) 12002n (0*vdd) 12002.1n (1*vdd) 12042n (1*vdd) 12042.1n (0*vdd) 12052n (0*vdd) 12052.1n (1*vdd) 12092n (1*vdd) 12092.1n (0*vdd) 12102n (0*vdd) 12102.1n (1*vdd) 12142n (1*vdd) 12142.1n (0*vdd) 12152n (0*vdd) 12152.1n (1*vdd) 12192n (1*vdd) 12192.1n (0*vdd) 12200n (0*vdd)]
Xchip (R1 R0 C2 C1 C0 CLK1 CLK2 WR RD DIN DOUT VDD 0) sram_4x6
COUT (DOUT 0) capacitor c=10f
CBL0 (Xchip.BL0 0) capacitor c=20f
CBLB0 (Xchip.BLB0 0) capacitor c=20f
CBL1 (Xchip.BL1 0) capacitor c=20f
CBLB1 (Xchip.BLB1 0) capacitor c=20f
CBL2 (Xchip.BL2 0) capacitor c=20f
CBLB2 (Xchip.BLB2 0) capacitor c=20f
CBL3 (Xchip.BL3 0) capacitor c=20f
CBLB3 (Xchip.BLB3 0) capacitor c=20f
CBL4 (Xchip.BL4 0) capacitor c=20f
CBLB4 (Xchip.BLB4 0) capacitor c=20f
CBL5 (Xchip.BL5 0) capacitor c=20f
CBLB5 (Xchip.BLB5 0) capacitor c=20f
CG0 (Xchip.GBL 0) capacitor c=5f
CG1 (Xchip.GBLB 0) capacitor c=5f
ic Xchip.XMEM.Q0_0=0 Xchip.XMEM.QB0_0=vdd Xchip.XMEM.Q0_1=0 Xchip.XMEM.QB0_1=vdd Xchip.XMEM.Q0_2=0 Xchip.XMEM.QB0_2=vdd Xchip.XMEM.Q0_3=0 Xchip.XMEM.QB0_3=vdd Xchip.XMEM.Q0_4=0 Xchip.XMEM.QB0_4=vdd Xchip.XMEM.Q0_5=0 Xchip.XMEM.QB0_5=vdd Xchip.XMEM.Q1_0=0 Xchip.XMEM.QB1_0=vdd Xchip.XMEM.Q1_1=0 Xchip.XMEM.QB1_1=vdd Xchip.XMEM.Q1_2=0 Xchip.XMEM.QB1_2=vdd Xchip.XMEM.Q1_3=0 Xchip.XMEM.QB1_3=vdd Xchip.XMEM.Q1_4=0 Xchip.XMEM.QB1_4=vdd Xchip.XMEM.Q1_5=0 Xchip.XMEM.QB1_5=vdd Xchip.XMEM.Q2_0=0 Xchip.XMEM.QB2_0=vdd Xchip.XMEM.Q2_1=0 Xchip.XMEM.QB2_1=vdd Xchip.XMEM.Q2_2=0 Xchip.XMEM.QB2_2=vdd Xchip.XMEM.Q2_3=0 Xchip.XMEM.QB2_3=vdd Xchip.XMEM.Q2_4=0 Xchip.XMEM.QB2_4=vdd Xchip.XMEM.Q2_5=0 Xchip.XMEM.QB2_5=vdd Xchip.XMEM.Q3_0=0 Xchip.XMEM.QB3_0=vdd Xchip.XMEM.Q3_1=0 Xchip.XMEM.QB3_1=vdd Xchip.XMEM.Q3_2=0 Xchip.XMEM.QB3_2=vdd Xchip.XMEM.Q3_3=0 Xchip.XMEM.QB3_3=vdd Xchip.XMEM.Q3_4=0 Xchip.XMEM.QB3_4=vdd Xchip.XMEM.Q3_5=0 Xchip.XMEM.QB3_5=vdd
tran tran stop=12200n maxstep=500p errpreset=moderate strobeperiod=500p strobeoutput=strobeonly
save R1 R0 C2 C1 C0 WR RD DIN CLK1 CLK2 DOUT Xchip.WEN Xchip.REN Xchip.ROWEN Xchip.PCB Xchip.GBL Xchip.GBLB Xchip.SENSE Xchip.WL0 Xchip.WL1 Xchip.WL2 Xchip.WL3 Xchip.CS0 Xchip.CS1 Xchip.CS2 Xchip.CS3 Xchip.CS4 Xchip.CS5 Xchip.BL0 Xchip.BL1 Xchip.BL2 Xchip.BL3 Xchip.BL4 Xchip.BL5 Xchip.BLB0 Xchip.BLB1 Xchip.BLB2 Xchip.BLB3 Xchip.BLB4 Xchip.BLB5 Xchip.XMEM.Q0_0 Xchip.XMEM.Q0_1 Xchip.XMEM.Q0_2 Xchip.XMEM.Q0_3 Xchip.XMEM.Q0_4 Xchip.XMEM.Q0_5 Xchip.XMEM.Q1_0 Xchip.XMEM.Q1_1 Xchip.XMEM.Q1_2 Xchip.XMEM.Q1_3 Xchip.XMEM.Q1_4 Xchip.XMEM.Q1_5 Xchip.XMEM.Q2_0 Xchip.XMEM.Q2_1 Xchip.XMEM.Q2_2 Xchip.XMEM.Q2_3 Xchip.XMEM.Q2_4 Xchip.XMEM.Q2_5 Xchip.XMEM.Q3_0 Xchip.XMEM.Q3_1 Xchip.XMEM.Q3_2 Xchip.XMEM.Q3_3 Xchip.XMEM.Q3_4 Xchip.XMEM.Q3_5 Xchip.XMEM.QB0_0 Xchip.XMEM.QB0_1 Xchip.XMEM.QB0_2 Xchip.XMEM.QB0_3 Xchip.XMEM.QB0_4 Xchip.XMEM.QB0_5 Xchip.XMEM.QB1_0 Xchip.XMEM.QB1_1 Xchip.XMEM.QB1_2 Xchip.XMEM.QB1_3 Xchip.XMEM.QB1_4 Xchip.XMEM.QB1_5 Xchip.XMEM.QB2_0 Xchip.XMEM.QB2_1 Xchip.XMEM.QB2_2 Xchip.XMEM.QB2_3 Xchip.XMEM.QB2_4 Xchip.XMEM.QB2_5 Xchip.XMEM.QB3_0 Xchip.XMEM.QB3_1 Xchip.XMEM.QB3_2 Xchip.XMEM.QB3_3 Xchip.XMEM.QB3_4 Xchip.XMEM.QB3_5
