simulator lang=spectre
include "/ecel/UFAD/ymahmud/vlsi_sram_project/Project Instruction Files/gpdk045_mos.scs" section=tt
include "/ecel/UFAD/ymahmud/vlsi_sram_project/project_file/full_array/netlists/design.scs"
parameters vdd=1.1
simOptions options temp=27 reltol=1e-3 vabstol=1e-7 iabstol=1e-14 gmin=1e-14
VDD (VDD 0) vsource dc=vdd
VR1 (R1 0) vsource type=pwl wave=[0n (0*vdd) 200n (0*vdd)]
VR0 (R0 0) vsource type=pwl wave=[0n (0*vdd) 200n (0*vdd)]
VC2 (C2 0) vsource type=pwl wave=[0n (0*vdd) 200n (0*vdd)]
VC1 (C1 0) vsource type=pwl wave=[0n (0*vdd) 200n (0*vdd)]
VC0 (C0 0) vsource type=pwl wave=[0n (0*vdd) 200n (0*vdd)]
VWR (WR 0) vsource type=pwl wave=[0n (0*vdd) 0.2n (0*vdd) 0.3n (1*vdd) 50.2n (1*vdd) 50.3n (0*vdd) 100.2n (0*vdd) 100.3n (1*vdd) 150.2n (1*vdd) 150.3n (0*vdd) 200n (0*vdd)]
VRD (RD 0) vsource type=pwl wave=[0n (0*vdd) 50.2n (0*vdd) 50.3n (1*vdd) 100.2n (1*vdd) 100.3n (0*vdd) 150.2n (0*vdd) 150.3n (1*vdd) 200n (1*vdd)]
VDIN (DIN 0) vsource type=pwl wave=[0n (0*vdd) 0.2n (0*vdd) 0.3n (1*vdd) 100.2n (1*vdd) 100.3n (0*vdd) 200n (0*vdd)]
VCLK1 (CLK1 0) vsource type=pwl wave=[0n (0*vdd) 20n (0*vdd) 20.1n (1*vdd) 40n (1*vdd) 40.1n (0*vdd) 70n (0*vdd) 70.1n (1*vdd) 90n (1*vdd) 90.1n (0*vdd) 120n (0*vdd) 120.1n (1*vdd) 140n (1*vdd) 140.1n (0*vdd) 170n (0*vdd) 170.1n (1*vdd) 190n (1*vdd) 190.1n (0*vdd) 200n (0*vdd)]
VCLK2 (CLK2 0) vsource type=pwl wave=[0n (0*vdd) 2n (0*vdd) 2.1n (1*vdd) 12n (1*vdd) 12.1n (0*vdd) 52n (0*vdd) 52.1n (1*vdd) 62n (1*vdd) 62.1n (0*vdd) 102n (0*vdd) 102.1n (1*vdd) 112n (1*vdd) 112.1n (0*vdd) 152n (0*vdd) 152.1n (1*vdd) 162n (1*vdd) 162.1n (0*vdd) 200n (0*vdd)]
Xchip (R1 R0 C2 C1 C0 CLK1 CLK2 WR RD DIN DOUT VDD 0) sram_4x6
COUT (DOUT 0) capacitor c=10f
CBL0 (Xchip.BL0 0) capacitor c=20f
CBLB0 (Xchip.BLB0 0) capacitor c=20f
CBL1 (Xchip.BL1 0) capacitor c=20f
CBLB1 (Xchip.BLB1 0) capacitor c=20f
CBL2 (Xchip.BL2 0) capacitor c=20f
CBLB2 (Xchip.BLB2 0) capacitor c=20f
CBL3 (Xchip.BL3 0) capacitor c=20f
CBLB3 (Xchip.BLB3 0) capacitor c=20f
CBL4 (Xchip.BL4 0) capacitor c=20f
CBLB4 (Xchip.BLB4 0) capacitor c=20f
CBL5 (Xchip.BL5 0) capacitor c=20f
CBLB5 (Xchip.BLB5 0) capacitor c=20f
CG0 (Xchip.GBL 0) capacitor c=5f
CG1 (Xchip.GBLB 0) capacitor c=5f
ic DOUT=0 Xchip.XLATCH.n0=0 Xchip.XLATCH.nb=vdd Xchip.XMEM.Q0_0=0 Xchip.XMEM.QB0_0=vdd Xchip.XMEM.Q0_1=0 Xchip.XMEM.QB0_1=vdd Xchip.XMEM.Q0_2=0 Xchip.XMEM.QB0_2=vdd Xchip.XMEM.Q0_3=0 Xchip.XMEM.QB0_3=vdd Xchip.XMEM.Q0_4=0 Xchip.XMEM.QB0_4=vdd Xchip.XMEM.Q0_5=0 Xchip.XMEM.QB0_5=vdd Xchip.XMEM.Q1_0=0 Xchip.XMEM.QB1_0=vdd Xchip.XMEM.Q1_1=0 Xchip.XMEM.QB1_1=vdd Xchip.XMEM.Q1_2=0 Xchip.XMEM.QB1_2=vdd Xchip.XMEM.Q1_3=0 Xchip.XMEM.QB1_3=vdd Xchip.XMEM.Q1_4=0 Xchip.XMEM.QB1_4=vdd Xchip.XMEM.Q1_5=0 Xchip.XMEM.QB1_5=vdd Xchip.XMEM.Q2_0=0 Xchip.XMEM.QB2_0=vdd Xchip.XMEM.Q2_1=0 Xchip.XMEM.QB2_1=vdd Xchip.XMEM.Q2_2=0 Xchip.XMEM.QB2_2=vdd Xchip.XMEM.Q2_3=0 Xchip.XMEM.QB2_3=vdd Xchip.XMEM.Q2_4=0 Xchip.XMEM.QB2_4=vdd Xchip.XMEM.Q2_5=0 Xchip.XMEM.QB2_5=vdd Xchip.XMEM.Q3_0=0 Xchip.XMEM.QB3_0=vdd Xchip.XMEM.Q3_1=0 Xchip.XMEM.QB3_1=vdd Xchip.XMEM.Q3_2=0 Xchip.XMEM.QB3_2=vdd Xchip.XMEM.Q3_3=0 Xchip.XMEM.QB3_3=vdd Xchip.XMEM.Q3_4=0 Xchip.XMEM.QB3_4=vdd Xchip.XMEM.Q3_5=0 Xchip.XMEM.QB3_5=vdd
tran tran stop=200n maxstep=5p errpreset=conservative
save CLK1 CLK2 WR RD DIN DOUT Xchip.GBL Xchip.GBLB Xchip.BL0 Xchip.BLB0 Xchip.WL0 Xchip.WEN Xchip.REN Xchip.SENSE Xchip.XMEM.Q0_0 Xchip.XMEM.QB0_0
