simulator lang=spectre
include "/ecel/UFAD/ymahmud/vlsi_sram_project/Project Instruction Files/gpdk045_mos.scs" section=tt
include "/ecel/UFAD/ymahmud/vlsi_sram_project/project_file/full_array/netlists/design.scs"
parameters vdd=1.1
VDD (VDD 0) vsource dc=vdd
simOptions options reltol=1e-3 temp=27
VCLK1 (CLK1 0) vsource type=pwl wave=[0n (0*vdd) 320n (0*vdd) 320.1n (1*vdd) 640n (1*vdd)]
VCLK2 (CLK2 0) vsource type=pwl wave=[0n (0*vdd) 160n (0*vdd) 160.1n (1*vdd) 320n (1*vdd) 320.1n (0*vdd) 480n (0*vdd) 480.1n (1*vdd) 640n (1*vdd)]
VWR (WR 0) vsource type=pwl wave=[0n (0*vdd) 80n (0*vdd) 80.1n (1*vdd) 160n (1*vdd) 160.1n (0*vdd) 240n (0*vdd) 240.1n (1*vdd) 320n (1*vdd) 320.1n (0*vdd) 400n (0*vdd) 400.1n (1*vdd) 480n (1*vdd) 480.1n (0*vdd) 560n (0*vdd) 560.1n (1*vdd) 640n (1*vdd)]
VRD (RD 0) vsource type=pwl wave=[0n (0*vdd) 40n (0*vdd) 40.1n (1*vdd) 80n (1*vdd) 80.1n (0*vdd) 120n (0*vdd) 120.1n (1*vdd) 160n (1*vdd) 160.1n (0*vdd) 200n (0*vdd) 200.1n (1*vdd) 240n (1*vdd) 240.1n (0*vdd) 280n (0*vdd) 280.1n (1*vdd) 320n (1*vdd) 320.1n (0*vdd) 360n (0*vdd) 360.1n (1*vdd) 400n (1*vdd) 400.1n (0*vdd) 440n (0*vdd) 440.1n (1*vdd) 480n (1*vdd) 480.1n (0*vdd) 520n (0*vdd) 520.1n (1*vdd) 560n (1*vdd) 560.1n (0*vdd) 600n (0*vdd) 600.1n (1*vdd) 640n (1*vdd)]
VC2 (C2 0) vsource type=pwl wave=[0n (0*vdd) 20n (0*vdd) 20.1n (1*vdd) 40n (1*vdd) 40.1n (0*vdd) 60n (0*vdd) 60.1n (1*vdd) 80n (1*vdd) 80.1n (0*vdd) 100n (0*vdd) 100.1n (1*vdd) 120n (1*vdd) 120.1n (0*vdd) 140n (0*vdd) 140.1n (1*vdd) 160n (1*vdd) 160.1n (0*vdd) 180n (0*vdd) 180.1n (1*vdd) 200n (1*vdd) 200.1n (0*vdd) 220n (0*vdd) 220.1n (1*vdd) 240n (1*vdd) 240.1n (0*vdd) 260n (0*vdd) 260.1n (1*vdd) 280n (1*vdd) 280.1n (0*vdd) 300n (0*vdd) 300.1n (1*vdd) 320n (1*vdd) 320.1n (0*vdd) 340n (0*vdd) 340.1n (1*vdd) 360n (1*vdd) 360.1n (0*vdd) 380n (0*vdd) 380.1n (1*vdd) 400n (1*vdd) 400.1n (0*vdd) 420n (0*vdd) 420.1n (1*vdd) 440n (1*vdd) 440.1n (0*vdd) 460n (0*vdd) 460.1n (1*vdd) 480n (1*vdd) 480.1n (0*vdd) 500n (0*vdd) 500.1n (1*vdd) 520n (1*vdd) 520.1n (0*vdd) 540n (0*vdd) 540.1n (1*vdd) 560n (1*vdd) 560.1n (0*vdd) 580n (0*vdd) 580.1n (1*vdd) 600n (1*vdd) 600.1n (0*vdd) 620n (0*vdd) 620.1n (1*vdd) 640n (1*vdd)]
VC1 (C1 0) vsource type=pwl wave=[0n (0*vdd) 10n (0*vdd) 10.1n (1*vdd) 20n (1*vdd) 20.1n (0*vdd) 30n (0*vdd) 30.1n (1*vdd) 40n (1*vdd) 40.1n (0*vdd) 50n (0*vdd) 50.1n (1*vdd) 60n (1*vdd) 60.1n (0*vdd) 70n (0*vdd) 70.1n (1*vdd) 80n (1*vdd) 80.1n (0*vdd) 90n (0*vdd) 90.1n (1*vdd) 100n (1*vdd) 100.1n (0*vdd) 110n (0*vdd) 110.1n (1*vdd) 120n (1*vdd) 120.1n (0*vdd) 130n (0*vdd) 130.1n (1*vdd) 140n (1*vdd) 140.1n (0*vdd) 150n (0*vdd) 150.1n (1*vdd) 160n (1*vdd) 160.1n (0*vdd) 170n (0*vdd) 170.1n (1*vdd) 180n (1*vdd) 180.1n (0*vdd) 190n (0*vdd) 190.1n (1*vdd) 200n (1*vdd) 200.1n (0*vdd) 210n (0*vdd) 210.1n (1*vdd) 220n (1*vdd) 220.1n (0*vdd) 230n (0*vdd) 230.1n (1*vdd) 240n (1*vdd) 240.1n (0*vdd) 250n (0*vdd) 250.1n (1*vdd) 260n (1*vdd) 260.1n (0*vdd) 270n (0*vdd) 270.1n (1*vdd) 280n (1*vdd) 280.1n (0*vdd) 290n (0*vdd) 290.1n (1*vdd) 300n (1*vdd) 300.1n (0*vdd) 310n (0*vdd) 310.1n (1*vdd) 320n (1*vdd) 320.1n (0*vdd) 330n (0*vdd) 330.1n (1*vdd) 340n (1*vdd) 340.1n (0*vdd) 350n (0*vdd) 350.1n (1*vdd) 360n (1*vdd) 360.1n (0*vdd) 370n (0*vdd) 370.1n (1*vdd) 380n (1*vdd) 380.1n (0*vdd) 390n (0*vdd) 390.1n (1*vdd) 400n (1*vdd) 400.1n (0*vdd) 410n (0*vdd) 410.1n (1*vdd) 420n (1*vdd) 420.1n (0*vdd) 430n (0*vdd) 430.1n (1*vdd) 440n (1*vdd) 440.1n (0*vdd) 450n (0*vdd) 450.1n (1*vdd) 460n (1*vdd) 460.1n (0*vdd) 470n (0*vdd) 470.1n (1*vdd) 480n (1*vdd) 480.1n (0*vdd) 490n (0*vdd) 490.1n (1*vdd) 500n (1*vdd) 500.1n (0*vdd) 510n (0*vdd) 510.1n (1*vdd) 520n (1*vdd) 520.1n (0*vdd) 530n (0*vdd) 530.1n (1*vdd) 540n (1*vdd) 540.1n (0*vdd) 550n (0*vdd) 550.1n (1*vdd) 560n (1*vdd) 560.1n (0*vdd) 570n (0*vdd) 570.1n (1*vdd) 580n (1*vdd) 580.1n (0*vdd) 590n (0*vdd) 590.1n (1*vdd) 600n (1*vdd) 600.1n (0*vdd) 610n (0*vdd) 610.1n (1*vdd) 620n (1*vdd) 620.1n (0*vdd) 630n (0*vdd) 630.1n (1*vdd) 640n (1*vdd)]
Xunit (CLK1 CLK2 WR RD C2 C1 WEN WENB REN RENB ROWEN PCB VDD 0) rw_control
CLWEN (WEN 0) capacitor c=5f
CLWENB (WENB 0) capacitor c=5f
CLREN (REN 0) capacitor c=5f
CLRENB (RENB 0) capacitor c=5f
CLROWEN (ROWEN 0) capacitor c=5f
CLPCB (PCB 0) capacitor c=5f
tran tran stop=640n maxstep=100p errpreset=moderate strobeperiod=100p
save CLK1 CLK2 WR RD C2 C1 WEN WENB REN RENB ROWEN PCB
