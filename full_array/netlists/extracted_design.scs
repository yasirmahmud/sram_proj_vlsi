simulator lang=spectre
subckt physical_sram_4x6 (GND VDD R1 R0 C2 C1 C0 CLK1 CLK2 WR RD DIN DOUT)
M90 (GND 3 48 GND) g45n1svt l=4.5e-08 w=3.6e-07 ad=5.04e-14 as=5.04e-14 pd=1e-06 ps=1e-06 sa=1.4e-07 sb=1.4e-07 sca=3.70436 scb=0.000161812 scc=1.4064e-08
M91 (9 3 32 GND) g45n1svt l=4.5e-08 w=1.08e-06 ad=1.512e-13 as=1.512e-13 pd=2.44e-06 ps=2.44e-06 sa=1.4e-07 sb=1.4e-07 sca=3.04786 scb=0.000104839 scc=6.53879e-09
M92 (GND RD 49 GND) g45n1svt l=4.5e-08 w=3.6e-07 ad=5.04e-14 as=5.04e-14 pd=1e-06 ps=1e-06 sa=1.4e-07 sb=1.4e-07 sca=3.70436 scb=0.000161812 scc=1.4064e-08
M93 (GND C0 51 GND) g45n1svt l=4.5e-08 w=3.6e-07 ad=5.04e-14 as=5.04e-14 pd=1e-06 ps=1e-06 sa=1.4e-07 sb=1.4e-07 sca=3.70436 scb=0.000161812 scc=1.4064e-08
M94 (GND WR 50 GND) g45n1svt l=4.5e-08 w=3.6e-07 ad=5.04e-14 as=5.04e-14 pd=1e-06 ps=1e-06 sa=1.4e-07 sb=1.4e-07 sca=3.70436 scb=0.000161812 scc=1.4064e-08
M95 (26 3 33 GND) g45n1svt l=4.5e-08 w=1.08e-06 ad=1.512e-13 as=1.512e-13 pd=2.44e-06 ps=2.44e-06 sa=1.4e-07 sb=1.4e-07 sca=3.04786 scb=0.000104839 scc=6.53879e-09
M96 (GND C1 52 GND) g45n1svt l=4.5e-08 w=3.6e-07 ad=5.04e-14 as=5.04e-14 pd=1e-06 ps=1e-06 sa=1.4e-07 sb=1.4e-07 sca=3.70436 scb=0.000161812 scc=1.4064e-08
M97 (GND CLK2 39 GND) g45n1svt l=4.5e-08 w=3.6e-07 ad=5.04e-14 as=5.04e-14 pd=1e-06 ps=1e-06 sa=1.4e-07 sb=1.4e-07 sca=3.70436 scb=0.000161812 scc=1.4064e-08
M98 (GND 4 53 GND) g45n1svt l=4.5e-08 w=3.6e-07 ad=5.04e-14 as=5.04e-14 pd=1e-06 ps=1e-06 sa=1.4e-07 sb=1.4e-07 sca=3.70436 scb=0.000161812 scc=1.4064e-08
M99 (GND C2 55 GND) g45n1svt l=4.5e-08 w=3.6e-07 ad=5.04e-14 as=5.04e-14 pd=1e-06 ps=1e-06 sa=1.4e-07 sb=1.4e-07 sca=3.70436 scb=0.000161812 scc=1.4064e-08
M100 (10 4 32 GND) g45n1svt l=4.5e-08 w=1.08e-06 ad=1.512e-13 as=1.512e-13 pd=2.44e-06 ps=2.44e-06 sa=1.4e-07 sb=1.4e-07 sca=3.04786 scb=0.000104839 scc=6.53879e-09
M101 (117 C2 118 GND) g45n1svt l=4.5e-08 w=1.08e-06 ad=1.512e-13 as=1.512e-13 pd=2.44e-06 ps=2.44e-06 sa=1.4e-07 sb=1.4e-07 sca=2.87541 scb=8.38884e-05 scc=2.97061e-09
M102 (119 C1 117 GND) g45n1svt l=4.5e-08 w=1.08e-06 ad=1.512e-13 as=1.512e-13 pd=2.44e-06 ps=2.44e-06 sa=1.4e-07 sb=1.4e-07 sca=2.87541 scb=8.38884e-05 scc=2.97061e-09
M103 (GND VDD 119 GND) g45n1svt l=4.5e-08 w=1.08e-06 ad=1.512e-13 as=1.512e-13 pd=2.44e-06 ps=2.44e-06 sa=1.4e-07 sb=1.4e-07 sca=2.87541 scb=8.38884e-05 scc=2.97061e-09
M104 (GND 118 54 GND) g45n1svt l=4.5e-08 w=3.6e-07 ad=5.04e-14 as=5.04e-14 pd=1e-06 ps=1e-06 sa=1.4e-07 sb=1.4e-07 sca=3.38446 scb=0.000101379 scc=3.37079e-09
M105 (120 55 121 GND) g45n1svt l=4.5e-08 w=1.08e-06 ad=1.512e-13 as=1.512e-13 pd=2.44e-06 ps=2.44e-06 sa=1.4e-07 sb=1.4e-07 sca=2.87541 scb=8.38884e-05 scc=2.97061e-09
M106 (27 4 33 GND) g45n1svt l=4.5e-08 w=1.08e-06 ad=1.512e-13 as=1.512e-13 pd=2.44e-06 ps=2.44e-06 sa=1.4e-07 sb=1.4e-07 sca=3.04786 scb=0.000104839 scc=6.53879e-09
M107 (122 52 120 GND) g45n1svt l=4.5e-08 w=1.08e-06 ad=1.512e-13 as=1.512e-13 pd=2.44e-06 ps=2.44e-06 sa=1.4e-07 sb=1.4e-07 sca=2.87541 scb=8.38884e-05 scc=2.97061e-09
M108 (GND 51 122 GND) g45n1svt l=4.5e-08 w=1.08e-06 ad=1.512e-13 as=1.512e-13 pd=2.44e-06 ps=2.44e-06 sa=1.4e-07 sb=1.4e-07 sca=2.87541 scb=8.38884e-05 scc=2.97061e-09
M109 (GND 121 3 GND) g45n1svt l=4.5e-08 w=3.6e-07 ad=5.04e-14 as=5.04e-14 pd=1e-06 ps=1e-06 sa=1.4e-07 sb=1.4e-07 sca=3.38446 scb=0.000101379 scc=3.37079e-09
M110 (GND 54 57 GND) g45n1svt l=4.5e-08 w=3.6e-07 ad=5.04e-14 as=5.04e-14 pd=1e-06 ps=1e-06 sa=1.4e-07 sb=1.4e-07 sca=3.70436 scb=0.000161812 scc=1.4064e-08
M111 (GND 5 56 GND) g45n1svt l=4.5e-08 w=3.6e-07 ad=5.04e-14 as=5.04e-14 pd=1e-06 ps=1e-06 sa=1.4e-07 sb=1.4e-07 sca=3.70436 scb=0.000161812 scc=1.4064e-08
M112 (126 55 127 GND) g45n1svt l=4.5e-08 w=1.08e-06 ad=1.512e-13 as=1.512e-13 pd=2.44e-06 ps=2.44e-06 sa=1.4e-07 sb=1.4e-07 sca=2.87541 scb=8.38884e-05 scc=2.97061e-09
M113 (123 WR 124 GND) g45n1svt l=4.5e-08 w=1.08e-06 ad=1.512e-13 as=1.512e-13 pd=2.44e-06 ps=2.44e-06 sa=1.4e-07 sb=1.4e-07 sca=2.87541 scb=8.38884e-05 scc=2.97061e-09
M114 (128 52 126 GND) g45n1svt l=4.5e-08 w=1.08e-06 ad=1.512e-13 as=1.512e-13 pd=2.44e-06 ps=2.44e-06 sa=1.4e-07 sb=1.4e-07 sca=2.87541 scb=8.38884e-05 scc=2.97061e-09
M115 (11 5 32 GND) g45n1svt l=4.5e-08 w=1.08e-06 ad=1.512e-13 as=1.512e-13 pd=2.44e-06 ps=2.44e-06 sa=1.4e-07 sb=1.4e-07 sca=3.04786 scb=0.000104839 scc=6.53879e-09
M116 (125 49 123 GND) g45n1svt l=4.5e-08 w=1.08e-06 ad=1.512e-13 as=1.512e-13 pd=2.44e-06 ps=2.44e-06 sa=1.4e-07 sb=1.4e-07 sca=2.87541 scb=8.38884e-05 scc=2.97061e-09
M117 (GND C0 128 GND) g45n1svt l=4.5e-08 w=1.08e-06 ad=1.512e-13 as=1.512e-13 pd=2.44e-06 ps=2.44e-06 sa=1.4e-07 sb=1.4e-07 sca=2.87541 scb=8.38884e-05 scc=2.97061e-09
M118 (GND CLK1 125 GND) g45n1svt l=4.5e-08 w=1.08e-06 ad=1.512e-13 as=1.512e-13 pd=2.44e-06 ps=2.44e-06 sa=1.4e-07 sb=1.4e-07 sca=2.87541 scb=8.38884e-05 scc=2.97061e-09
M119 (GND 127 4 GND) g45n1svt l=4.5e-08 w=3.6e-07 ad=5.04e-14 as=5.04e-14 pd=1e-06 ps=1e-06 sa=1.4e-07 sb=1.4e-07 sca=3.38446 scb=0.000101379 scc=3.37079e-09
M120 (GND 124 58 GND) g45n1svt l=4.5e-08 w=3.6e-07 ad=5.04e-14 as=5.04e-14 pd=1e-06 ps=1e-06 sa=1.4e-07 sb=1.4e-07 sca=3.38446 scb=0.000101379 scc=3.37079e-09
M121 (28 5 33 GND) g45n1svt l=4.5e-08 w=1.08e-06 ad=1.512e-13 as=1.512e-13 pd=2.44e-06 ps=2.44e-06 sa=1.4e-07 sb=1.4e-07 sca=3.04786 scb=0.000104839 scc=6.53879e-09
M122 (132 55 133 GND) g45n1svt l=4.5e-08 w=1.08e-06 ad=1.512e-13 as=1.512e-13 pd=2.44e-06 ps=2.44e-06 sa=1.4e-07 sb=1.4e-07 sca=2.87541 scb=8.38884e-05 scc=2.97061e-09
M123 (129 RD 130 GND) g45n1svt l=4.5e-08 w=1.08e-06 ad=1.512e-13 as=1.512e-13 pd=2.44e-06 ps=2.44e-06 sa=1.4e-07 sb=1.4e-07 sca=2.87541 scb=8.38884e-05 scc=2.97061e-09
M124 (134 C1 132 GND) g45n1svt l=4.5e-08 w=1.08e-06 ad=1.512e-13 as=1.512e-13 pd=2.44e-06 ps=2.44e-06 sa=1.4e-07 sb=1.4e-07 sca=2.87541 scb=8.38884e-05 scc=2.97061e-09
M125 (131 50 129 GND) g45n1svt l=4.5e-08 w=1.08e-06 ad=1.512e-13 as=1.512e-13 pd=2.44e-06 ps=2.44e-06 sa=1.4e-07 sb=1.4e-07 sca=2.87541 scb=8.38884e-05 scc=2.97061e-09
M126 (GND 6 60 GND) g45n1svt l=4.5e-08 w=3.6e-07 ad=5.04e-14 as=5.04e-14 pd=1e-06 ps=1e-06 sa=1.4e-07 sb=1.4e-07 sca=3.70436 scb=0.000161812 scc=1.4064e-08
M127 (GND 51 134 GND) g45n1svt l=4.5e-08 w=1.08e-06 ad=1.512e-13 as=1.512e-13 pd=2.44e-06 ps=2.44e-06 sa=1.4e-07 sb=1.4e-07 sca=2.87541 scb=8.38884e-05 scc=2.97061e-09
M128 (GND CLK1 131 GND) g45n1svt l=4.5e-08 w=1.08e-06 ad=1.512e-13 as=1.512e-13 pd=2.44e-06 ps=2.44e-06 sa=1.4e-07 sb=1.4e-07 sca=2.87541 scb=8.38884e-05 scc=2.97061e-09
M129 (GND 133 5 GND) g45n1svt l=4.5e-08 w=3.6e-07 ad=5.04e-14 as=5.04e-14 pd=1e-06 ps=1e-06 sa=1.4e-07 sb=1.4e-07 sca=3.38446 scb=0.000101379 scc=3.37079e-09
M130 (GND 130 59 GND) g45n1svt l=4.5e-08 w=3.6e-07 ad=5.04e-14 as=5.04e-14 pd=1e-06 ps=1e-06 sa=1.4e-07 sb=1.4e-07 sca=3.38446 scb=0.000101379 scc=3.37079e-09
M131 (12 6 32 GND) g45n1svt l=4.5e-08 w=1.08e-06 ad=1.512e-13 as=1.512e-13 pd=2.44e-06 ps=2.44e-06 sa=1.4e-07 sb=1.4e-07 sca=3.04786 scb=0.000104839 scc=6.53879e-09
M132 (138 55 139 GND) g45n1svt l=4.5e-08 w=1.08e-06 ad=1.512e-13 as=1.512e-13 pd=2.44e-06 ps=2.44e-06 sa=1.4e-07 sb=1.4e-07 sca=2.87541 scb=8.38884e-05 scc=2.97061e-09
M133 (135 58 136 GND) g45n1svt l=4.5e-08 w=1.08e-06 ad=1.512e-13 as=1.512e-13 pd=2.44e-06 ps=2.44e-06 sa=1.4e-07 sb=1.4e-07 sca=2.87541 scb=8.38884e-05 scc=2.97061e-09
M134 (140 C1 138 GND) g45n1svt l=4.5e-08 w=1.08e-06 ad=1.512e-13 as=1.512e-13 pd=2.44e-06 ps=2.44e-06 sa=1.4e-07 sb=1.4e-07 sca=2.87541 scb=8.38884e-05 scc=2.97061e-09
M135 (137 57 135 GND) g45n1svt l=4.5e-08 w=1.08e-06 ad=1.512e-13 as=1.512e-13 pd=2.44e-06 ps=2.44e-06 sa=1.4e-07 sb=1.4e-07 sca=2.87541 scb=8.38884e-05 scc=2.97061e-09
M136 (GND C0 140 GND) g45n1svt l=4.5e-08 w=1.08e-06 ad=1.512e-13 as=1.512e-13 pd=2.44e-06 ps=2.44e-06 sa=1.4e-07 sb=1.4e-07 sca=2.87541 scb=8.38884e-05 scc=2.97061e-09
M137 (GND 39 137 GND) g45n1svt l=4.5e-08 w=1.08e-06 ad=1.512e-13 as=1.512e-13 pd=2.44e-06 ps=2.44e-06 sa=1.4e-07 sb=1.4e-07 sca=2.87541 scb=8.38884e-05 scc=2.97061e-09
M138 (GND 139 6 GND) g45n1svt l=4.5e-08 w=3.6e-07 ad=5.04e-14 as=5.04e-14 pd=1e-06 ps=1e-06 sa=1.4e-07 sb=1.4e-07 sca=3.38446 scb=0.000101379 scc=3.37079e-09
M139 (GND 136 34 GND) g45n1svt l=4.5e-08 w=3.6e-07 ad=5.04e-14 as=5.04e-14 pd=1e-06 ps=1e-06 sa=1.4e-07 sb=1.4e-07 sca=3.38446 scb=0.000101379 scc=3.37079e-09
M140 (29 6 33 GND) g45n1svt l=4.5e-08 w=1.08e-06 ad=1.512e-13 as=1.512e-13 pd=2.44e-06 ps=2.44e-06 sa=1.4e-07 sb=1.4e-07 sca=3.04786 scb=0.000104839 scc=6.53879e-09
M141 (GND 7 61 GND) g45n1svt l=4.5e-08 w=3.6e-07 ad=5.04e-14 as=5.04e-14 pd=1e-06 ps=1e-06 sa=1.4e-07 sb=1.4e-07 sca=3.70436 scb=0.000161812 scc=1.4064e-08
M142 (144 C2 145 GND) g45n1svt l=4.5e-08 w=1.08e-06 ad=1.512e-13 as=1.512e-13 pd=2.44e-06 ps=2.44e-06 sa=1.4e-07 sb=1.4e-07 sca=2.87541 scb=8.38884e-05 scc=2.97061e-09
M143 (141 59 142 GND) g45n1svt l=4.5e-08 w=1.08e-06 ad=1.512e-13 as=1.512e-13 pd=2.44e-06 ps=2.44e-06 sa=1.4e-07 sb=1.4e-07 sca=2.87541 scb=8.38884e-05 scc=2.97061e-09
M144 (146 52 144 GND) g45n1svt l=4.5e-08 w=1.08e-06 ad=1.512e-13 as=1.512e-13 pd=2.44e-06 ps=2.44e-06 sa=1.4e-07 sb=1.4e-07 sca=2.87541 scb=8.38884e-05 scc=2.97061e-09
M145 (143 57 141 GND) g45n1svt l=4.5e-08 w=1.08e-06 ad=1.512e-13 as=1.512e-13 pd=2.44e-06 ps=2.44e-06 sa=1.4e-07 sb=1.4e-07 sca=2.87541 scb=8.38884e-05 scc=2.97061e-09
M146 (GND 51 146 GND) g45n1svt l=4.5e-08 w=1.08e-06 ad=1.512e-13 as=1.512e-13 pd=2.44e-06 ps=2.44e-06 sa=1.4e-07 sb=1.4e-07 sca=2.87541 scb=8.38884e-05 scc=2.97061e-09
M147 (GND 39 143 GND) g45n1svt l=4.5e-08 w=1.08e-06 ad=1.512e-13 as=1.512e-13 pd=2.44e-06 ps=2.44e-06 sa=1.4e-07 sb=1.4e-07 sca=2.87541 scb=8.38884e-05 scc=2.97061e-09
M148 (GND 145 7 GND) g45n1svt l=4.5e-08 w=3.6e-07 ad=5.04e-14 as=5.04e-14 pd=1e-06 ps=1e-06 sa=1.4e-07 sb=1.4e-07 sca=3.38446 scb=0.000101379 scc=3.37079e-09
M149 (GND 142 36 GND) g45n1svt l=4.5e-08 w=3.6e-07 ad=5.04e-14 as=5.04e-14 pd=1e-06 ps=1e-06 sa=1.4e-07 sb=1.4e-07 sca=3.38446 scb=0.000101379 scc=3.37079e-09
M150 (13 7 32 GND) g45n1svt l=4.5e-08 w=1.08e-06 ad=1.512e-13 as=1.512e-13 pd=2.44e-06 ps=2.44e-06 sa=1.4e-07 sb=1.4e-07 sca=3.04786 scb=0.000104839 scc=6.53879e-09
M151 (GND 34 35 GND) g45n1svt l=4.5e-08 w=3.6e-07 ad=5.04e-14 as=5.04e-14 pd=1e-06 ps=1e-06 sa=1.4e-07 sb=1.4e-07 sca=3.70436 scb=0.000161812 scc=1.4064e-08
M152 (147 C2 148 GND) g45n1svt l=4.5e-08 w=1.08e-06 ad=1.512e-13 as=1.512e-13 pd=2.44e-06 ps=2.44e-06 sa=1.4e-07 sb=1.4e-07 sca=2.87541 scb=8.38884e-05 scc=2.97061e-09
M153 (30 7 33 GND) g45n1svt l=4.5e-08 w=1.08e-06 ad=1.512e-13 as=1.512e-13 pd=2.44e-06 ps=2.44e-06 sa=1.4e-07 sb=1.4e-07 sca=3.04786 scb=0.000104839 scc=6.53879e-09
M154 (149 52 147 GND) g45n1svt l=4.5e-08 w=1.08e-06 ad=1.512e-13 as=1.512e-13 pd=2.44e-06 ps=2.44e-06 sa=1.4e-07 sb=1.4e-07 sca=2.87541 scb=8.38884e-05 scc=2.97061e-09
M155 (GND C0 149 GND) g45n1svt l=4.5e-08 w=1.08e-06 ad=1.512e-13 as=1.512e-13 pd=2.44e-06 ps=2.44e-06 sa=1.4e-07 sb=1.4e-07 sca=2.87541 scb=8.38884e-05 scc=2.97061e-09
M156 (GND 148 8 GND) g45n1svt l=4.5e-08 w=3.6e-07 ad=5.04e-14 as=5.04e-14 pd=1e-06 ps=1e-06 sa=1.4e-07 sb=1.4e-07 sca=3.38446 scb=0.000101379 scc=3.37079e-09
M157 (GND 36 37 GND) g45n1svt l=4.5e-08 w=3.6e-07 ad=5.04e-14 as=5.04e-14 pd=1e-06 ps=1e-06 sa=1.4e-07 sb=1.4e-07 sca=3.70436 scb=0.000161812 scc=1.4064e-08
M158 (GND 8 62 GND) g45n1svt l=4.5e-08 w=3.6e-07 ad=5.04e-14 as=5.04e-14 pd=1e-06 ps=1e-06 sa=1.4e-07 sb=1.4e-07 sca=3.70436 scb=0.000161812 scc=1.4064e-08
M159 (150 35 151 GND) g45n1svt l=4.5e-08 w=1.08e-06 ad=1.512e-13 as=1.512e-13 pd=2.44e-06 ps=2.44e-06 sa=1.4e-07 sb=1.4e-07 sca=2.87541 scb=8.38884e-05 scc=2.97061e-09
M160 (25 8 32 GND) g45n1svt l=4.5e-08 w=1.08e-06 ad=1.512e-13 as=1.512e-13 pd=2.44e-06 ps=2.44e-06 sa=1.4e-07 sb=1.4e-07 sca=3.04786 scb=0.000104839 scc=6.53879e-09
M161 (152 37 150 GND) g45n1svt l=4.5e-08 w=1.08e-06 ad=1.512e-13 as=1.512e-13 pd=2.44e-06 ps=2.44e-06 sa=1.4e-07 sb=1.4e-07 sca=2.87541 scb=8.38884e-05 scc=2.97061e-09
M162 (GND VDD 152 GND) g45n1svt l=4.5e-08 w=1.08e-06 ad=1.512e-13 as=1.512e-13 pd=2.44e-06 ps=2.44e-06 sa=1.4e-07 sb=1.4e-07 sca=2.87541 scb=8.38884e-05 scc=2.97061e-09
M163 (GND 151 63 GND) g45n1svt l=4.5e-08 w=3.6e-07 ad=5.04e-14 as=5.04e-14 pd=1e-06 ps=1e-06 sa=1.4e-07 sb=1.4e-07 sca=3.38446 scb=0.000101379 scc=3.37079e-09
M164 (GND R0 64 GND) g45n1svt l=4.5e-08 w=3.6e-07 ad=5.04e-14 as=5.04e-14 pd=1e-06 ps=1e-06 sa=1.4e-07 sb=1.4e-07 sca=3.70436 scb=0.000161812 scc=1.4064e-08
M165 (31 8 33 GND) g45n1svt l=4.5e-08 w=1.08e-06 ad=1.512e-13 as=1.512e-13 pd=2.44e-06 ps=2.44e-06 sa=1.4e-07 sb=1.4e-07 sca=3.04786 scb=0.000104839 scc=6.53879e-09
M166 (GND 63 38 GND) g45n1svt l=4.5e-08 w=3.6e-07 ad=5.04e-14 as=5.04e-14 pd=1e-06 ps=1e-06 sa=1.4e-07 sb=1.4e-07 sca=3.70436 scb=0.000161812 scc=1.4064e-08
M167 (GND R1 65 GND) g45n1svt l=4.5e-08 w=3.6e-07 ad=5.04e-14 as=5.04e-14 pd=1e-06 ps=1e-06 sa=1.4e-07 sb=1.4e-07 sca=3.70436 scb=0.000161812 scc=1.4064e-08
M168 (153 65 154 GND) g45n1svt l=4.5e-08 w=1.08e-06 ad=1.512e-13 as=1.512e-13 pd=2.44e-06 ps=2.44e-06 sa=1.4e-07 sb=1.4e-07 sca=2.87541 scb=8.38884e-05 scc=2.97061e-09
M169 (155 64 153 GND) g45n1svt l=4.5e-08 w=1.08e-06 ad=1.512e-13 as=1.512e-13 pd=2.44e-06 ps=2.44e-06 sa=1.4e-07 sb=1.4e-07 sca=2.87541 scb=8.38884e-05 scc=2.97061e-09
M170 (GND 38 155 GND) g45n1svt l=4.5e-08 w=1.08e-06 ad=1.512e-13 as=1.512e-13 pd=2.44e-06 ps=2.44e-06 sa=1.4e-07 sb=1.4e-07 sca=2.87541 scb=8.38884e-05 scc=2.97061e-09
M171 (GND 154 40 GND) g45n1svt l=4.5e-08 w=3.6e-07 ad=5.04e-14 as=5.04e-14 pd=1e-06 ps=1e-06 sa=1.4e-07 sb=1.4e-07 sca=3.38446 scb=0.000101379 scc=3.37079e-09
M172 (156 65 157 GND) g45n1svt l=4.5e-08 w=1.08e-06 ad=1.512e-13 as=1.512e-13 pd=2.44e-06 ps=2.44e-06 sa=1.4e-07 sb=1.4e-07 sca=2.87541 scb=8.38884e-05 scc=2.97061e-09
M173 (26 40 69 GND) g45n1svt l=4.5e-08 w=2.4e-07 ad=3.36e-14 as=3.36e-14 pd=7.6e-07 ps=7.6e-07 sa=1.4e-07 sb=1.4e-07 sca=9.45211 scb=0.00821004 scc=0.000286958
M174 (26 41 71 GND) g45n1svt l=4.5e-08 w=2.4e-07 ad=3.36e-14 as=3.36e-14 pd=7.6e-07 ps=7.6e-07 sa=1.4e-07 sb=1.4e-07 sca=9.45211 scb=0.00821004 scc=0.000286958
M175 (26 42 73 GND) g45n1svt l=4.5e-08 w=2.4e-07 ad=3.36e-14 as=3.36e-14 pd=7.6e-07 ps=7.6e-07 sa=1.4e-07 sb=1.4e-07 sca=9.45211 scb=0.00821004 scc=0.000286958
M176 (26 43 75 GND) g45n1svt l=4.5e-08 w=2.4e-07 ad=3.36e-14 as=3.36e-14 pd=7.6e-07 ps=7.6e-07 sa=1.4e-07 sb=1.4e-07 sca=9.45211 scb=0.00821004 scc=0.000286958
M177 (158 R0 156 GND) g45n1svt l=4.5e-08 w=1.08e-06 ad=1.512e-13 as=1.512e-13 pd=2.44e-06 ps=2.44e-06 sa=1.4e-07 sb=1.4e-07 sca=2.87541 scb=8.38884e-05 scc=2.97061e-09
M178 (GND 70 69 GND) g45n1svt l=4.5e-08 w=3.6e-07 ad=5.04e-14 as=5.04e-14 pd=1e-06 ps=1e-06 sa=1.4e-07 sb=1.4e-07 sca=5.75838 scb=0.0022385 scc=1.60319e-05
M179 (GND 72 71 GND) g45n1svt l=4.5e-08 w=3.6e-07 ad=5.04e-14 as=5.04e-14 pd=1e-06 ps=1e-06 sa=1.4e-07 sb=1.4e-07 sca=6.05657 scb=0.00229265 scc=1.60407e-05
M180 (GND 74 73 GND) g45n1svt l=4.5e-08 w=3.6e-07 ad=5.04e-14 as=5.04e-14 pd=1e-06 ps=1e-06 sa=1.4e-07 sb=1.4e-07 sca=6.05657 scb=0.00229265 scc=1.60407e-05
M181 (GND 76 75 GND) g45n1svt l=4.5e-08 w=3.6e-07 ad=5.04e-14 as=5.04e-14 pd=1e-06 ps=1e-06 sa=1.4e-07 sb=1.4e-07 sca=6.05657 scb=0.00229265 scc=1.60407e-05
M182 (GND 69 70 GND) g45n1svt l=4.5e-08 w=3.6e-07 ad=5.04e-14 as=5.04e-14 pd=1e-06 ps=1e-06 sa=1.4e-07 sb=1.4e-07 sca=5.75838 scb=0.0022385 scc=1.60319e-05
M183 (GND 71 72 GND) g45n1svt l=4.5e-08 w=3.6e-07 ad=5.04e-14 as=5.04e-14 pd=1e-06 ps=1e-06 sa=1.4e-07 sb=1.4e-07 sca=6.05657 scb=0.00229265 scc=1.60407e-05
M184 (GND 73 74 GND) g45n1svt l=4.5e-08 w=3.6e-07 ad=5.04e-14 as=5.04e-14 pd=1e-06 ps=1e-06 sa=1.4e-07 sb=1.4e-07 sca=6.05657 scb=0.00229265 scc=1.60407e-05
M185 (GND 75 76 GND) g45n1svt l=4.5e-08 w=3.6e-07 ad=5.04e-14 as=5.04e-14 pd=1e-06 ps=1e-06 sa=1.4e-07 sb=1.4e-07 sca=6.05657 scb=0.00229265 scc=1.60407e-05
M186 (GND 38 158 GND) g45n1svt l=4.5e-08 w=1.08e-06 ad=1.512e-13 as=1.512e-13 pd=2.44e-06 ps=2.44e-06 sa=1.4e-07 sb=1.4e-07 sca=2.87541 scb=8.38884e-05 scc=2.97061e-09
M187 (70 40 9 GND) g45n1svt l=4.5e-08 w=2.4e-07 ad=3.36e-14 as=3.36e-14 pd=7.6e-07 ps=7.6e-07 sa=1.4e-07 sb=1.4e-07 sca=6.50517 scb=0.00415999 scc=0.000152707
M188 (72 41 9 GND) g45n1svt l=4.5e-08 w=2.4e-07 ad=3.36e-14 as=3.36e-14 pd=7.6e-07 ps=7.6e-07 sa=1.4e-07 sb=1.4e-07 sca=6.50517 scb=0.00415999 scc=0.000152707
M189 (74 42 9 GND) g45n1svt l=4.5e-08 w=2.4e-07 ad=3.36e-14 as=3.36e-14 pd=7.6e-07 ps=7.6e-07 sa=1.4e-07 sb=1.4e-07 sca=6.50517 scb=0.00415999 scc=0.000152707
M190 (76 43 9 GND) g45n1svt l=4.5e-08 w=2.4e-07 ad=3.36e-14 as=3.36e-14 pd=7.6e-07 ps=7.6e-07 sa=1.4e-07 sb=1.4e-07 sca=6.50517 scb=0.00415999 scc=0.000152707
M191 (GND 157 41 GND) g45n1svt l=4.5e-08 w=3.6e-07 ad=5.04e-14 as=5.04e-14 pd=1e-06 ps=1e-06 sa=1.4e-07 sb=1.4e-07 sca=3.38446 scb=0.000101379 scc=3.37079e-09
M192 (27 40 77 GND) g45n1svt l=4.5e-08 w=2.4e-07 ad=3.36e-14 as=3.36e-14 pd=7.6e-07 ps=7.6e-07 sa=1.4e-07 sb=1.4e-07 sca=9.45211 scb=0.00821004 scc=0.000286958
M193 (27 41 85 GND) g45n1svt l=4.5e-08 w=2.4e-07 ad=3.36e-14 as=3.36e-14 pd=7.6e-07 ps=7.6e-07 sa=1.4e-07 sb=1.4e-07 sca=9.45211 scb=0.00821004 scc=0.000286958
M194 (27 42 93 GND) g45n1svt l=4.5e-08 w=2.4e-07 ad=3.36e-14 as=3.36e-14 pd=7.6e-07 ps=7.6e-07 sa=1.4e-07 sb=1.4e-07 sca=9.45211 scb=0.00821004 scc=0.000286958
M195 (27 43 101 GND) g45n1svt l=4.5e-08 w=2.4e-07 ad=3.36e-14 as=3.36e-14 pd=7.6e-07 ps=7.6e-07 sa=1.4e-07 sb=1.4e-07 sca=9.45211 scb=0.00821004 scc=0.000286958
M196 (GND 78 77 GND) g45n1svt l=4.5e-08 w=3.6e-07 ad=5.04e-14 as=5.04e-14 pd=1e-06 ps=1e-06 sa=1.4e-07 sb=1.4e-07 sca=5.75838 scb=0.0022385 scc=1.60319e-05
M197 (GND 86 85 GND) g45n1svt l=4.5e-08 w=3.6e-07 ad=5.04e-14 as=5.04e-14 pd=1e-06 ps=1e-06 sa=1.4e-07 sb=1.4e-07 sca=6.05657 scb=0.00229265 scc=1.60407e-05
M198 (GND 94 93 GND) g45n1svt l=4.5e-08 w=3.6e-07 ad=5.04e-14 as=5.04e-14 pd=1e-06 ps=1e-06 sa=1.4e-07 sb=1.4e-07 sca=6.05657 scb=0.00229265 scc=1.60407e-05
M199 (GND 102 101 GND) g45n1svt l=4.5e-08 w=3.6e-07 ad=5.04e-14 as=5.04e-14 pd=1e-06 ps=1e-06 sa=1.4e-07 sb=1.4e-07 sca=6.05657 scb=0.00229265 scc=1.60407e-05
M200 (GND 77 78 GND) g45n1svt l=4.5e-08 w=3.6e-07 ad=5.04e-14 as=5.04e-14 pd=1e-06 ps=1e-06 sa=1.4e-07 sb=1.4e-07 sca=5.75838 scb=0.0022385 scc=1.60319e-05
M201 (GND 85 86 GND) g45n1svt l=4.5e-08 w=3.6e-07 ad=5.04e-14 as=5.04e-14 pd=1e-06 ps=1e-06 sa=1.4e-07 sb=1.4e-07 sca=6.05657 scb=0.00229265 scc=1.60407e-05
M202 (GND 93 94 GND) g45n1svt l=4.5e-08 w=3.6e-07 ad=5.04e-14 as=5.04e-14 pd=1e-06 ps=1e-06 sa=1.4e-07 sb=1.4e-07 sca=6.05657 scb=0.00229265 scc=1.60407e-05
M203 (GND 101 102 GND) g45n1svt l=4.5e-08 w=3.6e-07 ad=5.04e-14 as=5.04e-14 pd=1e-06 ps=1e-06 sa=1.4e-07 sb=1.4e-07 sca=6.05657 scb=0.00229265 scc=1.60407e-05
M204 (78 40 10 GND) g45n1svt l=4.5e-08 w=2.4e-07 ad=3.36e-14 as=3.36e-14 pd=7.6e-07 ps=7.6e-07 sa=1.4e-07 sb=1.4e-07 sca=6.50517 scb=0.00415999 scc=0.000152707
M205 (86 41 10 GND) g45n1svt l=4.5e-08 w=2.4e-07 ad=3.36e-14 as=3.36e-14 pd=7.6e-07 ps=7.6e-07 sa=1.4e-07 sb=1.4e-07 sca=6.50517 scb=0.00415999 scc=0.000152707
M206 (94 42 10 GND) g45n1svt l=4.5e-08 w=2.4e-07 ad=3.36e-14 as=3.36e-14 pd=7.6e-07 ps=7.6e-07 sa=1.4e-07 sb=1.4e-07 sca=6.50517 scb=0.00415999 scc=0.000152707
M207 (102 43 10 GND) g45n1svt l=4.5e-08 w=2.4e-07 ad=3.36e-14 as=3.36e-14 pd=7.6e-07 ps=7.6e-07 sa=1.4e-07 sb=1.4e-07 sca=6.50517 scb=0.00415999 scc=0.000152707
M208 (28 40 79 GND) g45n1svt l=4.5e-08 w=2.4e-07 ad=3.36e-14 as=3.36e-14 pd=7.6e-07 ps=7.6e-07 sa=1.4e-07 sb=1.4e-07 sca=9.45211 scb=0.00821004 scc=0.000286958
M209 (28 41 87 GND) g45n1svt l=4.5e-08 w=2.4e-07 ad=3.36e-14 as=3.36e-14 pd=7.6e-07 ps=7.6e-07 sa=1.4e-07 sb=1.4e-07 sca=9.45211 scb=0.00821004 scc=0.000286958
M210 (28 42 95 GND) g45n1svt l=4.5e-08 w=2.4e-07 ad=3.36e-14 as=3.36e-14 pd=7.6e-07 ps=7.6e-07 sa=1.4e-07 sb=1.4e-07 sca=9.45211 scb=0.00821004 scc=0.000286958
M211 (28 43 103 GND) g45n1svt l=4.5e-08 w=2.4e-07 ad=3.36e-14 as=3.36e-14 pd=7.6e-07 ps=7.6e-07 sa=1.4e-07 sb=1.4e-07 sca=9.45211 scb=0.00821004 scc=0.000286958
M212 (GND 80 79 GND) g45n1svt l=4.5e-08 w=3.6e-07 ad=5.04e-14 as=5.04e-14 pd=1e-06 ps=1e-06 sa=1.4e-07 sb=1.4e-07 sca=5.75838 scb=0.0022385 scc=1.60319e-05
M213 (GND 88 87 GND) g45n1svt l=4.5e-08 w=3.6e-07 ad=5.04e-14 as=5.04e-14 pd=1e-06 ps=1e-06 sa=1.4e-07 sb=1.4e-07 sca=6.05657 scb=0.00229265 scc=1.60407e-05
M214 (GND 96 95 GND) g45n1svt l=4.5e-08 w=3.6e-07 ad=5.04e-14 as=5.04e-14 pd=1e-06 ps=1e-06 sa=1.4e-07 sb=1.4e-07 sca=6.05657 scb=0.00229265 scc=1.60407e-05
M215 (GND 104 103 GND) g45n1svt l=4.5e-08 w=3.6e-07 ad=5.04e-14 as=5.04e-14 pd=1e-06 ps=1e-06 sa=1.4e-07 sb=1.4e-07 sca=6.05657 scb=0.00229265 scc=1.60407e-05
M216 (GND 79 80 GND) g45n1svt l=4.5e-08 w=3.6e-07 ad=5.04e-14 as=5.04e-14 pd=1e-06 ps=1e-06 sa=1.4e-07 sb=1.4e-07 sca=5.75838 scb=0.0022385 scc=1.60319e-05
M217 (GND 87 88 GND) g45n1svt l=4.5e-08 w=3.6e-07 ad=5.04e-14 as=5.04e-14 pd=1e-06 ps=1e-06 sa=1.4e-07 sb=1.4e-07 sca=6.05657 scb=0.00229265 scc=1.60407e-05
M218 (GND 95 96 GND) g45n1svt l=4.5e-08 w=3.6e-07 ad=5.04e-14 as=5.04e-14 pd=1e-06 ps=1e-06 sa=1.4e-07 sb=1.4e-07 sca=6.05657 scb=0.00229265 scc=1.60407e-05
M219 (GND 103 104 GND) g45n1svt l=4.5e-08 w=3.6e-07 ad=5.04e-14 as=5.04e-14 pd=1e-06 ps=1e-06 sa=1.4e-07 sb=1.4e-07 sca=6.05657 scb=0.00229265 scc=1.60407e-05
M220 (80 40 11 GND) g45n1svt l=4.5e-08 w=2.4e-07 ad=3.36e-14 as=3.36e-14 pd=7.6e-07 ps=7.6e-07 sa=1.4e-07 sb=1.4e-07 sca=6.50517 scb=0.00415999 scc=0.000152707
M221 (88 41 11 GND) g45n1svt l=4.5e-08 w=2.4e-07 ad=3.36e-14 as=3.36e-14 pd=7.6e-07 ps=7.6e-07 sa=1.4e-07 sb=1.4e-07 sca=6.50517 scb=0.00415999 scc=0.000152707
M222 (96 42 11 GND) g45n1svt l=4.5e-08 w=2.4e-07 ad=3.36e-14 as=3.36e-14 pd=7.6e-07 ps=7.6e-07 sa=1.4e-07 sb=1.4e-07 sca=6.50517 scb=0.00415999 scc=0.000152707
M223 (104 43 11 GND) g45n1svt l=4.5e-08 w=2.4e-07 ad=3.36e-14 as=3.36e-14 pd=7.6e-07 ps=7.6e-07 sa=1.4e-07 sb=1.4e-07 sca=6.50517 scb=0.00415999 scc=0.000152707
M224 (29 40 81 GND) g45n1svt l=4.5e-08 w=2.4e-07 ad=3.36e-14 as=3.36e-14 pd=7.6e-07 ps=7.6e-07 sa=1.4e-07 sb=1.4e-07 sca=9.45211 scb=0.00821004 scc=0.000286958
M225 (29 41 89 GND) g45n1svt l=4.5e-08 w=2.4e-07 ad=3.36e-14 as=3.36e-14 pd=7.6e-07 ps=7.6e-07 sa=1.4e-07 sb=1.4e-07 sca=9.45211 scb=0.00821004 scc=0.000286958
M226 (29 42 97 GND) g45n1svt l=4.5e-08 w=2.4e-07 ad=3.36e-14 as=3.36e-14 pd=7.6e-07 ps=7.6e-07 sa=1.4e-07 sb=1.4e-07 sca=9.45211 scb=0.00821004 scc=0.000286958
M227 (29 43 105 GND) g45n1svt l=4.5e-08 w=2.4e-07 ad=3.36e-14 as=3.36e-14 pd=7.6e-07 ps=7.6e-07 sa=1.4e-07 sb=1.4e-07 sca=9.45211 scb=0.00821004 scc=0.000286958
M228 (159 R1 160 GND) g45n1svt l=4.5e-08 w=1.08e-06 ad=1.512e-13 as=1.512e-13 pd=2.44e-06 ps=2.44e-06 sa=1.4e-07 sb=1.4e-07 sca=2.87541 scb=8.38884e-05 scc=2.97061e-09
M229 (GND 82 81 GND) g45n1svt l=4.5e-08 w=3.6e-07 ad=5.04e-14 as=5.04e-14 pd=1e-06 ps=1e-06 sa=1.4e-07 sb=1.4e-07 sca=5.75838 scb=0.0022385 scc=1.60319e-05
M230 (GND 90 89 GND) g45n1svt l=4.5e-08 w=3.6e-07 ad=5.04e-14 as=5.04e-14 pd=1e-06 ps=1e-06 sa=1.4e-07 sb=1.4e-07 sca=6.05657 scb=0.00229265 scc=1.60407e-05
M231 (GND 98 97 GND) g45n1svt l=4.5e-08 w=3.6e-07 ad=5.04e-14 as=5.04e-14 pd=1e-06 ps=1e-06 sa=1.4e-07 sb=1.4e-07 sca=6.05657 scb=0.00229265 scc=1.60407e-05
M232 (GND 106 105 GND) g45n1svt l=4.5e-08 w=3.6e-07 ad=5.04e-14 as=5.04e-14 pd=1e-06 ps=1e-06 sa=1.4e-07 sb=1.4e-07 sca=6.05657 scb=0.00229265 scc=1.60407e-05
M233 (161 64 159 GND) g45n1svt l=4.5e-08 w=1.08e-06 ad=1.512e-13 as=1.512e-13 pd=2.44e-06 ps=2.44e-06 sa=1.4e-07 sb=1.4e-07 sca=2.87541 scb=8.38884e-05 scc=2.97061e-09
M234 (GND 81 82 GND) g45n1svt l=4.5e-08 w=3.6e-07 ad=5.04e-14 as=5.04e-14 pd=1e-06 ps=1e-06 sa=1.4e-07 sb=1.4e-07 sca=5.75838 scb=0.0022385 scc=1.60319e-05
M235 (GND 89 90 GND) g45n1svt l=4.5e-08 w=3.6e-07 ad=5.04e-14 as=5.04e-14 pd=1e-06 ps=1e-06 sa=1.4e-07 sb=1.4e-07 sca=6.05657 scb=0.00229265 scc=1.60407e-05
M236 (GND 97 98 GND) g45n1svt l=4.5e-08 w=3.6e-07 ad=5.04e-14 as=5.04e-14 pd=1e-06 ps=1e-06 sa=1.4e-07 sb=1.4e-07 sca=6.05657 scb=0.00229265 scc=1.60407e-05
M237 (GND 105 106 GND) g45n1svt l=4.5e-08 w=3.6e-07 ad=5.04e-14 as=5.04e-14 pd=1e-06 ps=1e-06 sa=1.4e-07 sb=1.4e-07 sca=6.05657 scb=0.00229265 scc=1.60407e-05
M238 (GND 38 161 GND) g45n1svt l=4.5e-08 w=1.08e-06 ad=1.512e-13 as=1.512e-13 pd=2.44e-06 ps=2.44e-06 sa=1.4e-07 sb=1.4e-07 sca=2.87541 scb=8.38884e-05 scc=2.97061e-09
M239 (82 40 12 GND) g45n1svt l=4.5e-08 w=2.4e-07 ad=3.36e-14 as=3.36e-14 pd=7.6e-07 ps=7.6e-07 sa=1.4e-07 sb=1.4e-07 sca=6.50517 scb=0.00415999 scc=0.000152707
M240 (90 41 12 GND) g45n1svt l=4.5e-08 w=2.4e-07 ad=3.36e-14 as=3.36e-14 pd=7.6e-07 ps=7.6e-07 sa=1.4e-07 sb=1.4e-07 sca=6.50517 scb=0.00415999 scc=0.000152707
M241 (98 42 12 GND) g45n1svt l=4.5e-08 w=2.4e-07 ad=3.36e-14 as=3.36e-14 pd=7.6e-07 ps=7.6e-07 sa=1.4e-07 sb=1.4e-07 sca=6.50517 scb=0.00415999 scc=0.000152707
M242 (106 43 12 GND) g45n1svt l=4.5e-08 w=2.4e-07 ad=3.36e-14 as=3.36e-14 pd=7.6e-07 ps=7.6e-07 sa=1.4e-07 sb=1.4e-07 sca=6.50517 scb=0.00415999 scc=0.000152707
M243 (GND 160 42 GND) g45n1svt l=4.5e-08 w=3.6e-07 ad=5.04e-14 as=5.04e-14 pd=1e-06 ps=1e-06 sa=1.4e-07 sb=1.4e-07 sca=3.38446 scb=0.000101379 scc=3.37079e-09
M244 (30 40 83 GND) g45n1svt l=4.5e-08 w=2.4e-07 ad=3.36e-14 as=3.36e-14 pd=7.6e-07 ps=7.6e-07 sa=1.4e-07 sb=1.4e-07 sca=9.45211 scb=0.00821004 scc=0.000286958
M245 (30 41 91 GND) g45n1svt l=4.5e-08 w=2.4e-07 ad=3.36e-14 as=3.36e-14 pd=7.6e-07 ps=7.6e-07 sa=1.4e-07 sb=1.4e-07 sca=9.45211 scb=0.00821004 scc=0.000286958
M246 (30 42 99 GND) g45n1svt l=4.5e-08 w=2.4e-07 ad=3.36e-14 as=3.36e-14 pd=7.6e-07 ps=7.6e-07 sa=1.4e-07 sb=1.4e-07 sca=9.45211 scb=0.00821004 scc=0.000286958
M247 (30 43 107 GND) g45n1svt l=4.5e-08 w=2.4e-07 ad=3.36e-14 as=3.36e-14 pd=7.6e-07 ps=7.6e-07 sa=1.4e-07 sb=1.4e-07 sca=9.45211 scb=0.00821004 scc=0.000286958
M248 (GND 84 83 GND) g45n1svt l=4.5e-08 w=3.6e-07 ad=5.04e-14 as=5.04e-14 pd=1e-06 ps=1e-06 sa=1.4e-07 sb=1.4e-07 sca=5.75838 scb=0.0022385 scc=1.60319e-05
M249 (GND 92 91 GND) g45n1svt l=4.5e-08 w=3.6e-07 ad=5.04e-14 as=5.04e-14 pd=1e-06 ps=1e-06 sa=1.4e-07 sb=1.4e-07 sca=6.05657 scb=0.00229265 scc=1.60407e-05
M250 (GND 100 99 GND) g45n1svt l=4.5e-08 w=3.6e-07 ad=5.04e-14 as=5.04e-14 pd=1e-06 ps=1e-06 sa=1.4e-07 sb=1.4e-07 sca=6.05657 scb=0.00229265 scc=1.60407e-05
M251 (GND 108 107 GND) g45n1svt l=4.5e-08 w=3.6e-07 ad=5.04e-14 as=5.04e-14 pd=1e-06 ps=1e-06 sa=1.4e-07 sb=1.4e-07 sca=6.05657 scb=0.00229265 scc=1.60407e-05
M252 (GND 83 84 GND) g45n1svt l=4.5e-08 w=3.6e-07 ad=5.04e-14 as=5.04e-14 pd=1e-06 ps=1e-06 sa=1.4e-07 sb=1.4e-07 sca=5.75838 scb=0.0022385 scc=1.60319e-05
M253 (GND 91 92 GND) g45n1svt l=4.5e-08 w=3.6e-07 ad=5.04e-14 as=5.04e-14 pd=1e-06 ps=1e-06 sa=1.4e-07 sb=1.4e-07 sca=6.05657 scb=0.00229265 scc=1.60407e-05
M254 (GND 99 100 GND) g45n1svt l=4.5e-08 w=3.6e-07 ad=5.04e-14 as=5.04e-14 pd=1e-06 ps=1e-06 sa=1.4e-07 sb=1.4e-07 sca=6.05657 scb=0.00229265 scc=1.60407e-05
M255 (GND 107 108 GND) g45n1svt l=4.5e-08 w=3.6e-07 ad=5.04e-14 as=5.04e-14 pd=1e-06 ps=1e-06 sa=1.4e-07 sb=1.4e-07 sca=6.05657 scb=0.00229265 scc=1.60407e-05
M256 (84 40 13 GND) g45n1svt l=4.5e-08 w=2.4e-07 ad=3.36e-14 as=3.36e-14 pd=7.6e-07 ps=7.6e-07 sa=1.4e-07 sb=1.4e-07 sca=6.50517 scb=0.00415999 scc=0.000152707
M257 (92 41 13 GND) g45n1svt l=4.5e-08 w=2.4e-07 ad=3.36e-14 as=3.36e-14 pd=7.6e-07 ps=7.6e-07 sa=1.4e-07 sb=1.4e-07 sca=6.50517 scb=0.00415999 scc=0.000152707
M258 (100 42 13 GND) g45n1svt l=4.5e-08 w=2.4e-07 ad=3.36e-14 as=3.36e-14 pd=7.6e-07 ps=7.6e-07 sa=1.4e-07 sb=1.4e-07 sca=6.50517 scb=0.00415999 scc=0.000152707
M259 (108 43 13 GND) g45n1svt l=4.5e-08 w=2.4e-07 ad=3.36e-14 as=3.36e-14 pd=7.6e-07 ps=7.6e-07 sa=1.4e-07 sb=1.4e-07 sca=6.50517 scb=0.00415999 scc=0.000152707
M260 (31 40 109 GND) g45n1svt l=4.5e-08 w=2.4e-07 ad=3.36e-14 as=3.36e-14 pd=7.6e-07 ps=7.6e-07 sa=1.4e-07 sb=1.4e-07 sca=9.45211 scb=0.00821004 scc=0.000286958
M261 (31 41 111 GND) g45n1svt l=4.5e-08 w=2.4e-07 ad=3.36e-14 as=3.36e-14 pd=7.6e-07 ps=7.6e-07 sa=1.4e-07 sb=1.4e-07 sca=9.45211 scb=0.00821004 scc=0.000286958
M262 (31 42 113 GND) g45n1svt l=4.5e-08 w=2.4e-07 ad=3.36e-14 as=3.36e-14 pd=7.6e-07 ps=7.6e-07 sa=1.4e-07 sb=1.4e-07 sca=9.45211 scb=0.00821004 scc=0.000286958
M263 (31 43 115 GND) g45n1svt l=4.5e-08 w=2.4e-07 ad=3.36e-14 as=3.36e-14 pd=7.6e-07 ps=7.6e-07 sa=1.4e-07 sb=1.4e-07 sca=9.45211 scb=0.00821004 scc=0.000286958
M264 (GND 110 109 GND) g45n1svt l=4.5e-08 w=3.6e-07 ad=5.04e-14 as=5.04e-14 pd=1e-06 ps=1e-06 sa=1.4e-07 sb=1.4e-07 sca=5.75838 scb=0.0022385 scc=1.60319e-05
M265 (GND 112 111 GND) g45n1svt l=4.5e-08 w=3.6e-07 ad=5.04e-14 as=5.04e-14 pd=1e-06 ps=1e-06 sa=1.4e-07 sb=1.4e-07 sca=6.05657 scb=0.00229265 scc=1.60407e-05
M266 (GND 114 113 GND) g45n1svt l=4.5e-08 w=3.6e-07 ad=5.04e-14 as=5.04e-14 pd=1e-06 ps=1e-06 sa=1.4e-07 sb=1.4e-07 sca=6.05657 scb=0.00229265 scc=1.60407e-05
M267 (GND 116 115 GND) g45n1svt l=4.5e-08 w=3.6e-07 ad=5.04e-14 as=5.04e-14 pd=1e-06 ps=1e-06 sa=1.4e-07 sb=1.4e-07 sca=6.05657 scb=0.00229265 scc=1.60407e-05
M268 (GND 109 110 GND) g45n1svt l=4.5e-08 w=3.6e-07 ad=5.04e-14 as=5.04e-14 pd=1e-06 ps=1e-06 sa=1.4e-07 sb=1.4e-07 sca=5.75838 scb=0.0022385 scc=1.60319e-05
M269 (GND 111 112 GND) g45n1svt l=4.5e-08 w=3.6e-07 ad=5.04e-14 as=5.04e-14 pd=1e-06 ps=1e-06 sa=1.4e-07 sb=1.4e-07 sca=6.05657 scb=0.00229265 scc=1.60407e-05
M270 (GND 113 114 GND) g45n1svt l=4.5e-08 w=3.6e-07 ad=5.04e-14 as=5.04e-14 pd=1e-06 ps=1e-06 sa=1.4e-07 sb=1.4e-07 sca=6.05657 scb=0.00229265 scc=1.60407e-05
M271 (GND 115 116 GND) g45n1svt l=4.5e-08 w=3.6e-07 ad=5.04e-14 as=5.04e-14 pd=1e-06 ps=1e-06 sa=1.4e-07 sb=1.4e-07 sca=6.05657 scb=0.00229265 scc=1.60407e-05
M272 (110 40 25 GND) g45n1svt l=4.5e-08 w=2.4e-07 ad=3.36e-14 as=3.36e-14 pd=7.6e-07 ps=7.6e-07 sa=1.4e-07 sb=1.4e-07 sca=6.06571 scb=0.00385227 scc=0.000152152
M273 (112 41 25 GND) g45n1svt l=4.5e-08 w=2.4e-07 ad=3.36e-14 as=3.36e-14 pd=7.6e-07 ps=7.6e-07 sa=1.4e-07 sb=1.4e-07 sca=6.06571 scb=0.00385227 scc=0.000152152
M274 (114 42 25 GND) g45n1svt l=4.5e-08 w=2.4e-07 ad=3.36e-14 as=3.36e-14 pd=7.6e-07 ps=7.6e-07 sa=1.4e-07 sb=1.4e-07 sca=6.06571 scb=0.00385227 scc=0.000152152
M275 (116 43 25 GND) g45n1svt l=4.5e-08 w=2.4e-07 ad=3.36e-14 as=3.36e-14 pd=7.6e-07 ps=7.6e-07 sa=1.4e-07 sb=1.4e-07 sca=6.06571 scb=0.00385227 scc=0.000152152
M276 (162 R1 163 GND) g45n1svt l=4.5e-08 w=1.08e-06 ad=1.512e-13 as=1.512e-13 pd=2.44e-06 ps=2.44e-06 sa=1.4e-07 sb=1.4e-07 sca=2.87541 scb=8.38884e-05 scc=2.97061e-09
M277 (164 R0 162 GND) g45n1svt l=4.5e-08 w=1.08e-06 ad=1.512e-13 as=1.512e-13 pd=2.44e-06 ps=2.44e-06 sa=1.4e-07 sb=1.4e-07 sca=2.87541 scb=8.38884e-05 scc=2.97061e-09
M278 (GND 38 164 GND) g45n1svt l=4.5e-08 w=1.08e-06 ad=1.512e-13 as=1.512e-13 pd=2.44e-06 ps=2.44e-06 sa=1.4e-07 sb=1.4e-07 sca=2.87541 scb=8.38884e-05 scc=2.97061e-09
M279 (GND 163 43 GND) g45n1svt l=4.5e-08 w=3.6e-07 ad=5.04e-14 as=5.04e-14 pd=1e-06 ps=1e-06 sa=1.4e-07 sb=1.4e-07 sca=3.38446 scb=0.000101379 scc=3.37079e-09
M280 (44 36 66 GND) g45n1svt l=4.5e-08 w=1.08e-06 ad=1.512e-13 as=1.512e-13 pd=2.44e-06 ps=2.44e-06 sa=1.4e-07 sb=1.4e-07 sca=3.04786 scb=0.000104839 scc=6.53879e-09
M281 (GND 66 67 GND) g45n1svt l=4.5e-08 w=3.6e-07 ad=5.04e-14 as=5.04e-14 pd=1e-06 ps=1e-06 sa=1.4e-07 sb=1.4e-07 sca=3.70436 scb=0.000161812 scc=1.4064e-08
M282 (GND DIN 68 GND) g45n1svt l=4.5e-08 w=3.6e-07 ad=5.04e-14 as=5.04e-14 pd=1e-06 ps=1e-06 sa=1.4e-07 sb=1.4e-07 sca=3.70436 scb=0.000161812 scc=1.4064e-08
M283 (GND 67 DOUT GND) g45n1svt l=4.5e-08 w=3.6e-07 ad=5.04e-14 as=5.04e-14 pd=1e-06 ps=1e-06 sa=1.4e-07 sb=1.4e-07 sca=3.70436 scb=0.000161812 scc=1.4064e-08
M284 (DIN 34 32 GND) g45n1svt l=4.5e-08 w=1.08e-06 ad=1.512e-13 as=1.512e-13 pd=2.44e-06 ps=2.44e-06 sa=1.4e-07 sb=1.4e-07 sca=3.04786 scb=0.000104839 scc=6.53879e-09
M285 (45 32 46 GND) g45n1svt l=4.5e-08 w=2.4e-07 ad=3.36e-14 as=3.36e-14 pd=7.6e-07 ps=7.6e-07 sa=1.4e-07 sb=1.4e-07 sca=3.52678 scb=0.000111658 scc=3.66286e-09
M286 (DOUT 37 66 GND) g45n1svt l=4.5e-08 w=1.08e-06 ad=1.512e-13 as=1.512e-13 pd=2.44e-06 ps=2.44e-06 sa=1.4e-07 sb=1.4e-07 sca=3.04786 scb=0.000104839 scc=6.53879e-09
M287 (45 33 47 GND) g45n1svt l=4.5e-08 w=2.4e-07 ad=3.36e-14 as=3.36e-14 pd=7.6e-07 ps=7.6e-07 sa=1.4e-07 sb=1.4e-07 sca=3.52678 scb=0.000111658 scc=3.66286e-09
M288 (GND 46 44 GND) g45n1svt l=4.5e-08 w=3.6e-07 ad=5.04e-14 as=5.04e-14 pd=1e-06 ps=1e-06 sa=1.4e-07 sb=1.4e-07 sca=3.38446 scb=0.000101379 scc=3.37079e-09
M289 (68 34 33 GND) g45n1svt l=4.5e-08 w=1.08e-06 ad=1.512e-13 as=1.512e-13 pd=2.44e-06 ps=2.44e-06 sa=1.4e-07 sb=1.4e-07 sca=3.04786 scb=0.000104839 scc=6.53879e-09
M290 (GND 36 45 GND) g45n1svt l=4.5e-08 w=3.6e-07 ad=5.04e-14 as=5.04e-14 pd=1e-06 ps=1e-06 sa=1.4e-07 sb=1.4e-07 sca=3.38446 scb=0.000101379 scc=3.37079e-09
M291 (VDD 3 48 VDD) g45p1svt l=4.5e-08 w=3.6e-07 ad=5.04e-14 as=5.04e-14 pd=1e-06 ps=1e-06 sa=1.4e-07 sb=1.4e-07 sca=21.3981 scb=0.0224765 scc=0.00127211
M292 (9 48 32 VDD) g45p1svt l=4.5e-08 w=1.08e-06 ad=1.512e-13 as=1.512e-13 pd=2.44e-06 ps=2.44e-06 sa=1.4e-07 sb=1.4e-07 sca=11.3534 scb=0.00879444 scc=0.000426483
M293 (VDD RD 49 VDD) g45p1svt l=4.5e-08 w=3.6e-07 ad=5.04e-14 as=5.04e-14 pd=1e-06 ps=1e-06 sa=1.4e-07 sb=1.4e-07 sca=21.3981 scb=0.0224765 scc=0.00127211
M294 (VDD C0 51 VDD) g45p1svt l=4.5e-08 w=3.6e-07 ad=5.04e-14 as=5.04e-14 pd=1e-06 ps=1e-06 sa=1.4e-07 sb=1.4e-07 sca=21.3981 scb=0.0224765 scc=0.00127211
M295 (VDD WR 50 VDD) g45p1svt l=4.5e-08 w=3.6e-07 ad=5.04e-14 as=5.04e-14 pd=1e-06 ps=1e-06 sa=1.4e-07 sb=1.4e-07 sca=21.3981 scb=0.0224765 scc=0.00127211
M296 (26 48 33 VDD) g45p1svt l=4.5e-08 w=1.08e-06 ad=1.512e-13 as=1.512e-13 pd=2.44e-06 ps=2.44e-06 sa=1.4e-07 sb=1.4e-07 sca=11.3534 scb=0.00879444 scc=0.000426483
M297 (VDD C1 52 VDD) g45p1svt l=4.5e-08 w=3.6e-07 ad=5.04e-14 as=5.04e-14 pd=1e-06 ps=1e-06 sa=1.4e-07 sb=1.4e-07 sca=21.3981 scb=0.0224765 scc=0.00127211
M298 (VDD CLK2 39 VDD) g45p1svt l=4.5e-08 w=3.6e-07 ad=5.04e-14 as=5.04e-14 pd=1e-06 ps=1e-06 sa=1.4e-07 sb=1.4e-07 sca=21.3981 scb=0.0224765 scc=0.00127211
M299 (VDD 4 53 VDD) g45p1svt l=4.5e-08 w=3.6e-07 ad=5.04e-14 as=5.04e-14 pd=1e-06 ps=1e-06 sa=1.4e-07 sb=1.4e-07 sca=21.3981 scb=0.0224765 scc=0.00127211
M300 (VDD C2 55 VDD) g45p1svt l=4.5e-08 w=3.6e-07 ad=5.04e-14 as=5.04e-14 pd=1e-06 ps=1e-06 sa=1.4e-07 sb=1.4e-07 sca=21.3981 scb=0.0224765 scc=0.00127211
M301 (10 53 32 VDD) g45p1svt l=4.5e-08 w=1.08e-06 ad=1.512e-13 as=1.512e-13 pd=2.44e-06 ps=2.44e-06 sa=1.4e-07 sb=1.4e-07 sca=11.3534 scb=0.00879444 scc=0.000426483
M302 (VDD C2 118 VDD) g45p1svt l=4.5e-08 w=3.6e-07 ad=5.04e-14 as=5.04e-14 pd=1e-06 ps=1e-06 sa=1.4e-07 sb=1.4e-07 sca=21.3981 scb=0.0224765 scc=0.00127211
M303 (VDD C1 118 VDD) g45p1svt l=4.5e-08 w=3.6e-07 ad=5.04e-14 as=5.04e-14 pd=1e-06 ps=1e-06 sa=1.4e-07 sb=1.4e-07 sca=19.771 scb=0.0212746 scc=0.00126961
M304 (VDD VDD 118 VDD) g45p1svt l=4.5e-08 w=3.6e-07 ad=5.04e-14 as=5.04e-14 pd=1e-06 ps=1e-06 sa=1.4e-07 sb=1.4e-07 sca=19.771 scb=0.0212746 scc=0.00126961
M305 (VDD 118 54 VDD) g45p1svt l=4.5e-08 w=3.6e-07 ad=5.04e-14 as=5.04e-14 pd=1e-06 ps=1e-06 sa=1.4e-07 sb=1.4e-07 sca=19.771 scb=0.0212746 scc=0.00126961
M306 (VDD 55 121 VDD) g45p1svt l=4.5e-08 w=3.6e-07 ad=5.04e-14 as=5.04e-14 pd=1e-06 ps=1e-06 sa=1.4e-07 sb=1.4e-07 sca=21.3981 scb=0.0224765 scc=0.00127211
M307 (27 53 33 VDD) g45p1svt l=4.5e-08 w=1.08e-06 ad=1.512e-13 as=1.512e-13 pd=2.44e-06 ps=2.44e-06 sa=1.4e-07 sb=1.4e-07 sca=11.3534 scb=0.00879444 scc=0.000426483
M308 (VDD 52 121 VDD) g45p1svt l=4.5e-08 w=3.6e-07 ad=5.04e-14 as=5.04e-14 pd=1e-06 ps=1e-06 sa=1.4e-07 sb=1.4e-07 sca=19.771 scb=0.0212746 scc=0.00126961
M309 (VDD 51 121 VDD) g45p1svt l=4.5e-08 w=3.6e-07 ad=5.04e-14 as=5.04e-14 pd=1e-06 ps=1e-06 sa=1.4e-07 sb=1.4e-07 sca=19.771 scb=0.0212746 scc=0.00126961
M310 (VDD 121 3 VDD) g45p1svt l=4.5e-08 w=3.6e-07 ad=5.04e-14 as=5.04e-14 pd=1e-06 ps=1e-06 sa=1.4e-07 sb=1.4e-07 sca=19.771 scb=0.0212746 scc=0.00126961
M311 (VDD 54 57 VDD) g45p1svt l=4.5e-08 w=3.6e-07 ad=5.04e-14 as=5.04e-14 pd=1e-06 ps=1e-06 sa=1.4e-07 sb=1.4e-07 sca=21.3981 scb=0.0224765 scc=0.00127211
M312 (VDD 5 56 VDD) g45p1svt l=4.5e-08 w=3.6e-07 ad=5.04e-14 as=5.04e-14 pd=1e-06 ps=1e-06 sa=1.4e-07 sb=1.4e-07 sca=21.3981 scb=0.0224765 scc=0.00127211
M313 (VDD 55 127 VDD) g45p1svt l=4.5e-08 w=3.6e-07 ad=5.04e-14 as=5.04e-14 pd=1e-06 ps=1e-06 sa=1.4e-07 sb=1.4e-07 sca=21.3981 scb=0.0224765 scc=0.00127211
M314 (VDD WR 124 VDD) g45p1svt l=4.5e-08 w=3.6e-07 ad=5.04e-14 as=5.04e-14 pd=1e-06 ps=1e-06 sa=1.4e-07 sb=1.4e-07 sca=21.3981 scb=0.0224765 scc=0.00127211
M315 (VDD 52 127 VDD) g45p1svt l=4.5e-08 w=3.6e-07 ad=5.04e-14 as=5.04e-14 pd=1e-06 ps=1e-06 sa=1.4e-07 sb=1.4e-07 sca=19.771 scb=0.0212746 scc=0.00126961
M316 (11 56 32 VDD) g45p1svt l=4.5e-08 w=1.08e-06 ad=1.512e-13 as=1.512e-13 pd=2.44e-06 ps=2.44e-06 sa=1.4e-07 sb=1.4e-07 sca=11.3534 scb=0.00879444 scc=0.000426483
M317 (VDD 49 124 VDD) g45p1svt l=4.5e-08 w=3.6e-07 ad=5.04e-14 as=5.04e-14 pd=1e-06 ps=1e-06 sa=1.4e-07 sb=1.4e-07 sca=19.771 scb=0.0212746 scc=0.00126961
M318 (VDD C0 127 VDD) g45p1svt l=4.5e-08 w=3.6e-07 ad=5.04e-14 as=5.04e-14 pd=1e-06 ps=1e-06 sa=1.4e-07 sb=1.4e-07 sca=19.771 scb=0.0212746 scc=0.00126961
M319 (VDD CLK1 124 VDD) g45p1svt l=4.5e-08 w=3.6e-07 ad=5.04e-14 as=5.04e-14 pd=1e-06 ps=1e-06 sa=1.4e-07 sb=1.4e-07 sca=19.771 scb=0.0212746 scc=0.00126961
M320 (VDD 127 4 VDD) g45p1svt l=4.5e-08 w=3.6e-07 ad=5.04e-14 as=5.04e-14 pd=1e-06 ps=1e-06 sa=1.4e-07 sb=1.4e-07 sca=19.771 scb=0.0212746 scc=0.00126961
M321 (VDD 124 58 VDD) g45p1svt l=4.5e-08 w=3.6e-07 ad=5.04e-14 as=5.04e-14 pd=1e-06 ps=1e-06 sa=1.4e-07 sb=1.4e-07 sca=19.771 scb=0.0212746 scc=0.00126961
M322 (28 56 33 VDD) g45p1svt l=4.5e-08 w=1.08e-06 ad=1.512e-13 as=1.512e-13 pd=2.44e-06 ps=2.44e-06 sa=1.4e-07 sb=1.4e-07 sca=11.3534 scb=0.00879444 scc=0.000426483
M323 (VDD 55 133 VDD) g45p1svt l=4.5e-08 w=3.6e-07 ad=5.04e-14 as=5.04e-14 pd=1e-06 ps=1e-06 sa=1.4e-07 sb=1.4e-07 sca=21.3981 scb=0.0224765 scc=0.00127211
M324 (VDD RD 130 VDD) g45p1svt l=4.5e-08 w=3.6e-07 ad=5.04e-14 as=5.04e-14 pd=1e-06 ps=1e-06 sa=1.4e-07 sb=1.4e-07 sca=21.3981 scb=0.0224765 scc=0.00127211
M325 (VDD C1 133 VDD) g45p1svt l=4.5e-08 w=3.6e-07 ad=5.04e-14 as=5.04e-14 pd=1e-06 ps=1e-06 sa=1.4e-07 sb=1.4e-07 sca=19.771 scb=0.0212746 scc=0.00126961
M326 (VDD 50 130 VDD) g45p1svt l=4.5e-08 w=3.6e-07 ad=5.04e-14 as=5.04e-14 pd=1e-06 ps=1e-06 sa=1.4e-07 sb=1.4e-07 sca=19.771 scb=0.0212746 scc=0.00126961
M327 (VDD 6 60 VDD) g45p1svt l=4.5e-08 w=3.6e-07 ad=5.04e-14 as=5.04e-14 pd=1e-06 ps=1e-06 sa=1.4e-07 sb=1.4e-07 sca=21.3981 scb=0.0224765 scc=0.00127211
M328 (VDD 51 133 VDD) g45p1svt l=4.5e-08 w=3.6e-07 ad=5.04e-14 as=5.04e-14 pd=1e-06 ps=1e-06 sa=1.4e-07 sb=1.4e-07 sca=19.771 scb=0.0212746 scc=0.00126961
M329 (VDD CLK1 130 VDD) g45p1svt l=4.5e-08 w=3.6e-07 ad=5.04e-14 as=5.04e-14 pd=1e-06 ps=1e-06 sa=1.4e-07 sb=1.4e-07 sca=19.771 scb=0.0212746 scc=0.00126961
M330 (VDD 133 5 VDD) g45p1svt l=4.5e-08 w=3.6e-07 ad=5.04e-14 as=5.04e-14 pd=1e-06 ps=1e-06 sa=1.4e-07 sb=1.4e-07 sca=19.771 scb=0.0212746 scc=0.00126961
M331 (VDD 130 59 VDD) g45p1svt l=4.5e-08 w=3.6e-07 ad=5.04e-14 as=5.04e-14 pd=1e-06 ps=1e-06 sa=1.4e-07 sb=1.4e-07 sca=19.771 scb=0.0212746 scc=0.00126961
M332 (12 60 32 VDD) g45p1svt l=4.5e-08 w=1.08e-06 ad=1.512e-13 as=1.512e-13 pd=2.44e-06 ps=2.44e-06 sa=1.4e-07 sb=1.4e-07 sca=11.3534 scb=0.00879444 scc=0.000426483
M333 (VDD 55 139 VDD) g45p1svt l=4.5e-08 w=3.6e-07 ad=5.04e-14 as=5.04e-14 pd=1e-06 ps=1e-06 sa=1.4e-07 sb=1.4e-07 sca=21.3981 scb=0.0224765 scc=0.00127211
M334 (VDD 58 136 VDD) g45p1svt l=4.5e-08 w=3.6e-07 ad=5.04e-14 as=5.04e-14 pd=1e-06 ps=1e-06 sa=1.4e-07 sb=1.4e-07 sca=21.3981 scb=0.0224765 scc=0.00127211
M335 (VDD C1 139 VDD) g45p1svt l=4.5e-08 w=3.6e-07 ad=5.04e-14 as=5.04e-14 pd=1e-06 ps=1e-06 sa=1.4e-07 sb=1.4e-07 sca=19.771 scb=0.0212746 scc=0.00126961
M336 (VDD 57 136 VDD) g45p1svt l=4.5e-08 w=3.6e-07 ad=5.04e-14 as=5.04e-14 pd=1e-06 ps=1e-06 sa=1.4e-07 sb=1.4e-07 sca=19.771 scb=0.0212746 scc=0.00126961
M337 (VDD C0 139 VDD) g45p1svt l=4.5e-08 w=3.6e-07 ad=5.04e-14 as=5.04e-14 pd=1e-06 ps=1e-06 sa=1.4e-07 sb=1.4e-07 sca=19.771 scb=0.0212746 scc=0.00126961
M338 (VDD 39 136 VDD) g45p1svt l=4.5e-08 w=3.6e-07 ad=5.04e-14 as=5.04e-14 pd=1e-06 ps=1e-06 sa=1.4e-07 sb=1.4e-07 sca=19.771 scb=0.0212746 scc=0.00126961
M339 (VDD 139 6 VDD) g45p1svt l=4.5e-08 w=3.6e-07 ad=5.04e-14 as=5.04e-14 pd=1e-06 ps=1e-06 sa=1.4e-07 sb=1.4e-07 sca=19.771 scb=0.0212746 scc=0.00126961
M340 (VDD 136 34 VDD) g45p1svt l=4.5e-08 w=3.6e-07 ad=5.04e-14 as=5.04e-14 pd=1e-06 ps=1e-06 sa=1.4e-07 sb=1.4e-07 sca=19.771 scb=0.0212746 scc=0.00126961
M341 (29 60 33 VDD) g45p1svt l=4.5e-08 w=1.08e-06 ad=1.512e-13 as=1.512e-13 pd=2.44e-06 ps=2.44e-06 sa=1.4e-07 sb=1.4e-07 sca=11.3534 scb=0.00879444 scc=0.000426483
M342 (VDD 7 61 VDD) g45p1svt l=4.5e-08 w=3.6e-07 ad=5.04e-14 as=5.04e-14 pd=1e-06 ps=1e-06 sa=1.4e-07 sb=1.4e-07 sca=21.3981 scb=0.0224765 scc=0.00127211
M343 (VDD C2 145 VDD) g45p1svt l=4.5e-08 w=3.6e-07 ad=5.04e-14 as=5.04e-14 pd=1e-06 ps=1e-06 sa=1.4e-07 sb=1.4e-07 sca=21.3981 scb=0.0224765 scc=0.00127211
M344 (VDD 59 142 VDD) g45p1svt l=4.5e-08 w=3.6e-07 ad=5.04e-14 as=5.04e-14 pd=1e-06 ps=1e-06 sa=1.4e-07 sb=1.4e-07 sca=21.3981 scb=0.0224765 scc=0.00127211
M345 (VDD 52 145 VDD) g45p1svt l=4.5e-08 w=3.6e-07 ad=5.04e-14 as=5.04e-14 pd=1e-06 ps=1e-06 sa=1.4e-07 sb=1.4e-07 sca=19.771 scb=0.0212746 scc=0.00126961
M346 (VDD 57 142 VDD) g45p1svt l=4.5e-08 w=3.6e-07 ad=5.04e-14 as=5.04e-14 pd=1e-06 ps=1e-06 sa=1.4e-07 sb=1.4e-07 sca=19.771 scb=0.0212746 scc=0.00126961
M347 (VDD 51 145 VDD) g45p1svt l=4.5e-08 w=3.6e-07 ad=5.04e-14 as=5.04e-14 pd=1e-06 ps=1e-06 sa=1.4e-07 sb=1.4e-07 sca=19.771 scb=0.0212746 scc=0.00126961
M348 (VDD 39 142 VDD) g45p1svt l=4.5e-08 w=3.6e-07 ad=5.04e-14 as=5.04e-14 pd=1e-06 ps=1e-06 sa=1.4e-07 sb=1.4e-07 sca=19.771 scb=0.0212746 scc=0.00126961
M349 (VDD 145 7 VDD) g45p1svt l=4.5e-08 w=3.6e-07 ad=5.04e-14 as=5.04e-14 pd=1e-06 ps=1e-06 sa=1.4e-07 sb=1.4e-07 sca=19.771 scb=0.0212746 scc=0.00126961
M350 (VDD 142 36 VDD) g45p1svt l=4.5e-08 w=3.6e-07 ad=5.04e-14 as=5.04e-14 pd=1e-06 ps=1e-06 sa=1.4e-07 sb=1.4e-07 sca=19.771 scb=0.0212746 scc=0.00126961
M351 (13 61 32 VDD) g45p1svt l=4.5e-08 w=1.08e-06 ad=1.512e-13 as=1.512e-13 pd=2.44e-06 ps=2.44e-06 sa=1.4e-07 sb=1.4e-07 sca=11.3534 scb=0.00879444 scc=0.000426483
M352 (VDD 34 35 VDD) g45p1svt l=4.5e-08 w=3.6e-07 ad=5.04e-14 as=5.04e-14 pd=1e-06 ps=1e-06 sa=1.4e-07 sb=1.4e-07 sca=21.3981 scb=0.0224765 scc=0.00127211
M353 (VDD C2 148 VDD) g45p1svt l=4.5e-08 w=3.6e-07 ad=5.04e-14 as=5.04e-14 pd=1e-06 ps=1e-06 sa=1.4e-07 sb=1.4e-07 sca=21.3981 scb=0.0224765 scc=0.00127211
M354 (30 61 33 VDD) g45p1svt l=4.5e-08 w=1.08e-06 ad=1.512e-13 as=1.512e-13 pd=2.44e-06 ps=2.44e-06 sa=1.4e-07 sb=1.4e-07 sca=11.3534 scb=0.00879444 scc=0.000426483
M355 (VDD 52 148 VDD) g45p1svt l=4.5e-08 w=3.6e-07 ad=5.04e-14 as=5.04e-14 pd=1e-06 ps=1e-06 sa=1.4e-07 sb=1.4e-07 sca=19.771 scb=0.0212746 scc=0.00126961
M356 (VDD C0 148 VDD) g45p1svt l=4.5e-08 w=3.6e-07 ad=5.04e-14 as=5.04e-14 pd=1e-06 ps=1e-06 sa=1.4e-07 sb=1.4e-07 sca=19.771 scb=0.0212746 scc=0.00126961
M357 (VDD 148 8 VDD) g45p1svt l=4.5e-08 w=3.6e-07 ad=5.04e-14 as=5.04e-14 pd=1e-06 ps=1e-06 sa=1.4e-07 sb=1.4e-07 sca=19.771 scb=0.0212746 scc=0.00126961
M358 (VDD 36 37 VDD) g45p1svt l=4.5e-08 w=3.6e-07 ad=5.04e-14 as=5.04e-14 pd=1e-06 ps=1e-06 sa=1.4e-07 sb=1.4e-07 sca=21.3981 scb=0.0224765 scc=0.00127211
M359 (VDD 8 62 VDD) g45p1svt l=4.5e-08 w=3.6e-07 ad=5.04e-14 as=5.04e-14 pd=1e-06 ps=1e-06 sa=1.4e-07 sb=1.4e-07 sca=21.3981 scb=0.0224765 scc=0.00127211
M360 (VDD 35 151 VDD) g45p1svt l=4.5e-08 w=3.6e-07 ad=5.04e-14 as=5.04e-14 pd=1e-06 ps=1e-06 sa=1.4e-07 sb=1.4e-07 sca=21.3981 scb=0.0224765 scc=0.00127211
M361 (25 62 32 VDD) g45p1svt l=4.5e-08 w=1.08e-06 ad=1.512e-13 as=1.512e-13 pd=2.44e-06 ps=2.44e-06 sa=1.4e-07 sb=1.4e-07 sca=11.3534 scb=0.00879444 scc=0.000426483
M362 (VDD 37 151 VDD) g45p1svt l=4.5e-08 w=3.6e-07 ad=5.04e-14 as=5.04e-14 pd=1e-06 ps=1e-06 sa=1.4e-07 sb=1.4e-07 sca=19.771 scb=0.0212746 scc=0.00126961
M363 (VDD VDD 151 VDD) g45p1svt l=4.5e-08 w=3.6e-07 ad=5.04e-14 as=5.04e-14 pd=1e-06 ps=1e-06 sa=1.4e-07 sb=1.4e-07 sca=19.771 scb=0.0212746 scc=0.00126961
M364 (VDD 151 63 VDD) g45p1svt l=4.5e-08 w=3.6e-07 ad=5.04e-14 as=5.04e-14 pd=1e-06 ps=1e-06 sa=1.4e-07 sb=1.4e-07 sca=19.771 scb=0.0212746 scc=0.00126961
M365 (VDD R0 64 VDD) g45p1svt l=4.5e-08 w=3.6e-07 ad=5.04e-14 as=5.04e-14 pd=1e-06 ps=1e-06 sa=1.4e-07 sb=1.4e-07 sca=21.3981 scb=0.0224765 scc=0.00127211
M366 (31 62 33 VDD) g45p1svt l=4.5e-08 w=1.08e-06 ad=1.512e-13 as=1.512e-13 pd=2.44e-06 ps=2.44e-06 sa=1.4e-07 sb=1.4e-07 sca=11.3534 scb=0.00879444 scc=0.000426483
M367 (VDD 63 38 VDD) g45p1svt l=4.5e-08 w=3.6e-07 ad=5.04e-14 as=5.04e-14 pd=1e-06 ps=1e-06 sa=1.4e-07 sb=1.4e-07 sca=21.3981 scb=0.0224765 scc=0.00127211
M368 (VDD R1 65 VDD) g45p1svt l=4.5e-08 w=3.6e-07 ad=5.04e-14 as=5.04e-14 pd=1e-06 ps=1e-06 sa=1.4e-07 sb=1.4e-07 sca=21.3981 scb=0.0224765 scc=0.00127211
M369 (VDD 65 154 VDD) g45p1svt l=4.5e-08 w=3.6e-07 ad=5.04e-14 as=5.04e-14 pd=1e-06 ps=1e-06 sa=1.4e-07 sb=1.4e-07 sca=21.3981 scb=0.0224765 scc=0.00127211
M370 (VDD 64 154 VDD) g45p1svt l=4.5e-08 w=3.6e-07 ad=5.04e-14 as=5.04e-14 pd=1e-06 ps=1e-06 sa=1.4e-07 sb=1.4e-07 sca=19.771 scb=0.0212746 scc=0.00126961
M371 (VDD 38 154 VDD) g45p1svt l=4.5e-08 w=3.6e-07 ad=5.04e-14 as=5.04e-14 pd=1e-06 ps=1e-06 sa=1.4e-07 sb=1.4e-07 sca=19.771 scb=0.0212746 scc=0.00126961
M372 (VDD 154 40 VDD) g45p1svt l=4.5e-08 w=3.6e-07 ad=5.04e-14 as=5.04e-14 pd=1e-06 ps=1e-06 sa=1.4e-07 sb=1.4e-07 sca=19.771 scb=0.0212746 scc=0.00126961
M373 (VDD 39 9 VDD) g45p1svt l=4.5e-08 w=1.08e-06 ad=1.512e-13 as=1.512e-13 pd=2.44e-06 ps=2.44e-06 sa=1.4e-07 sb=1.4e-07 sca=11.3534 scb=0.00879444 scc=0.000426483
M374 (VDD 39 26 VDD) g45p1svt l=4.5e-08 w=1.08e-06 ad=1.512e-13 as=1.512e-13 pd=2.44e-06 ps=2.44e-06 sa=1.4e-07 sb=1.4e-07 sca=9.72638 scb=0.00759256 scc=0.000423976
M375 (26 39 9 VDD) g45p1svt l=4.5e-08 w=1.08e-06 ad=1.512e-13 as=1.512e-13 pd=2.44e-06 ps=2.44e-06 sa=1.4e-07 sb=1.4e-07 sca=9.72638 scb=0.00759256 scc=0.000423976
M376 (VDD 65 157 VDD) g45p1svt l=4.5e-08 w=3.6e-07 ad=5.04e-14 as=5.04e-14 pd=1e-06 ps=1e-06 sa=1.4e-07 sb=1.4e-07 sca=21.3981 scb=0.0224765 scc=0.00127211
M377 (VDD 70 69 VDD) g45p1svt l=4.5e-08 w=1.2e-07 ad=1.68e-14 as=1.68e-14 pd=5.2e-07 ps=5.2e-07 sa=1.4e-07 sb=1.4e-07 sca=57.0437 scb=0.0528056 scc=0.00752443
M378 (VDD 72 71 VDD) g45p1svt l=4.5e-08 w=1.2e-07 ad=1.68e-14 as=1.68e-14 pd=5.2e-07 ps=5.2e-07 sa=1.4e-07 sb=1.4e-07 sca=57.0437 scb=0.0528056 scc=0.00752443
M379 (VDD 74 73 VDD) g45p1svt l=4.5e-08 w=1.2e-07 ad=1.68e-14 as=1.68e-14 pd=5.2e-07 ps=5.2e-07 sa=1.4e-07 sb=1.4e-07 sca=57.0437 scb=0.0528056 scc=0.00752443
M380 (VDD 76 75 VDD) g45p1svt l=4.5e-08 w=1.2e-07 ad=1.68e-14 as=1.68e-14 pd=5.2e-07 ps=5.2e-07 sa=1.4e-07 sb=1.4e-07 sca=57.0437 scb=0.0528056 scc=0.00752443
M381 (VDD R0 157 VDD) g45p1svt l=4.5e-08 w=3.6e-07 ad=5.04e-14 as=5.04e-14 pd=1e-06 ps=1e-06 sa=1.4e-07 sb=1.4e-07 sca=19.771 scb=0.0212746 scc=0.00126961
M382 (70 69 VDD VDD) g45p1svt l=4.5e-08 w=1.2e-07 ad=1.68e-14 as=1.68e-14 pd=5.2e-07 ps=5.2e-07 sa=1.4e-07 sb=1.4e-07 sca=73.81 scb=0.0749781 scc=0.0101674
M383 (72 71 VDD VDD) g45p1svt l=4.5e-08 w=1.2e-07 ad=1.68e-14 as=1.68e-14 pd=5.2e-07 ps=5.2e-07 sa=1.4e-07 sb=1.4e-07 sca=73.81 scb=0.0749781 scc=0.0101674
M384 (74 73 VDD VDD) g45p1svt l=4.5e-08 w=1.2e-07 ad=1.68e-14 as=1.68e-14 pd=5.2e-07 ps=5.2e-07 sa=1.4e-07 sb=1.4e-07 sca=73.81 scb=0.0749781 scc=0.0101674
M385 (76 75 VDD VDD) g45p1svt l=4.5e-08 w=1.2e-07 ad=1.68e-14 as=1.68e-14 pd=5.2e-07 ps=5.2e-07 sa=1.4e-07 sb=1.4e-07 sca=73.81 scb=0.0749781 scc=0.0101674
M386 (VDD 38 157 VDD) g45p1svt l=4.5e-08 w=3.6e-07 ad=5.04e-14 as=5.04e-14 pd=1e-06 ps=1e-06 sa=1.4e-07 sb=1.4e-07 sca=19.771 scb=0.0212746 scc=0.00126961
M387 (VDD 39 10 VDD) g45p1svt l=4.5e-08 w=1.08e-06 ad=1.512e-13 as=1.512e-13 pd=2.44e-06 ps=2.44e-06 sa=1.4e-07 sb=1.4e-07 sca=11.3534 scb=0.00879444 scc=0.000426483
M388 (VDD 157 41 VDD) g45p1svt l=4.5e-08 w=3.6e-07 ad=5.04e-14 as=5.04e-14 pd=1e-06 ps=1e-06 sa=1.4e-07 sb=1.4e-07 sca=19.771 scb=0.0212746 scc=0.00126961
M389 (VDD 39 27 VDD) g45p1svt l=4.5e-08 w=1.08e-06 ad=1.512e-13 as=1.512e-13 pd=2.44e-06 ps=2.44e-06 sa=1.4e-07 sb=1.4e-07 sca=9.72638 scb=0.00759256 scc=0.000423976
M390 (VDD 78 77 VDD) g45p1svt l=4.5e-08 w=1.2e-07 ad=1.68e-14 as=1.68e-14 pd=5.2e-07 ps=5.2e-07 sa=1.4e-07 sb=1.4e-07 sca=57.0437 scb=0.0528056 scc=0.00752443
M391 (VDD 86 85 VDD) g45p1svt l=4.5e-08 w=1.2e-07 ad=1.68e-14 as=1.68e-14 pd=5.2e-07 ps=5.2e-07 sa=1.4e-07 sb=1.4e-07 sca=57.0437 scb=0.0528056 scc=0.00752443
M392 (VDD 94 93 VDD) g45p1svt l=4.5e-08 w=1.2e-07 ad=1.68e-14 as=1.68e-14 pd=5.2e-07 ps=5.2e-07 sa=1.4e-07 sb=1.4e-07 sca=57.0437 scb=0.0528056 scc=0.00752443
M393 (VDD 102 101 VDD) g45p1svt l=4.5e-08 w=1.2e-07 ad=1.68e-14 as=1.68e-14 pd=5.2e-07 ps=5.2e-07 sa=1.4e-07 sb=1.4e-07 sca=57.0437 scb=0.0528056 scc=0.00752443
M394 (27 39 10 VDD) g45p1svt l=4.5e-08 w=1.08e-06 ad=1.512e-13 as=1.512e-13 pd=2.44e-06 ps=2.44e-06 sa=1.4e-07 sb=1.4e-07 sca=9.72638 scb=0.00759256 scc=0.000423976
M395 (78 77 VDD VDD) g45p1svt l=4.5e-08 w=1.2e-07 ad=1.68e-14 as=1.68e-14 pd=5.2e-07 ps=5.2e-07 sa=1.4e-07 sb=1.4e-07 sca=73.81 scb=0.0749781 scc=0.0101674
M396 (86 85 VDD VDD) g45p1svt l=4.5e-08 w=1.2e-07 ad=1.68e-14 as=1.68e-14 pd=5.2e-07 ps=5.2e-07 sa=1.4e-07 sb=1.4e-07 sca=73.81 scb=0.0749781 scc=0.0101674
M397 (94 93 VDD VDD) g45p1svt l=4.5e-08 w=1.2e-07 ad=1.68e-14 as=1.68e-14 pd=5.2e-07 ps=5.2e-07 sa=1.4e-07 sb=1.4e-07 sca=73.81 scb=0.0749781 scc=0.0101674
M398 (102 101 VDD VDD) g45p1svt l=4.5e-08 w=1.2e-07 ad=1.68e-14 as=1.68e-14 pd=5.2e-07 ps=5.2e-07 sa=1.4e-07 sb=1.4e-07 sca=73.81 scb=0.0749781 scc=0.0101674
M399 (VDD 80 79 VDD) g45p1svt l=4.5e-08 w=1.2e-07 ad=1.68e-14 as=1.68e-14 pd=5.2e-07 ps=5.2e-07 sa=1.4e-07 sb=1.4e-07 sca=57.0437 scb=0.0528056 scc=0.00752443
M400 (VDD 88 87 VDD) g45p1svt l=4.5e-08 w=1.2e-07 ad=1.68e-14 as=1.68e-14 pd=5.2e-07 ps=5.2e-07 sa=1.4e-07 sb=1.4e-07 sca=57.0437 scb=0.0528056 scc=0.00752443
M401 (VDD 96 95 VDD) g45p1svt l=4.5e-08 w=1.2e-07 ad=1.68e-14 as=1.68e-14 pd=5.2e-07 ps=5.2e-07 sa=1.4e-07 sb=1.4e-07 sca=57.0437 scb=0.0528056 scc=0.00752443
M402 (VDD 104 103 VDD) g45p1svt l=4.5e-08 w=1.2e-07 ad=1.68e-14 as=1.68e-14 pd=5.2e-07 ps=5.2e-07 sa=1.4e-07 sb=1.4e-07 sca=57.0437 scb=0.0528056 scc=0.00752443
M403 (80 79 VDD VDD) g45p1svt l=4.5e-08 w=1.2e-07 ad=1.68e-14 as=1.68e-14 pd=5.2e-07 ps=5.2e-07 sa=1.4e-07 sb=1.4e-07 sca=73.81 scb=0.0749781 scc=0.0101674
M404 (88 87 VDD VDD) g45p1svt l=4.5e-08 w=1.2e-07 ad=1.68e-14 as=1.68e-14 pd=5.2e-07 ps=5.2e-07 sa=1.4e-07 sb=1.4e-07 sca=73.81 scb=0.0749781 scc=0.0101674
M405 (96 95 VDD VDD) g45p1svt l=4.5e-08 w=1.2e-07 ad=1.68e-14 as=1.68e-14 pd=5.2e-07 ps=5.2e-07 sa=1.4e-07 sb=1.4e-07 sca=73.81 scb=0.0749781 scc=0.0101674
M406 (104 103 VDD VDD) g45p1svt l=4.5e-08 w=1.2e-07 ad=1.68e-14 as=1.68e-14 pd=5.2e-07 ps=5.2e-07 sa=1.4e-07 sb=1.4e-07 sca=73.81 scb=0.0749781 scc=0.0101674
M407 (VDD 39 11 VDD) g45p1svt l=4.5e-08 w=1.08e-06 ad=1.512e-13 as=1.512e-13 pd=2.44e-06 ps=2.44e-06 sa=1.4e-07 sb=1.4e-07 sca=11.3534 scb=0.00879444 scc=0.000426483
M408 (VDD R1 160 VDD) g45p1svt l=4.5e-08 w=3.6e-07 ad=5.04e-14 as=5.04e-14 pd=1e-06 ps=1e-06 sa=1.4e-07 sb=1.4e-07 sca=21.3981 scb=0.0224765 scc=0.00127211
M409 (VDD 82 81 VDD) g45p1svt l=4.5e-08 w=1.2e-07 ad=1.68e-14 as=1.68e-14 pd=5.2e-07 ps=5.2e-07 sa=1.4e-07 sb=1.4e-07 sca=57.0437 scb=0.0528056 scc=0.00752443
M410 (VDD 90 89 VDD) g45p1svt l=4.5e-08 w=1.2e-07 ad=1.68e-14 as=1.68e-14 pd=5.2e-07 ps=5.2e-07 sa=1.4e-07 sb=1.4e-07 sca=57.0437 scb=0.0528056 scc=0.00752443
M411 (VDD 98 97 VDD) g45p1svt l=4.5e-08 w=1.2e-07 ad=1.68e-14 as=1.68e-14 pd=5.2e-07 ps=5.2e-07 sa=1.4e-07 sb=1.4e-07 sca=57.0437 scb=0.0528056 scc=0.00752443
M412 (VDD 106 105 VDD) g45p1svt l=4.5e-08 w=1.2e-07 ad=1.68e-14 as=1.68e-14 pd=5.2e-07 ps=5.2e-07 sa=1.4e-07 sb=1.4e-07 sca=57.0437 scb=0.0528056 scc=0.00752443
M413 (VDD 39 28 VDD) g45p1svt l=4.5e-08 w=1.08e-06 ad=1.512e-13 as=1.512e-13 pd=2.44e-06 ps=2.44e-06 sa=1.4e-07 sb=1.4e-07 sca=9.72638 scb=0.00759256 scc=0.000423976
M414 (82 81 VDD VDD) g45p1svt l=4.5e-08 w=1.2e-07 ad=1.68e-14 as=1.68e-14 pd=5.2e-07 ps=5.2e-07 sa=1.4e-07 sb=1.4e-07 sca=73.81 scb=0.0749781 scc=0.0101674
M415 (90 89 VDD VDD) g45p1svt l=4.5e-08 w=1.2e-07 ad=1.68e-14 as=1.68e-14 pd=5.2e-07 ps=5.2e-07 sa=1.4e-07 sb=1.4e-07 sca=73.81 scb=0.0749781 scc=0.0101674
M416 (98 97 VDD VDD) g45p1svt l=4.5e-08 w=1.2e-07 ad=1.68e-14 as=1.68e-14 pd=5.2e-07 ps=5.2e-07 sa=1.4e-07 sb=1.4e-07 sca=73.81 scb=0.0749781 scc=0.0101674
M417 (106 105 VDD VDD) g45p1svt l=4.5e-08 w=1.2e-07 ad=1.68e-14 as=1.68e-14 pd=5.2e-07 ps=5.2e-07 sa=1.4e-07 sb=1.4e-07 sca=73.81 scb=0.0749781 scc=0.0101674
M418 (VDD 64 160 VDD) g45p1svt l=4.5e-08 w=3.6e-07 ad=5.04e-14 as=5.04e-14 pd=1e-06 ps=1e-06 sa=1.4e-07 sb=1.4e-07 sca=19.771 scb=0.0212746 scc=0.00126961
M419 (28 39 11 VDD) g45p1svt l=4.5e-08 w=1.08e-06 ad=1.512e-13 as=1.512e-13 pd=2.44e-06 ps=2.44e-06 sa=1.4e-07 sb=1.4e-07 sca=9.72638 scb=0.00759256 scc=0.000423976
M420 (VDD 38 160 VDD) g45p1svt l=4.5e-08 w=3.6e-07 ad=5.04e-14 as=5.04e-14 pd=1e-06 ps=1e-06 sa=1.4e-07 sb=1.4e-07 sca=19.771 scb=0.0212746 scc=0.00126961
M421 (VDD 160 42 VDD) g45p1svt l=4.5e-08 w=3.6e-07 ad=5.04e-14 as=5.04e-14 pd=1e-06 ps=1e-06 sa=1.4e-07 sb=1.4e-07 sca=19.771 scb=0.0212746 scc=0.00126961
M422 (VDD 84 83 VDD) g45p1svt l=4.5e-08 w=1.2e-07 ad=1.68e-14 as=1.68e-14 pd=5.2e-07 ps=5.2e-07 sa=1.4e-07 sb=1.4e-07 sca=57.0437 scb=0.0528056 scc=0.00752443
M423 (VDD 92 91 VDD) g45p1svt l=4.5e-08 w=1.2e-07 ad=1.68e-14 as=1.68e-14 pd=5.2e-07 ps=5.2e-07 sa=1.4e-07 sb=1.4e-07 sca=57.0437 scb=0.0528056 scc=0.00752443
M424 (VDD 100 99 VDD) g45p1svt l=4.5e-08 w=1.2e-07 ad=1.68e-14 as=1.68e-14 pd=5.2e-07 ps=5.2e-07 sa=1.4e-07 sb=1.4e-07 sca=57.0437 scb=0.0528056 scc=0.00752443
M425 (VDD 108 107 VDD) g45p1svt l=4.5e-08 w=1.2e-07 ad=1.68e-14 as=1.68e-14 pd=5.2e-07 ps=5.2e-07 sa=1.4e-07 sb=1.4e-07 sca=57.0437 scb=0.0528056 scc=0.00752443
M426 (84 83 VDD VDD) g45p1svt l=4.5e-08 w=1.2e-07 ad=1.68e-14 as=1.68e-14 pd=5.2e-07 ps=5.2e-07 sa=1.4e-07 sb=1.4e-07 sca=73.81 scb=0.0749781 scc=0.0101674
M427 (92 91 VDD VDD) g45p1svt l=4.5e-08 w=1.2e-07 ad=1.68e-14 as=1.68e-14 pd=5.2e-07 ps=5.2e-07 sa=1.4e-07 sb=1.4e-07 sca=73.81 scb=0.0749781 scc=0.0101674
M428 (100 99 VDD VDD) g45p1svt l=4.5e-08 w=1.2e-07 ad=1.68e-14 as=1.68e-14 pd=5.2e-07 ps=5.2e-07 sa=1.4e-07 sb=1.4e-07 sca=73.81 scb=0.0749781 scc=0.0101674
M429 (108 107 VDD VDD) g45p1svt l=4.5e-08 w=1.2e-07 ad=1.68e-14 as=1.68e-14 pd=5.2e-07 ps=5.2e-07 sa=1.4e-07 sb=1.4e-07 sca=73.81 scb=0.0749781 scc=0.0101674
M430 (VDD 110 109 VDD) g45p1svt l=4.5e-08 w=1.2e-07 ad=1.68e-14 as=1.68e-14 pd=5.2e-07 ps=5.2e-07 sa=1.4e-07 sb=1.4e-07 sca=57.0437 scb=0.0528056 scc=0.00752443
M431 (VDD 112 111 VDD) g45p1svt l=4.5e-08 w=1.2e-07 ad=1.68e-14 as=1.68e-14 pd=5.2e-07 ps=5.2e-07 sa=1.4e-07 sb=1.4e-07 sca=57.0437 scb=0.0528056 scc=0.00752443
M432 (VDD 114 113 VDD) g45p1svt l=4.5e-08 w=1.2e-07 ad=1.68e-14 as=1.68e-14 pd=5.2e-07 ps=5.2e-07 sa=1.4e-07 sb=1.4e-07 sca=57.0437 scb=0.0528056 scc=0.00752443
M433 (VDD 116 115 VDD) g45p1svt l=4.5e-08 w=1.2e-07 ad=1.68e-14 as=1.68e-14 pd=5.2e-07 ps=5.2e-07 sa=1.4e-07 sb=1.4e-07 sca=57.0437 scb=0.0528056 scc=0.00752443
M434 (VDD 39 12 VDD) g45p1svt l=4.5e-08 w=1.08e-06 ad=1.512e-13 as=1.512e-13 pd=2.44e-06 ps=2.44e-06 sa=1.4e-07 sb=1.4e-07 sca=11.3534 scb=0.00879444 scc=0.000426483
M435 (110 109 VDD VDD) g45p1svt l=4.5e-08 w=1.2e-07 ad=1.68e-14 as=1.68e-14 pd=5.2e-07 ps=5.2e-07 sa=1.4e-07 sb=1.4e-07 sca=73.81 scb=0.0749781 scc=0.0101674
M436 (112 111 VDD VDD) g45p1svt l=4.5e-08 w=1.2e-07 ad=1.68e-14 as=1.68e-14 pd=5.2e-07 ps=5.2e-07 sa=1.4e-07 sb=1.4e-07 sca=73.81 scb=0.0749781 scc=0.0101674
M437 (114 113 VDD VDD) g45p1svt l=4.5e-08 w=1.2e-07 ad=1.68e-14 as=1.68e-14 pd=5.2e-07 ps=5.2e-07 sa=1.4e-07 sb=1.4e-07 sca=73.81 scb=0.0749781 scc=0.0101674
M438 (116 115 VDD VDD) g45p1svt l=4.5e-08 w=1.2e-07 ad=1.68e-14 as=1.68e-14 pd=5.2e-07 ps=5.2e-07 sa=1.4e-07 sb=1.4e-07 sca=73.81 scb=0.0749781 scc=0.0101674
M439 (VDD 39 29 VDD) g45p1svt l=4.5e-08 w=1.08e-06 ad=1.512e-13 as=1.512e-13 pd=2.44e-06 ps=2.44e-06 sa=1.4e-07 sb=1.4e-07 sca=9.72638 scb=0.00759256 scc=0.000423976
M440 (29 39 12 VDD) g45p1svt l=4.5e-08 w=1.08e-06 ad=1.512e-13 as=1.512e-13 pd=2.44e-06 ps=2.44e-06 sa=1.4e-07 sb=1.4e-07 sca=9.72638 scb=0.00759256 scc=0.000423976
M441 (VDD R1 163 VDD) g45p1svt l=4.5e-08 w=3.6e-07 ad=5.04e-14 as=5.04e-14 pd=1e-06 ps=1e-06 sa=1.4e-07 sb=1.4e-07 sca=21.3981 scb=0.0224765 scc=0.00127211
M442 (VDD R0 163 VDD) g45p1svt l=4.5e-08 w=3.6e-07 ad=5.04e-14 as=5.04e-14 pd=1e-06 ps=1e-06 sa=1.4e-07 sb=1.4e-07 sca=19.771 scb=0.0212746 scc=0.00126961
M443 (VDD 38 163 VDD) g45p1svt l=4.5e-08 w=3.6e-07 ad=5.04e-14 as=5.04e-14 pd=1e-06 ps=1e-06 sa=1.4e-07 sb=1.4e-07 sca=19.771 scb=0.0212746 scc=0.00126961
M444 (VDD 163 43 VDD) g45p1svt l=4.5e-08 w=3.6e-07 ad=5.04e-14 as=5.04e-14 pd=1e-06 ps=1e-06 sa=1.4e-07 sb=1.4e-07 sca=19.771 scb=0.0212746 scc=0.00126961
M445 (VDD 39 13 VDD) g45p1svt l=4.5e-08 w=1.08e-06 ad=1.512e-13 as=1.512e-13 pd=2.44e-06 ps=2.44e-06 sa=1.4e-07 sb=1.4e-07 sca=11.3534 scb=0.00879444 scc=0.000426483
M446 (VDD 39 30 VDD) g45p1svt l=4.5e-08 w=1.08e-06 ad=1.512e-13 as=1.512e-13 pd=2.44e-06 ps=2.44e-06 sa=1.4e-07 sb=1.4e-07 sca=9.72638 scb=0.00759256 scc=0.000423976
M447 (30 39 13 VDD) g45p1svt l=4.5e-08 w=1.08e-06 ad=1.512e-13 as=1.512e-13 pd=2.44e-06 ps=2.44e-06 sa=1.4e-07 sb=1.4e-07 sca=9.72638 scb=0.00759256 scc=0.000423976
M448 (44 37 66 VDD) g45p1svt l=4.5e-08 w=1.08e-06 ad=1.512e-13 as=1.512e-13 pd=2.44e-06 ps=2.44e-06 sa=1.4e-07 sb=1.4e-07 sca=11.3534 scb=0.00879444 scc=0.000426483
M449 (VDD 66 67 VDD) g45p1svt l=4.5e-08 w=3.6e-07 ad=5.04e-14 as=5.04e-14 pd=1e-06 ps=1e-06 sa=1.4e-07 sb=1.4e-07 sca=21.3981 scb=0.0224765 scc=0.00127211
M450 (VDD 39 25 VDD) g45p1svt l=4.5e-08 w=1.08e-06 ad=1.512e-13 as=1.512e-13 pd=2.44e-06 ps=2.44e-06 sa=1.4e-07 sb=1.4e-07 sca=11.3534 scb=0.00879444 scc=0.000426483
M451 (VDD 39 31 VDD) g45p1svt l=4.5e-08 w=1.08e-06 ad=1.512e-13 as=1.512e-13 pd=2.44e-06 ps=2.44e-06 sa=1.4e-07 sb=1.4e-07 sca=9.72638 scb=0.00759256 scc=0.000423976
M452 (VDD DIN 68 VDD) g45p1svt l=4.5e-08 w=3.6e-07 ad=5.04e-14 as=5.04e-14 pd=1e-06 ps=1e-06 sa=1.4e-07 sb=1.4e-07 sca=21.3981 scb=0.0224765 scc=0.00127211
M453 (31 39 25 VDD) g45p1svt l=4.5e-08 w=1.08e-06 ad=1.512e-13 as=1.512e-13 pd=2.44e-06 ps=2.44e-06 sa=1.4e-07 sb=1.4e-07 sca=9.72638 scb=0.00759256 scc=0.000423976
M454 (VDD 67 DOUT VDD) g45p1svt l=4.5e-08 w=3.6e-07 ad=5.04e-14 as=5.04e-14 pd=1e-06 ps=1e-06 sa=1.4e-07 sb=1.4e-07 sca=21.3981 scb=0.0224765 scc=0.00127211
M455 (DIN 35 32 VDD) g45p1svt l=4.5e-08 w=1.08e-06 ad=1.512e-13 as=1.512e-13 pd=2.44e-06 ps=2.44e-06 sa=1.4e-07 sb=1.4e-07 sca=11.3534 scb=0.00879444 scc=0.000426483
M456 (VDD 47 47 VDD) g45p1svt l=4.5e-08 w=1.44e-06 ad=2.016e-13 as=2.016e-13 pd=3.16e-06 ps=3.16e-06 sa=1.4e-07 sb=1.4e-07 sca=9.63848 scb=0.00691547 scc=0.00032049
M457 (DOUT 36 66 VDD) g45p1svt l=4.5e-08 w=1.08e-06 ad=1.512e-13 as=1.512e-13 pd=2.44e-06 ps=2.44e-06 sa=1.4e-07 sb=1.4e-07 sca=11.3534 scb=0.00879444 scc=0.000426483
M458 (VDD 47 46 VDD) g45p1svt l=4.5e-08 w=1.44e-06 ad=2.016e-13 as=2.016e-13 pd=3.16e-06 ps=3.16e-06 sa=1.4e-07 sb=1.4e-07 sca=8.01144 scb=0.00571359 scc=0.000317983
M459 (VDD 46 44 VDD) g45p1svt l=4.5e-08 w=3.6e-07 ad=5.04e-14 as=5.04e-14 pd=1e-06 ps=1e-06 sa=1.4e-07 sb=1.4e-07 sca=11.5777 scb=0.010688 scc=0.000634804
M460 (68 35 33 VDD) g45p1svt l=4.5e-08 w=1.08e-06 ad=1.512e-13 as=1.512e-13 pd=2.44e-06 ps=2.44e-06 sa=1.4e-07 sb=1.4e-07 sca=11.3534 scb=0.00879444 scc=0.000426483
ends
subckt sram_4x6 (R1 R0 C2 C1 C0 CLK1 CLK2 WR RD DIN DOUT VDD GND)
Xphysical (GND VDD R1 R0 C2 C1 C0 CLK1 CLK2 WR RD DIN DOUT) physical_sram_4x6
ends
