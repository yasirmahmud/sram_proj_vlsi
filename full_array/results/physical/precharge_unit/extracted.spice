* +++++++++++++++++++++++++++++++++++++++++++++++++++++
* CDL Netlist:
*
* Cell Name: precharge_unit
* Netlisted: 2026-11-07 03:30:32
* Pegasus 25.14-s010
* +++++++++++++++++++++++++++++++++++++++++++++++++++++
*.LDD

* +++++++++++++++++++++++++++++++++++++++++++++++++++++
* Sub cell: precharge_unit
* +++++++++++++++++++++++++++++++++++++++++++++++++++++
.subckt precharge_unit GND VDD PCB BL BLB
M3 VDD PCB BL VDD g45p1svt L=4.5e-08 W=1.08e-06 AD=1.512e-13 AS=1.512e-13 PD=2.44e-06 PS=2.44e-06 fw=1.08e-06 sa=1.4e-07 sb=1.4e-07 sca=11.3534 scb=0.00879444 scc=0.000426483 $X=4700 $Y=3240
M4 VDD PCB BLB VDD g45p1svt L=4.5e-08 W=1.08e-06 AD=1.512e-13 AS=1.512e-13 PD=2.44e-06 PS=2.44e-06 fw=1.08e-06 sa=1.4e-07 sb=1.4e-07 sca=9.72638 scb=0.00759256 scc=0.000423976 $X=6100 $Y=3240
M5 BLB PCB BL VDD g45p1svt L=4.5e-08 W=1.08e-06 AD=1.512e-13 AS=1.512e-13 PD=2.44e-06 PS=2.44e-06 fw=1.08e-06 sa=1.4e-07 sb=1.4e-07 sca=9.72638 scb=0.00759256 scc=0.000423976 $X=7500 $Y=3240
** N=5 EP=5 NDC=3 FDC=3 HDC=3
.ends precharge_unit
