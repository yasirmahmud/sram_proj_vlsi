* +++++++++++++++++++++++++++++++++++++++++++++++++++++
* CDL Netlist:
*
* Cell Name: bit_array
* Netlisted: 2026-11-07 03:33:36
* Pegasus 25.14-s010
* +++++++++++++++++++++++++++++++++++++++++++++++++++++
*.LDD

* +++++++++++++++++++++++++++++++++++++++++++++++++++++
* Sub cell: bit_array
* +++++++++++++++++++++++++++++++++++++++++++++++++++++
.subckt bit_array GND WL0 BLB0 BL0 VDD WL1 WL2 WL3 BL1 BL2
+ BL3 BL4 BL5 BLB1 BLB2 BLB3 BLB4 BLB5
M24 BLB0 WL0 19 GND g45n1svt L=4.5e-08 W=2.4e-07 AD=3.36e-14 AS=3.36e-14 PD=7.6e-07 PS=7.6e-07 fw=2.4e-07 sa=1.4e-07 sb=1.4e-07 sca=9.45211 scb=0.00821004 scc=0.000286958 $X=13050 $Y=2160
M25 BLB0 WL1 21 GND g45n1svt L=4.5e-08 W=2.4e-07 AD=3.36e-14 AS=3.36e-14 PD=7.6e-07 PS=7.6e-07 fw=2.4e-07 sa=1.4e-07 sb=1.4e-07 sca=9.45211 scb=0.00821004 scc=0.000286958 $X=13050 $Y=6200
M26 BLB0 WL2 23 GND g45n1svt L=4.5e-08 W=2.4e-07 AD=3.36e-14 AS=3.36e-14 PD=7.6e-07 PS=7.6e-07 fw=2.4e-07 sa=1.4e-07 sb=1.4e-07 sca=9.45211 scb=0.00821004 scc=0.000286958 $X=13050 $Y=10240
M27 BLB0 WL3 25 GND g45n1svt L=4.5e-08 W=2.4e-07 AD=3.36e-14 AS=3.36e-14 PD=7.6e-07 PS=7.6e-07 fw=2.4e-07 sa=1.4e-07 sb=1.4e-07 sca=9.45211 scb=0.00821004 scc=0.000286958 $X=13050 $Y=14280
M28 GND 20 19 GND g45n1svt L=4.5e-08 W=3.6e-07 AD=5.04e-14 AS=5.04e-14 PD=1e-06 PS=1e-06 fw=3.6e-07 sa=1.4e-07 sb=1.4e-07 sca=5.75838 scb=0.0022385 scc=1.60319e-05 $X=14220 $Y=1620
M29 GND 22 21 GND g45n1svt L=4.5e-08 W=3.6e-07 AD=5.04e-14 AS=5.04e-14 PD=1e-06 PS=1e-06 fw=3.6e-07 sa=1.4e-07 sb=1.4e-07 sca=6.05657 scb=0.00229265 scc=1.60407e-05 $X=14220 $Y=5660
M30 GND 24 23 GND g45n1svt L=4.5e-08 W=3.6e-07 AD=5.04e-14 AS=5.04e-14 PD=1e-06 PS=1e-06 fw=3.6e-07 sa=1.4e-07 sb=1.4e-07 sca=6.05657 scb=0.00229265 scc=1.60407e-05 $X=14220 $Y=9700
M31 GND 26 25 GND g45n1svt L=4.5e-08 W=3.6e-07 AD=5.04e-14 AS=5.04e-14 PD=1e-06 PS=1e-06 fw=3.6e-07 sa=1.4e-07 sb=1.4e-07 sca=6.05657 scb=0.00229265 scc=1.60407e-05 $X=14220 $Y=13740
M32 GND 19 20 GND g45n1svt L=4.5e-08 W=3.6e-07 AD=5.04e-14 AS=5.04e-14 PD=1e-06 PS=1e-06 fw=3.6e-07 sa=1.4e-07 sb=1.4e-07 sca=5.75838 scb=0.0022385 scc=1.60319e-05 $X=15250 $Y=1620
M33 GND 21 22 GND g45n1svt L=4.5e-08 W=3.6e-07 AD=5.04e-14 AS=5.04e-14 PD=1e-06 PS=1e-06 fw=3.6e-07 sa=1.4e-07 sb=1.4e-07 sca=6.05657 scb=0.00229265 scc=1.60407e-05 $X=15250 $Y=5660
M34 GND 23 24 GND g45n1svt L=4.5e-08 W=3.6e-07 AD=5.04e-14 AS=5.04e-14 PD=1e-06 PS=1e-06 fw=3.6e-07 sa=1.4e-07 sb=1.4e-07 sca=6.05657 scb=0.00229265 scc=1.60407e-05 $X=15250 $Y=9700
M35 GND 25 26 GND g45n1svt L=4.5e-08 W=3.6e-07 AD=5.04e-14 AS=5.04e-14 PD=1e-06 PS=1e-06 fw=3.6e-07 sa=1.4e-07 sb=1.4e-07 sca=6.05657 scb=0.00229265 scc=1.60407e-05 $X=15250 $Y=13740
M36 20 WL0 BL0 GND g45n1svt L=4.5e-08 W=2.4e-07 AD=3.36e-14 AS=3.36e-14 PD=7.6e-07 PS=7.6e-07 fw=2.4e-07 sa=1.4e-07 sb=1.4e-07 sca=6.50517 scb=0.00415999 scc=0.000152707 $X=16340 $Y=2830
M37 22 WL1 BL0 GND g45n1svt L=4.5e-08 W=2.4e-07 AD=3.36e-14 AS=3.36e-14 PD=7.6e-07 PS=7.6e-07 fw=2.4e-07 sa=1.4e-07 sb=1.4e-07 sca=6.50517 scb=0.00415999 scc=0.000152707 $X=16340 $Y=6870
M38 24 WL2 BL0 GND g45n1svt L=4.5e-08 W=2.4e-07 AD=3.36e-14 AS=3.36e-14 PD=7.6e-07 PS=7.6e-07 fw=2.4e-07 sa=1.4e-07 sb=1.4e-07 sca=6.50517 scb=0.00415999 scc=0.000152707 $X=16340 $Y=10910
M39 26 WL3 BL0 GND g45n1svt L=4.5e-08 W=2.4e-07 AD=3.36e-14 AS=3.36e-14 PD=7.6e-07 PS=7.6e-07 fw=2.4e-07 sa=1.4e-07 sb=1.4e-07 sca=6.50517 scb=0.00415999 scc=0.000152707 $X=16340 $Y=14950
M40 BLB1 WL0 27 GND g45n1svt L=4.5e-08 W=2.4e-07 AD=3.36e-14 AS=3.36e-14 PD=7.6e-07 PS=7.6e-07 fw=2.4e-07 sa=1.4e-07 sb=1.4e-07 sca=9.45211 scb=0.00821004 scc=0.000286958 $X=17650 $Y=2160
M41 BLB1 WL1 35 GND g45n1svt L=4.5e-08 W=2.4e-07 AD=3.36e-14 AS=3.36e-14 PD=7.6e-07 PS=7.6e-07 fw=2.4e-07 sa=1.4e-07 sb=1.4e-07 sca=9.45211 scb=0.00821004 scc=0.000286958 $X=17650 $Y=6200
M42 BLB1 WL2 43 GND g45n1svt L=4.5e-08 W=2.4e-07 AD=3.36e-14 AS=3.36e-14 PD=7.6e-07 PS=7.6e-07 fw=2.4e-07 sa=1.4e-07 sb=1.4e-07 sca=9.45211 scb=0.00821004 scc=0.000286958 $X=17650 $Y=10240
M43 BLB1 WL3 51 GND g45n1svt L=4.5e-08 W=2.4e-07 AD=3.36e-14 AS=3.36e-14 PD=7.6e-07 PS=7.6e-07 fw=2.4e-07 sa=1.4e-07 sb=1.4e-07 sca=9.45211 scb=0.00821004 scc=0.000286958 $X=17650 $Y=14280
M44 GND 28 27 GND g45n1svt L=4.5e-08 W=3.6e-07 AD=5.04e-14 AS=5.04e-14 PD=1e-06 PS=1e-06 fw=3.6e-07 sa=1.4e-07 sb=1.4e-07 sca=5.75838 scb=0.0022385 scc=1.60319e-05 $X=18820 $Y=1620
M45 GND 36 35 GND g45n1svt L=4.5e-08 W=3.6e-07 AD=5.04e-14 AS=5.04e-14 PD=1e-06 PS=1e-06 fw=3.6e-07 sa=1.4e-07 sb=1.4e-07 sca=6.05657 scb=0.00229265 scc=1.60407e-05 $X=18820 $Y=5660
M46 GND 44 43 GND g45n1svt L=4.5e-08 W=3.6e-07 AD=5.04e-14 AS=5.04e-14 PD=1e-06 PS=1e-06 fw=3.6e-07 sa=1.4e-07 sb=1.4e-07 sca=6.05657 scb=0.00229265 scc=1.60407e-05 $X=18820 $Y=9700
M47 GND 52 51 GND g45n1svt L=4.5e-08 W=3.6e-07 AD=5.04e-14 AS=5.04e-14 PD=1e-06 PS=1e-06 fw=3.6e-07 sa=1.4e-07 sb=1.4e-07 sca=6.05657 scb=0.00229265 scc=1.60407e-05 $X=18820 $Y=13740
M48 GND 27 28 GND g45n1svt L=4.5e-08 W=3.6e-07 AD=5.04e-14 AS=5.04e-14 PD=1e-06 PS=1e-06 fw=3.6e-07 sa=1.4e-07 sb=1.4e-07 sca=5.75838 scb=0.0022385 scc=1.60319e-05 $X=19850 $Y=1620
M49 GND 35 36 GND g45n1svt L=4.5e-08 W=3.6e-07 AD=5.04e-14 AS=5.04e-14 PD=1e-06 PS=1e-06 fw=3.6e-07 sa=1.4e-07 sb=1.4e-07 sca=6.05657 scb=0.00229265 scc=1.60407e-05 $X=19850 $Y=5660
M50 GND 43 44 GND g45n1svt L=4.5e-08 W=3.6e-07 AD=5.04e-14 AS=5.04e-14 PD=1e-06 PS=1e-06 fw=3.6e-07 sa=1.4e-07 sb=1.4e-07 sca=6.05657 scb=0.00229265 scc=1.60407e-05 $X=19850 $Y=9700
M51 GND 51 52 GND g45n1svt L=4.5e-08 W=3.6e-07 AD=5.04e-14 AS=5.04e-14 PD=1e-06 PS=1e-06 fw=3.6e-07 sa=1.4e-07 sb=1.4e-07 sca=6.05657 scb=0.00229265 scc=1.60407e-05 $X=19850 $Y=13740
M52 28 WL0 BL1 GND g45n1svt L=4.5e-08 W=2.4e-07 AD=3.36e-14 AS=3.36e-14 PD=7.6e-07 PS=7.6e-07 fw=2.4e-07 sa=1.4e-07 sb=1.4e-07 sca=6.50517 scb=0.00415999 scc=0.000152707 $X=20940 $Y=2830
M53 36 WL1 BL1 GND g45n1svt L=4.5e-08 W=2.4e-07 AD=3.36e-14 AS=3.36e-14 PD=7.6e-07 PS=7.6e-07 fw=2.4e-07 sa=1.4e-07 sb=1.4e-07 sca=6.50517 scb=0.00415999 scc=0.000152707 $X=20940 $Y=6870
M54 44 WL2 BL1 GND g45n1svt L=4.5e-08 W=2.4e-07 AD=3.36e-14 AS=3.36e-14 PD=7.6e-07 PS=7.6e-07 fw=2.4e-07 sa=1.4e-07 sb=1.4e-07 sca=6.50517 scb=0.00415999 scc=0.000152707 $X=20940 $Y=10910
M55 52 WL3 BL1 GND g45n1svt L=4.5e-08 W=2.4e-07 AD=3.36e-14 AS=3.36e-14 PD=7.6e-07 PS=7.6e-07 fw=2.4e-07 sa=1.4e-07 sb=1.4e-07 sca=6.50517 scb=0.00415999 scc=0.000152707 $X=20940 $Y=14950
M56 BLB2 WL0 29 GND g45n1svt L=4.5e-08 W=2.4e-07 AD=3.36e-14 AS=3.36e-14 PD=7.6e-07 PS=7.6e-07 fw=2.4e-07 sa=1.4e-07 sb=1.4e-07 sca=9.45211 scb=0.00821004 scc=0.000286958 $X=22250 $Y=2160
M57 BLB2 WL1 37 GND g45n1svt L=4.5e-08 W=2.4e-07 AD=3.36e-14 AS=3.36e-14 PD=7.6e-07 PS=7.6e-07 fw=2.4e-07 sa=1.4e-07 sb=1.4e-07 sca=9.45211 scb=0.00821004 scc=0.000286958 $X=22250 $Y=6200
M58 BLB2 WL2 45 GND g45n1svt L=4.5e-08 W=2.4e-07 AD=3.36e-14 AS=3.36e-14 PD=7.6e-07 PS=7.6e-07 fw=2.4e-07 sa=1.4e-07 sb=1.4e-07 sca=9.45211 scb=0.00821004 scc=0.000286958 $X=22250 $Y=10240
M59 BLB2 WL3 53 GND g45n1svt L=4.5e-08 W=2.4e-07 AD=3.36e-14 AS=3.36e-14 PD=7.6e-07 PS=7.6e-07 fw=2.4e-07 sa=1.4e-07 sb=1.4e-07 sca=9.45211 scb=0.00821004 scc=0.000286958 $X=22250 $Y=14280
M60 GND 30 29 GND g45n1svt L=4.5e-08 W=3.6e-07 AD=5.04e-14 AS=5.04e-14 PD=1e-06 PS=1e-06 fw=3.6e-07 sa=1.4e-07 sb=1.4e-07 sca=5.75838 scb=0.0022385 scc=1.60319e-05 $X=23420 $Y=1620
M61 GND 38 37 GND g45n1svt L=4.5e-08 W=3.6e-07 AD=5.04e-14 AS=5.04e-14 PD=1e-06 PS=1e-06 fw=3.6e-07 sa=1.4e-07 sb=1.4e-07 sca=6.05657 scb=0.00229265 scc=1.60407e-05 $X=23420 $Y=5660
M62 GND 46 45 GND g45n1svt L=4.5e-08 W=3.6e-07 AD=5.04e-14 AS=5.04e-14 PD=1e-06 PS=1e-06 fw=3.6e-07 sa=1.4e-07 sb=1.4e-07 sca=6.05657 scb=0.00229265 scc=1.60407e-05 $X=23420 $Y=9700
M63 GND 54 53 GND g45n1svt L=4.5e-08 W=3.6e-07 AD=5.04e-14 AS=5.04e-14 PD=1e-06 PS=1e-06 fw=3.6e-07 sa=1.4e-07 sb=1.4e-07 sca=6.05657 scb=0.00229265 scc=1.60407e-05 $X=23420 $Y=13740
M64 GND 29 30 GND g45n1svt L=4.5e-08 W=3.6e-07 AD=5.04e-14 AS=5.04e-14 PD=1e-06 PS=1e-06 fw=3.6e-07 sa=1.4e-07 sb=1.4e-07 sca=5.75838 scb=0.0022385 scc=1.60319e-05 $X=24450 $Y=1620
M65 GND 37 38 GND g45n1svt L=4.5e-08 W=3.6e-07 AD=5.04e-14 AS=5.04e-14 PD=1e-06 PS=1e-06 fw=3.6e-07 sa=1.4e-07 sb=1.4e-07 sca=6.05657 scb=0.00229265 scc=1.60407e-05 $X=24450 $Y=5660
M66 GND 45 46 GND g45n1svt L=4.5e-08 W=3.6e-07 AD=5.04e-14 AS=5.04e-14 PD=1e-06 PS=1e-06 fw=3.6e-07 sa=1.4e-07 sb=1.4e-07 sca=6.05657 scb=0.00229265 scc=1.60407e-05 $X=24450 $Y=9700
M67 GND 53 54 GND g45n1svt L=4.5e-08 W=3.6e-07 AD=5.04e-14 AS=5.04e-14 PD=1e-06 PS=1e-06 fw=3.6e-07 sa=1.4e-07 sb=1.4e-07 sca=6.05657 scb=0.00229265 scc=1.60407e-05 $X=24450 $Y=13740
M68 30 WL0 BL2 GND g45n1svt L=4.5e-08 W=2.4e-07 AD=3.36e-14 AS=3.36e-14 PD=7.6e-07 PS=7.6e-07 fw=2.4e-07 sa=1.4e-07 sb=1.4e-07 sca=6.50517 scb=0.00415999 scc=0.000152707 $X=25540 $Y=2830
M69 38 WL1 BL2 GND g45n1svt L=4.5e-08 W=2.4e-07 AD=3.36e-14 AS=3.36e-14 PD=7.6e-07 PS=7.6e-07 fw=2.4e-07 sa=1.4e-07 sb=1.4e-07 sca=6.50517 scb=0.00415999 scc=0.000152707 $X=25540 $Y=6870
M70 46 WL2 BL2 GND g45n1svt L=4.5e-08 W=2.4e-07 AD=3.36e-14 AS=3.36e-14 PD=7.6e-07 PS=7.6e-07 fw=2.4e-07 sa=1.4e-07 sb=1.4e-07 sca=6.50517 scb=0.00415999 scc=0.000152707 $X=25540 $Y=10910
M71 54 WL3 BL2 GND g45n1svt L=4.5e-08 W=2.4e-07 AD=3.36e-14 AS=3.36e-14 PD=7.6e-07 PS=7.6e-07 fw=2.4e-07 sa=1.4e-07 sb=1.4e-07 sca=6.50517 scb=0.00415999 scc=0.000152707 $X=25540 $Y=14950
M72 BLB3 WL0 31 GND g45n1svt L=4.5e-08 W=2.4e-07 AD=3.36e-14 AS=3.36e-14 PD=7.6e-07 PS=7.6e-07 fw=2.4e-07 sa=1.4e-07 sb=1.4e-07 sca=9.45211 scb=0.00821004 scc=0.000286958 $X=26850 $Y=2160
M73 BLB3 WL1 39 GND g45n1svt L=4.5e-08 W=2.4e-07 AD=3.36e-14 AS=3.36e-14 PD=7.6e-07 PS=7.6e-07 fw=2.4e-07 sa=1.4e-07 sb=1.4e-07 sca=9.45211 scb=0.00821004 scc=0.000286958 $X=26850 $Y=6200
M74 BLB3 WL2 47 GND g45n1svt L=4.5e-08 W=2.4e-07 AD=3.36e-14 AS=3.36e-14 PD=7.6e-07 PS=7.6e-07 fw=2.4e-07 sa=1.4e-07 sb=1.4e-07 sca=9.45211 scb=0.00821004 scc=0.000286958 $X=26850 $Y=10240
M75 BLB3 WL3 55 GND g45n1svt L=4.5e-08 W=2.4e-07 AD=3.36e-14 AS=3.36e-14 PD=7.6e-07 PS=7.6e-07 fw=2.4e-07 sa=1.4e-07 sb=1.4e-07 sca=9.45211 scb=0.00821004 scc=0.000286958 $X=26850 $Y=14280
M76 GND 32 31 GND g45n1svt L=4.5e-08 W=3.6e-07 AD=5.04e-14 AS=5.04e-14 PD=1e-06 PS=1e-06 fw=3.6e-07 sa=1.4e-07 sb=1.4e-07 sca=5.75838 scb=0.0022385 scc=1.60319e-05 $X=28020 $Y=1620
M77 GND 40 39 GND g45n1svt L=4.5e-08 W=3.6e-07 AD=5.04e-14 AS=5.04e-14 PD=1e-06 PS=1e-06 fw=3.6e-07 sa=1.4e-07 sb=1.4e-07 sca=6.05657 scb=0.00229265 scc=1.60407e-05 $X=28020 $Y=5660
M78 GND 48 47 GND g45n1svt L=4.5e-08 W=3.6e-07 AD=5.04e-14 AS=5.04e-14 PD=1e-06 PS=1e-06 fw=3.6e-07 sa=1.4e-07 sb=1.4e-07 sca=6.05657 scb=0.00229265 scc=1.60407e-05 $X=28020 $Y=9700
M79 GND 56 55 GND g45n1svt L=4.5e-08 W=3.6e-07 AD=5.04e-14 AS=5.04e-14 PD=1e-06 PS=1e-06 fw=3.6e-07 sa=1.4e-07 sb=1.4e-07 sca=6.05657 scb=0.00229265 scc=1.60407e-05 $X=28020 $Y=13740
M80 GND 31 32 GND g45n1svt L=4.5e-08 W=3.6e-07 AD=5.04e-14 AS=5.04e-14 PD=1e-06 PS=1e-06 fw=3.6e-07 sa=1.4e-07 sb=1.4e-07 sca=5.75838 scb=0.0022385 scc=1.60319e-05 $X=29050 $Y=1620
M81 GND 39 40 GND g45n1svt L=4.5e-08 W=3.6e-07 AD=5.04e-14 AS=5.04e-14 PD=1e-06 PS=1e-06 fw=3.6e-07 sa=1.4e-07 sb=1.4e-07 sca=6.05657 scb=0.00229265 scc=1.60407e-05 $X=29050 $Y=5660
M82 GND 47 48 GND g45n1svt L=4.5e-08 W=3.6e-07 AD=5.04e-14 AS=5.04e-14 PD=1e-06 PS=1e-06 fw=3.6e-07 sa=1.4e-07 sb=1.4e-07 sca=6.05657 scb=0.00229265 scc=1.60407e-05 $X=29050 $Y=9700
M83 GND 55 56 GND g45n1svt L=4.5e-08 W=3.6e-07 AD=5.04e-14 AS=5.04e-14 PD=1e-06 PS=1e-06 fw=3.6e-07 sa=1.4e-07 sb=1.4e-07 sca=6.05657 scb=0.00229265 scc=1.60407e-05 $X=29050 $Y=13740
M84 32 WL0 BL3 GND g45n1svt L=4.5e-08 W=2.4e-07 AD=3.36e-14 AS=3.36e-14 PD=7.6e-07 PS=7.6e-07 fw=2.4e-07 sa=1.4e-07 sb=1.4e-07 sca=6.50517 scb=0.00415999 scc=0.000152707 $X=30140 $Y=2830
M85 40 WL1 BL3 GND g45n1svt L=4.5e-08 W=2.4e-07 AD=3.36e-14 AS=3.36e-14 PD=7.6e-07 PS=7.6e-07 fw=2.4e-07 sa=1.4e-07 sb=1.4e-07 sca=6.50517 scb=0.00415999 scc=0.000152707 $X=30140 $Y=6870
M86 48 WL2 BL3 GND g45n1svt L=4.5e-08 W=2.4e-07 AD=3.36e-14 AS=3.36e-14 PD=7.6e-07 PS=7.6e-07 fw=2.4e-07 sa=1.4e-07 sb=1.4e-07 sca=6.50517 scb=0.00415999 scc=0.000152707 $X=30140 $Y=10910
M87 56 WL3 BL3 GND g45n1svt L=4.5e-08 W=2.4e-07 AD=3.36e-14 AS=3.36e-14 PD=7.6e-07 PS=7.6e-07 fw=2.4e-07 sa=1.4e-07 sb=1.4e-07 sca=6.50517 scb=0.00415999 scc=0.000152707 $X=30140 $Y=14950
M88 BLB4 WL0 33 GND g45n1svt L=4.5e-08 W=2.4e-07 AD=3.36e-14 AS=3.36e-14 PD=7.6e-07 PS=7.6e-07 fw=2.4e-07 sa=1.4e-07 sb=1.4e-07 sca=9.45211 scb=0.00821004 scc=0.000286958 $X=31450 $Y=2160
M89 BLB4 WL1 41 GND g45n1svt L=4.5e-08 W=2.4e-07 AD=3.36e-14 AS=3.36e-14 PD=7.6e-07 PS=7.6e-07 fw=2.4e-07 sa=1.4e-07 sb=1.4e-07 sca=9.45211 scb=0.00821004 scc=0.000286958 $X=31450 $Y=6200
M90 BLB4 WL2 49 GND g45n1svt L=4.5e-08 W=2.4e-07 AD=3.36e-14 AS=3.36e-14 PD=7.6e-07 PS=7.6e-07 fw=2.4e-07 sa=1.4e-07 sb=1.4e-07 sca=9.45211 scb=0.00821004 scc=0.000286958 $X=31450 $Y=10240
M91 BLB4 WL3 57 GND g45n1svt L=4.5e-08 W=2.4e-07 AD=3.36e-14 AS=3.36e-14 PD=7.6e-07 PS=7.6e-07 fw=2.4e-07 sa=1.4e-07 sb=1.4e-07 sca=9.45211 scb=0.00821004 scc=0.000286958 $X=31450 $Y=14280
M92 GND 34 33 GND g45n1svt L=4.5e-08 W=3.6e-07 AD=5.04e-14 AS=5.04e-14 PD=1e-06 PS=1e-06 fw=3.6e-07 sa=1.4e-07 sb=1.4e-07 sca=5.75838 scb=0.0022385 scc=1.60319e-05 $X=32620 $Y=1620
M93 GND 42 41 GND g45n1svt L=4.5e-08 W=3.6e-07 AD=5.04e-14 AS=5.04e-14 PD=1e-06 PS=1e-06 fw=3.6e-07 sa=1.4e-07 sb=1.4e-07 sca=6.05657 scb=0.00229265 scc=1.60407e-05 $X=32620 $Y=5660
M94 GND 50 49 GND g45n1svt L=4.5e-08 W=3.6e-07 AD=5.04e-14 AS=5.04e-14 PD=1e-06 PS=1e-06 fw=3.6e-07 sa=1.4e-07 sb=1.4e-07 sca=6.05657 scb=0.00229265 scc=1.60407e-05 $X=32620 $Y=9700
M95 GND 58 57 GND g45n1svt L=4.5e-08 W=3.6e-07 AD=5.04e-14 AS=5.04e-14 PD=1e-06 PS=1e-06 fw=3.6e-07 sa=1.4e-07 sb=1.4e-07 sca=6.05657 scb=0.00229265 scc=1.60407e-05 $X=32620 $Y=13740
M96 GND 33 34 GND g45n1svt L=4.5e-08 W=3.6e-07 AD=5.04e-14 AS=5.04e-14 PD=1e-06 PS=1e-06 fw=3.6e-07 sa=1.4e-07 sb=1.4e-07 sca=5.75838 scb=0.0022385 scc=1.60319e-05 $X=33650 $Y=1620
M97 GND 41 42 GND g45n1svt L=4.5e-08 W=3.6e-07 AD=5.04e-14 AS=5.04e-14 PD=1e-06 PS=1e-06 fw=3.6e-07 sa=1.4e-07 sb=1.4e-07 sca=6.05657 scb=0.00229265 scc=1.60407e-05 $X=33650 $Y=5660
M98 GND 49 50 GND g45n1svt L=4.5e-08 W=3.6e-07 AD=5.04e-14 AS=5.04e-14 PD=1e-06 PS=1e-06 fw=3.6e-07 sa=1.4e-07 sb=1.4e-07 sca=6.05657 scb=0.00229265 scc=1.60407e-05 $X=33650 $Y=9700
M99 GND 57 58 GND g45n1svt L=4.5e-08 W=3.6e-07 AD=5.04e-14 AS=5.04e-14 PD=1e-06 PS=1e-06 fw=3.6e-07 sa=1.4e-07 sb=1.4e-07 sca=6.05657 scb=0.00229265 scc=1.60407e-05 $X=33650 $Y=13740
M100 34 WL0 BL4 GND g45n1svt L=4.5e-08 W=2.4e-07 AD=3.36e-14 AS=3.36e-14 PD=7.6e-07 PS=7.6e-07 fw=2.4e-07 sa=1.4e-07 sb=1.4e-07 sca=6.50517 scb=0.00415999 scc=0.000152707 $X=34740 $Y=2830
M101 42 WL1 BL4 GND g45n1svt L=4.5e-08 W=2.4e-07 AD=3.36e-14 AS=3.36e-14 PD=7.6e-07 PS=7.6e-07 fw=2.4e-07 sa=1.4e-07 sb=1.4e-07 sca=6.50517 scb=0.00415999 scc=0.000152707 $X=34740 $Y=6870
M102 50 WL2 BL4 GND g45n1svt L=4.5e-08 W=2.4e-07 AD=3.36e-14 AS=3.36e-14 PD=7.6e-07 PS=7.6e-07 fw=2.4e-07 sa=1.4e-07 sb=1.4e-07 sca=6.50517 scb=0.00415999 scc=0.000152707 $X=34740 $Y=10910
M103 58 WL3 BL4 GND g45n1svt L=4.5e-08 W=2.4e-07 AD=3.36e-14 AS=3.36e-14 PD=7.6e-07 PS=7.6e-07 fw=2.4e-07 sa=1.4e-07 sb=1.4e-07 sca=6.50517 scb=0.00415999 scc=0.000152707 $X=34740 $Y=14950
M104 BLB5 WL0 59 GND g45n1svt L=4.5e-08 W=2.4e-07 AD=3.36e-14 AS=3.36e-14 PD=7.6e-07 PS=7.6e-07 fw=2.4e-07 sa=1.4e-07 sb=1.4e-07 sca=9.45211 scb=0.00821004 scc=0.000286958 $X=36050 $Y=2160
M105 BLB5 WL1 61 GND g45n1svt L=4.5e-08 W=2.4e-07 AD=3.36e-14 AS=3.36e-14 PD=7.6e-07 PS=7.6e-07 fw=2.4e-07 sa=1.4e-07 sb=1.4e-07 sca=9.45211 scb=0.00821004 scc=0.000286958 $X=36050 $Y=6200
M106 BLB5 WL2 63 GND g45n1svt L=4.5e-08 W=2.4e-07 AD=3.36e-14 AS=3.36e-14 PD=7.6e-07 PS=7.6e-07 fw=2.4e-07 sa=1.4e-07 sb=1.4e-07 sca=9.45211 scb=0.00821004 scc=0.000286958 $X=36050 $Y=10240
M107 BLB5 WL3 65 GND g45n1svt L=4.5e-08 W=2.4e-07 AD=3.36e-14 AS=3.36e-14 PD=7.6e-07 PS=7.6e-07 fw=2.4e-07 sa=1.4e-07 sb=1.4e-07 sca=9.45211 scb=0.00821004 scc=0.000286958 $X=36050 $Y=14280
M108 GND 60 59 GND g45n1svt L=4.5e-08 W=3.6e-07 AD=5.04e-14 AS=5.04e-14 PD=1e-06 PS=1e-06 fw=3.6e-07 sa=1.4e-07 sb=1.4e-07 sca=5.75838 scb=0.0022385 scc=1.60319e-05 $X=37220 $Y=1620
M109 GND 62 61 GND g45n1svt L=4.5e-08 W=3.6e-07 AD=5.04e-14 AS=5.04e-14 PD=1e-06 PS=1e-06 fw=3.6e-07 sa=1.4e-07 sb=1.4e-07 sca=6.05657 scb=0.00229265 scc=1.60407e-05 $X=37220 $Y=5660
M110 GND 64 63 GND g45n1svt L=4.5e-08 W=3.6e-07 AD=5.04e-14 AS=5.04e-14 PD=1e-06 PS=1e-06 fw=3.6e-07 sa=1.4e-07 sb=1.4e-07 sca=6.05657 scb=0.00229265 scc=1.60407e-05 $X=37220 $Y=9700
M111 GND 66 65 GND g45n1svt L=4.5e-08 W=3.6e-07 AD=5.04e-14 AS=5.04e-14 PD=1e-06 PS=1e-06 fw=3.6e-07 sa=1.4e-07 sb=1.4e-07 sca=6.05657 scb=0.00229265 scc=1.60407e-05 $X=37220 $Y=13740
M112 GND 59 60 GND g45n1svt L=4.5e-08 W=3.6e-07 AD=5.04e-14 AS=5.04e-14 PD=1e-06 PS=1e-06 fw=3.6e-07 sa=1.4e-07 sb=1.4e-07 sca=5.75838 scb=0.0022385 scc=1.60319e-05 $X=38250 $Y=1620
M113 GND 61 62 GND g45n1svt L=4.5e-08 W=3.6e-07 AD=5.04e-14 AS=5.04e-14 PD=1e-06 PS=1e-06 fw=3.6e-07 sa=1.4e-07 sb=1.4e-07 sca=6.05657 scb=0.00229265 scc=1.60407e-05 $X=38250 $Y=5660
M114 GND 63 64 GND g45n1svt L=4.5e-08 W=3.6e-07 AD=5.04e-14 AS=5.04e-14 PD=1e-06 PS=1e-06 fw=3.6e-07 sa=1.4e-07 sb=1.4e-07 sca=6.05657 scb=0.00229265 scc=1.60407e-05 $X=38250 $Y=9700
M115 GND 65 66 GND g45n1svt L=4.5e-08 W=3.6e-07 AD=5.04e-14 AS=5.04e-14 PD=1e-06 PS=1e-06 fw=3.6e-07 sa=1.4e-07 sb=1.4e-07 sca=6.05657 scb=0.00229265 scc=1.60407e-05 $X=38250 $Y=13740
M116 60 WL0 BL5 GND g45n1svt L=4.5e-08 W=2.4e-07 AD=3.36e-14 AS=3.36e-14 PD=7.6e-07 PS=7.6e-07 fw=2.4e-07 sa=1.4e-07 sb=1.4e-07 sca=6.06571 scb=0.00385227 scc=0.000152152 $X=39340 $Y=2830
M117 62 WL1 BL5 GND g45n1svt L=4.5e-08 W=2.4e-07 AD=3.36e-14 AS=3.36e-14 PD=7.6e-07 PS=7.6e-07 fw=2.4e-07 sa=1.4e-07 sb=1.4e-07 sca=6.06571 scb=0.00385227 scc=0.000152152 $X=39340 $Y=6870
M118 64 WL2 BL5 GND g45n1svt L=4.5e-08 W=2.4e-07 AD=3.36e-14 AS=3.36e-14 PD=7.6e-07 PS=7.6e-07 fw=2.4e-07 sa=1.4e-07 sb=1.4e-07 sca=6.06571 scb=0.00385227 scc=0.000152152 $X=39340 $Y=10910
M119 66 WL3 BL5 GND g45n1svt L=4.5e-08 W=2.4e-07 AD=3.36e-14 AS=3.36e-14 PD=7.6e-07 PS=7.6e-07 fw=2.4e-07 sa=1.4e-07 sb=1.4e-07 sca=6.06571 scb=0.00385227 scc=0.000152152 $X=39340 $Y=14950
M120 VDD 20 19 VDD g45p1svt L=4.5e-08 W=1.2e-07 AD=1.68e-14 AS=1.68e-14 PD=5.2e-07 PS=5.2e-07 fw=1.2e-07 sa=1.4e-07 sb=1.4e-07 sca=57.0437 scb=0.0528056 scc=0.00752443 $X=14220 $Y=3410
M121 VDD 22 21 VDD g45p1svt L=4.5e-08 W=1.2e-07 AD=1.68e-14 AS=1.68e-14 PD=5.2e-07 PS=5.2e-07 fw=1.2e-07 sa=1.4e-07 sb=1.4e-07 sca=57.0437 scb=0.0528056 scc=0.00752443 $X=14220 $Y=7450
M122 VDD 24 23 VDD g45p1svt L=4.5e-08 W=1.2e-07 AD=1.68e-14 AS=1.68e-14 PD=5.2e-07 PS=5.2e-07 fw=1.2e-07 sa=1.4e-07 sb=1.4e-07 sca=57.0437 scb=0.0528056 scc=0.00752443 $X=14220 $Y=11490
M123 VDD 26 25 VDD g45p1svt L=4.5e-08 W=1.2e-07 AD=1.68e-14 AS=1.68e-14 PD=5.2e-07 PS=5.2e-07 fw=1.2e-07 sa=1.4e-07 sb=1.4e-07 sca=57.0437 scb=0.0528056 scc=0.00752443 $X=14220 $Y=15530
M124 20 19 VDD VDD g45p1svt L=4.5e-08 W=1.2e-07 AD=1.68e-14 AS=1.68e-14 PD=5.2e-07 PS=5.2e-07 fw=1.2e-07 sa=1.4e-07 sb=1.4e-07 sca=73.81 scb=0.0749781 scc=0.0101674 $X=15250 $Y=3410
M125 22 21 VDD VDD g45p1svt L=4.5e-08 W=1.2e-07 AD=1.68e-14 AS=1.68e-14 PD=5.2e-07 PS=5.2e-07 fw=1.2e-07 sa=1.4e-07 sb=1.4e-07 sca=73.81 scb=0.0749781 scc=0.0101674 $X=15250 $Y=7450
M126 24 23 VDD VDD g45p1svt L=4.5e-08 W=1.2e-07 AD=1.68e-14 AS=1.68e-14 PD=5.2e-07 PS=5.2e-07 fw=1.2e-07 sa=1.4e-07 sb=1.4e-07 sca=73.81 scb=0.0749781 scc=0.0101674 $X=15250 $Y=11490
M127 26 25 VDD VDD g45p1svt L=4.5e-08 W=1.2e-07 AD=1.68e-14 AS=1.68e-14 PD=5.2e-07 PS=5.2e-07 fw=1.2e-07 sa=1.4e-07 sb=1.4e-07 sca=73.81 scb=0.0749781 scc=0.0101674 $X=15250 $Y=15530
M128 VDD 28 27 VDD g45p1svt L=4.5e-08 W=1.2e-07 AD=1.68e-14 AS=1.68e-14 PD=5.2e-07 PS=5.2e-07 fw=1.2e-07 sa=1.4e-07 sb=1.4e-07 sca=57.0437 scb=0.0528056 scc=0.00752443 $X=18820 $Y=3410
M129 VDD 36 35 VDD g45p1svt L=4.5e-08 W=1.2e-07 AD=1.68e-14 AS=1.68e-14 PD=5.2e-07 PS=5.2e-07 fw=1.2e-07 sa=1.4e-07 sb=1.4e-07 sca=57.0437 scb=0.0528056 scc=0.00752443 $X=18820 $Y=7450
M130 VDD 44 43 VDD g45p1svt L=4.5e-08 W=1.2e-07 AD=1.68e-14 AS=1.68e-14 PD=5.2e-07 PS=5.2e-07 fw=1.2e-07 sa=1.4e-07 sb=1.4e-07 sca=57.0437 scb=0.0528056 scc=0.00752443 $X=18820 $Y=11490
M131 VDD 52 51 VDD g45p1svt L=4.5e-08 W=1.2e-07 AD=1.68e-14 AS=1.68e-14 PD=5.2e-07 PS=5.2e-07 fw=1.2e-07 sa=1.4e-07 sb=1.4e-07 sca=57.0437 scb=0.0528056 scc=0.00752443 $X=18820 $Y=15530
M132 28 27 VDD VDD g45p1svt L=4.5e-08 W=1.2e-07 AD=1.68e-14 AS=1.68e-14 PD=5.2e-07 PS=5.2e-07 fw=1.2e-07 sa=1.4e-07 sb=1.4e-07 sca=73.81 scb=0.0749781 scc=0.0101674 $X=19850 $Y=3410
M133 36 35 VDD VDD g45p1svt L=4.5e-08 W=1.2e-07 AD=1.68e-14 AS=1.68e-14 PD=5.2e-07 PS=5.2e-07 fw=1.2e-07 sa=1.4e-07 sb=1.4e-07 sca=73.81 scb=0.0749781 scc=0.0101674 $X=19850 $Y=7450
M134 44 43 VDD VDD g45p1svt L=4.5e-08 W=1.2e-07 AD=1.68e-14 AS=1.68e-14 PD=5.2e-07 PS=5.2e-07 fw=1.2e-07 sa=1.4e-07 sb=1.4e-07 sca=73.81 scb=0.0749781 scc=0.0101674 $X=19850 $Y=11490
M135 52 51 VDD VDD g45p1svt L=4.5e-08 W=1.2e-07 AD=1.68e-14 AS=1.68e-14 PD=5.2e-07 PS=5.2e-07 fw=1.2e-07 sa=1.4e-07 sb=1.4e-07 sca=73.81 scb=0.0749781 scc=0.0101674 $X=19850 $Y=15530
M136 VDD 30 29 VDD g45p1svt L=4.5e-08 W=1.2e-07 AD=1.68e-14 AS=1.68e-14 PD=5.2e-07 PS=5.2e-07 fw=1.2e-07 sa=1.4e-07 sb=1.4e-07 sca=57.0437 scb=0.0528056 scc=0.00752443 $X=23420 $Y=3410
M137 VDD 38 37 VDD g45p1svt L=4.5e-08 W=1.2e-07 AD=1.68e-14 AS=1.68e-14 PD=5.2e-07 PS=5.2e-07 fw=1.2e-07 sa=1.4e-07 sb=1.4e-07 sca=57.0437 scb=0.0528056 scc=0.00752443 $X=23420 $Y=7450
M138 VDD 46 45 VDD g45p1svt L=4.5e-08 W=1.2e-07 AD=1.68e-14 AS=1.68e-14 PD=5.2e-07 PS=5.2e-07 fw=1.2e-07 sa=1.4e-07 sb=1.4e-07 sca=57.0437 scb=0.0528056 scc=0.00752443 $X=23420 $Y=11490
M139 VDD 54 53 VDD g45p1svt L=4.5e-08 W=1.2e-07 AD=1.68e-14 AS=1.68e-14 PD=5.2e-07 PS=5.2e-07 fw=1.2e-07 sa=1.4e-07 sb=1.4e-07 sca=57.0437 scb=0.0528056 scc=0.00752443 $X=23420 $Y=15530
M140 30 29 VDD VDD g45p1svt L=4.5e-08 W=1.2e-07 AD=1.68e-14 AS=1.68e-14 PD=5.2e-07 PS=5.2e-07 fw=1.2e-07 sa=1.4e-07 sb=1.4e-07 sca=73.81 scb=0.0749781 scc=0.0101674 $X=24450 $Y=3410
M141 38 37 VDD VDD g45p1svt L=4.5e-08 W=1.2e-07 AD=1.68e-14 AS=1.68e-14 PD=5.2e-07 PS=5.2e-07 fw=1.2e-07 sa=1.4e-07 sb=1.4e-07 sca=73.81 scb=0.0749781 scc=0.0101674 $X=24450 $Y=7450
M142 46 45 VDD VDD g45p1svt L=4.5e-08 W=1.2e-07 AD=1.68e-14 AS=1.68e-14 PD=5.2e-07 PS=5.2e-07 fw=1.2e-07 sa=1.4e-07 sb=1.4e-07 sca=73.81 scb=0.0749781 scc=0.0101674 $X=24450 $Y=11490
M143 54 53 VDD VDD g45p1svt L=4.5e-08 W=1.2e-07 AD=1.68e-14 AS=1.68e-14 PD=5.2e-07 PS=5.2e-07 fw=1.2e-07 sa=1.4e-07 sb=1.4e-07 sca=73.81 scb=0.0749781 scc=0.0101674 $X=24450 $Y=15530
M144 VDD 32 31 VDD g45p1svt L=4.5e-08 W=1.2e-07 AD=1.68e-14 AS=1.68e-14 PD=5.2e-07 PS=5.2e-07 fw=1.2e-07 sa=1.4e-07 sb=1.4e-07 sca=57.0437 scb=0.0528056 scc=0.00752443 $X=28020 $Y=3410
M145 VDD 40 39 VDD g45p1svt L=4.5e-08 W=1.2e-07 AD=1.68e-14 AS=1.68e-14 PD=5.2e-07 PS=5.2e-07 fw=1.2e-07 sa=1.4e-07 sb=1.4e-07 sca=57.0437 scb=0.0528056 scc=0.00752443 $X=28020 $Y=7450
M146 VDD 48 47 VDD g45p1svt L=4.5e-08 W=1.2e-07 AD=1.68e-14 AS=1.68e-14 PD=5.2e-07 PS=5.2e-07 fw=1.2e-07 sa=1.4e-07 sb=1.4e-07 sca=57.0437 scb=0.0528056 scc=0.00752443 $X=28020 $Y=11490
M147 VDD 56 55 VDD g45p1svt L=4.5e-08 W=1.2e-07 AD=1.68e-14 AS=1.68e-14 PD=5.2e-07 PS=5.2e-07 fw=1.2e-07 sa=1.4e-07 sb=1.4e-07 sca=57.0437 scb=0.0528056 scc=0.00752443 $X=28020 $Y=15530
M148 32 31 VDD VDD g45p1svt L=4.5e-08 W=1.2e-07 AD=1.68e-14 AS=1.68e-14 PD=5.2e-07 PS=5.2e-07 fw=1.2e-07 sa=1.4e-07 sb=1.4e-07 sca=73.81 scb=0.0749781 scc=0.0101674 $X=29050 $Y=3410
M149 40 39 VDD VDD g45p1svt L=4.5e-08 W=1.2e-07 AD=1.68e-14 AS=1.68e-14 PD=5.2e-07 PS=5.2e-07 fw=1.2e-07 sa=1.4e-07 sb=1.4e-07 sca=73.81 scb=0.0749781 scc=0.0101674 $X=29050 $Y=7450
M150 48 47 VDD VDD g45p1svt L=4.5e-08 W=1.2e-07 AD=1.68e-14 AS=1.68e-14 PD=5.2e-07 PS=5.2e-07 fw=1.2e-07 sa=1.4e-07 sb=1.4e-07 sca=73.81 scb=0.0749781 scc=0.0101674 $X=29050 $Y=11490
M151 56 55 VDD VDD g45p1svt L=4.5e-08 W=1.2e-07 AD=1.68e-14 AS=1.68e-14 PD=5.2e-07 PS=5.2e-07 fw=1.2e-07 sa=1.4e-07 sb=1.4e-07 sca=73.81 scb=0.0749781 scc=0.0101674 $X=29050 $Y=15530
M152 VDD 34 33 VDD g45p1svt L=4.5e-08 W=1.2e-07 AD=1.68e-14 AS=1.68e-14 PD=5.2e-07 PS=5.2e-07 fw=1.2e-07 sa=1.4e-07 sb=1.4e-07 sca=57.0437 scb=0.0528056 scc=0.00752443 $X=32620 $Y=3410
M153 VDD 42 41 VDD g45p1svt L=4.5e-08 W=1.2e-07 AD=1.68e-14 AS=1.68e-14 PD=5.2e-07 PS=5.2e-07 fw=1.2e-07 sa=1.4e-07 sb=1.4e-07 sca=57.0437 scb=0.0528056 scc=0.00752443 $X=32620 $Y=7450
M154 VDD 50 49 VDD g45p1svt L=4.5e-08 W=1.2e-07 AD=1.68e-14 AS=1.68e-14 PD=5.2e-07 PS=5.2e-07 fw=1.2e-07 sa=1.4e-07 sb=1.4e-07 sca=57.0437 scb=0.0528056 scc=0.00752443 $X=32620 $Y=11490
M155 VDD 58 57 VDD g45p1svt L=4.5e-08 W=1.2e-07 AD=1.68e-14 AS=1.68e-14 PD=5.2e-07 PS=5.2e-07 fw=1.2e-07 sa=1.4e-07 sb=1.4e-07 sca=57.0437 scb=0.0528056 scc=0.00752443 $X=32620 $Y=15530
M156 34 33 VDD VDD g45p1svt L=4.5e-08 W=1.2e-07 AD=1.68e-14 AS=1.68e-14 PD=5.2e-07 PS=5.2e-07 fw=1.2e-07 sa=1.4e-07 sb=1.4e-07 sca=73.81 scb=0.0749781 scc=0.0101674 $X=33650 $Y=3410
M157 42 41 VDD VDD g45p1svt L=4.5e-08 W=1.2e-07 AD=1.68e-14 AS=1.68e-14 PD=5.2e-07 PS=5.2e-07 fw=1.2e-07 sa=1.4e-07 sb=1.4e-07 sca=73.81 scb=0.0749781 scc=0.0101674 $X=33650 $Y=7450
M158 50 49 VDD VDD g45p1svt L=4.5e-08 W=1.2e-07 AD=1.68e-14 AS=1.68e-14 PD=5.2e-07 PS=5.2e-07 fw=1.2e-07 sa=1.4e-07 sb=1.4e-07 sca=73.81 scb=0.0749781 scc=0.0101674 $X=33650 $Y=11490
M159 58 57 VDD VDD g45p1svt L=4.5e-08 W=1.2e-07 AD=1.68e-14 AS=1.68e-14 PD=5.2e-07 PS=5.2e-07 fw=1.2e-07 sa=1.4e-07 sb=1.4e-07 sca=73.81 scb=0.0749781 scc=0.0101674 $X=33650 $Y=15530
M160 VDD 60 59 VDD g45p1svt L=4.5e-08 W=1.2e-07 AD=1.68e-14 AS=1.68e-14 PD=5.2e-07 PS=5.2e-07 fw=1.2e-07 sa=1.4e-07 sb=1.4e-07 sca=57.0437 scb=0.0528056 scc=0.00752443 $X=37220 $Y=3410
M161 VDD 62 61 VDD g45p1svt L=4.5e-08 W=1.2e-07 AD=1.68e-14 AS=1.68e-14 PD=5.2e-07 PS=5.2e-07 fw=1.2e-07 sa=1.4e-07 sb=1.4e-07 sca=57.0437 scb=0.0528056 scc=0.00752443 $X=37220 $Y=7450
M162 VDD 64 63 VDD g45p1svt L=4.5e-08 W=1.2e-07 AD=1.68e-14 AS=1.68e-14 PD=5.2e-07 PS=5.2e-07 fw=1.2e-07 sa=1.4e-07 sb=1.4e-07 sca=57.0437 scb=0.0528056 scc=0.00752443 $X=37220 $Y=11490
M163 VDD 66 65 VDD g45p1svt L=4.5e-08 W=1.2e-07 AD=1.68e-14 AS=1.68e-14 PD=5.2e-07 PS=5.2e-07 fw=1.2e-07 sa=1.4e-07 sb=1.4e-07 sca=57.0437 scb=0.0528056 scc=0.00752443 $X=37220 $Y=15530
M164 60 59 VDD VDD g45p1svt L=4.5e-08 W=1.2e-07 AD=1.68e-14 AS=1.68e-14 PD=5.2e-07 PS=5.2e-07 fw=1.2e-07 sa=1.4e-07 sb=1.4e-07 sca=73.81 scb=0.0749781 scc=0.0101674 $X=38250 $Y=3410
M165 62 61 VDD VDD g45p1svt L=4.5e-08 W=1.2e-07 AD=1.68e-14 AS=1.68e-14 PD=5.2e-07 PS=5.2e-07 fw=1.2e-07 sa=1.4e-07 sb=1.4e-07 sca=73.81 scb=0.0749781 scc=0.0101674 $X=38250 $Y=7450
M166 64 63 VDD VDD g45p1svt L=4.5e-08 W=1.2e-07 AD=1.68e-14 AS=1.68e-14 PD=5.2e-07 PS=5.2e-07 fw=1.2e-07 sa=1.4e-07 sb=1.4e-07 sca=73.81 scb=0.0749781 scc=0.0101674 $X=38250 $Y=11490
M167 66 65 VDD VDD g45p1svt L=4.5e-08 W=1.2e-07 AD=1.68e-14 AS=1.68e-14 PD=5.2e-07 PS=5.2e-07 fw=1.2e-07 sa=1.4e-07 sb=1.4e-07 sca=73.81 scb=0.0749781 scc=0.0101674 $X=38250 $Y=15530
** N=66 EP=18 NDC=144 FDC=144 HDC=144
.ends bit_array
