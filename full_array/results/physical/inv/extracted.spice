* +++++++++++++++++++++++++++++++++++++++++++++++++++++
* CDL Netlist:
*
* Cell Name: inv
* Netlisted: 2026-11-07 03:29:45
* Pegasus 25.14-s010
* +++++++++++++++++++++++++++++++++++++++++++++++++++++
*.LDD

* +++++++++++++++++++++++++++++++++++++++++++++++++++++
* Sub cell: inv
* +++++++++++++++++++++++++++++++++++++++++++++++++++++
.subckt inv GND VDD OUT IN
M0 GND IN OUT GND g45n1svt L=4.5e-08 W=3.6e-07 AD=5.04e-14 AS=5.04e-14 PD=1e-06 PS=1e-06 fw=3.6e-07 sa=1.4e-07 sb=1.4e-07 sca=3.70436 scb=0.000161812 scc=1.4064e-08 $X=3360 $Y=1540
M1 VDD IN OUT VDD g45p1svt L=4.5e-08 W=3.6e-07 AD=5.04e-14 AS=5.04e-14 PD=1e-06 PS=1e-06 fw=3.6e-07 sa=1.4e-07 sb=1.4e-07 sca=21.3981 scb=0.0224765 scc=0.00127211 $X=4060 $Y=4280
** N=4 EP=4 NDC=2 FDC=2 HDC=2
.ends inv
