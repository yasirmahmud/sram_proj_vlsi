* +++++++++++++++++++++++++++++++++++++++++++++++++++++
* CDL Netlist:
*
* Cell Name: bitcell
* Netlisted: 2026-11-07 03:32:51
* Pegasus 25.14-s010
* +++++++++++++++++++++++++++++++++++++++++++++++++++++
*.LDD

* +++++++++++++++++++++++++++++++++++++++++++++++++++++
* Sub cell: bitcell
* +++++++++++++++++++++++++++++++++++++++++++++++++++++
.subckt bitcell GND VDD WL Q Q_bar BL_bar BL
M6 BL_bar WL Q_bar GND g45n1svt L=4.5e-08 W=2.4e-07 AD=3.36e-14 AS=3.36e-14 PD=7.6e-07 PS=7.6e-07 fw=2.4e-07 sa=1.4e-07 sb=1.4e-07 sca=9.45211 scb=0.00821004 scc=0.000286958 $X=430 $Y=1460
M7 GND Q Q_bar GND g45n1svt L=4.5e-08 W=3.6e-07 AD=5.04e-14 AS=5.04e-14 PD=1e-06 PS=1e-06 fw=3.6e-07 sa=1.4e-07 sb=1.4e-07 sca=5.75838 scb=0.0022385 scc=1.60319e-05 $X=1600 $Y=920
M8 GND Q_bar Q GND g45n1svt L=4.5e-08 W=3.6e-07 AD=5.04e-14 AS=5.04e-14 PD=1e-06 PS=1e-06 fw=3.6e-07 sa=1.4e-07 sb=1.4e-07 sca=5.75838 scb=0.0022385 scc=1.60319e-05 $X=2630 $Y=920
M9 Q WL BL GND g45n1svt L=4.5e-08 W=2.4e-07 AD=3.36e-14 AS=3.36e-14 PD=7.6e-07 PS=7.6e-07 fw=2.4e-07 sa=1.4e-07 sb=1.4e-07 sca=6.06571 scb=0.00385227 scc=0.000152152 $X=3720 $Y=2130
M10 VDD Q Q_bar VDD g45p1svt L=4.5e-08 W=1.2e-07 AD=1.68e-14 AS=1.68e-14 PD=5.2e-07 PS=5.2e-07 fw=1.2e-07 sa=1.4e-07 sb=1.4e-07 sca=57.0437 scb=0.0528056 scc=0.00752443 $X=1600 $Y=2710
M11 Q Q_bar VDD VDD g45p1svt L=4.5e-08 W=1.2e-07 AD=1.68e-14 AS=1.68e-14 PD=5.2e-07 PS=5.2e-07 fw=1.2e-07 sa=1.4e-07 sb=1.4e-07 sca=73.81 scb=0.0749781 scc=0.0101674 $X=2630 $Y=2710
** N=7 EP=7 NDC=6 FDC=6 HDC=6
.ends bitcell
