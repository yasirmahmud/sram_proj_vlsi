* +++++++++++++++++++++++++++++++++++++++++++++++++++++
* CDL Netlist:
*
* Cell Name: nand3
* Netlisted: 2026-11-07 03:29:45
* Pegasus 25.14-s010
* +++++++++++++++++++++++++++++++++++++++++++++++++++++
*.LDD

* +++++++++++++++++++++++++++++++++++++++++++++++++++++
* Sub cell: nmos1v_CDNS_794040155650
* +++++++++++++++++++++++++++++++++++++++++++++++++++++
.subckt nmos1v_CDNS_794040155650 1 2 3 4
M0 3 2 4 1 g45n1svt L=4.5e-08 W=1.08e-06 AD=1.512e-13 AS=1.512e-13 PD=2.44e-06 PS=2.44e-06 fw=1.08e-06 sa=1.4e-07 sb=1.4e-07 sca=2.87541 scb=8.38884e-05 scc=2.97061e-09 $X=0 $Y=0
** N=4 EP=4 NDC=1 FDC=1 HDC=1
.ends nmos1v_CDNS_794040155650

* +++++++++++++++++++++++++++++++++++++++++++++++++++++
* Sub cell: nand3
* +++++++++++++++++++++++++++++++++++++++++++++++++++++
.subckt nand3 GND VDD Y A B E
X0 GND A 3 Y nmos1v_CDNS_794040155650 $T=5920 2820 0 0 $X=5500 $Y=2620
X1 GND B 5 3 nmos1v_CDNS_794040155650 $T=7320 2820 0 0 $X=6900 $Y=2620
X2 GND E GND 5 nmos1v_CDNS_794040155650 $T=8720 2820 0 0 $X=8300 $Y=2620
M6 VDD A Y VDD g45p1svt L=4.5e-08 W=3.6e-07 AD=5.04e-14 AS=5.04e-14 PD=1e-06 PS=1e-06 fw=3.6e-07 sa=1.4e-07 sb=1.4e-07 sca=21.3981 scb=0.0224765 scc=0.00127211 $X=6620 $Y=8280
M7 VDD B Y VDD g45p1svt L=4.5e-08 W=3.6e-07 AD=5.04e-14 AS=5.04e-14 PD=1e-06 PS=1e-06 fw=3.6e-07 sa=1.4e-07 sb=1.4e-07 sca=19.771 scb=0.0212746 scc=0.00126961 $X=8020 $Y=8280
M8 VDD E Y VDD g45p1svt L=4.5e-08 W=3.6e-07 AD=5.04e-14 AS=5.04e-14 PD=1e-06 PS=1e-06 fw=3.6e-07 sa=1.4e-07 sb=1.4e-07 sca=19.771 scb=0.0212746 scc=0.00126961 $X=9420 $Y=8280
** N=8 EP=6 NDC=3 FDC=6 HDC=4
.ends nand3
