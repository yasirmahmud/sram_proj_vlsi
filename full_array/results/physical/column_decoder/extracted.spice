* +++++++++++++++++++++++++++++++++++++++++++++++++++++
* CDL Netlist:
*
* Cell Name: column_decoder
* Netlisted: 2026-11-07 03:32:03
* Pegasus 25.14-s010
* +++++++++++++++++++++++++++++++++++++++++++++++++++++
*.LDD

* +++++++++++++++++++++++++++++++++++++++++++++++++++++
* Sub cell: inv
* +++++++++++++++++++++++++++++++++++++++++++++++++++++
.subckt inv GND VDD OUT IN
M2 GND IN OUT GND g45n1svt L=4.5e-08 W=3.6e-07 AD=5.04e-14 AS=5.04e-14 PD=1e-06 PS=1e-06 fw=3.6e-07 sa=1.4e-07 sb=1.4e-07 sca=3.70436 scb=0.000161812 scc=1.4064e-08 $X=3360 $Y=1540
M3 VDD IN OUT VDD g45p1svt L=4.5e-08 W=3.6e-07 AD=5.04e-14 AS=5.04e-14 PD=1e-06 PS=1e-06 fw=3.6e-07 sa=1.4e-07 sb=1.4e-07 sca=21.3981 scb=0.0224765 scc=0.00127211 $X=4060 $Y=4280
** N=4 EP=4 NDC=2 FDC=2 HDC=2
.ends inv

* +++++++++++++++++++++++++++++++++++++++++++++++++++++
* Sub cell: column_decoder
* +++++++++++++++++++++++++++++++++++++++++++++++++++++
.subckt column_decoder GND C0 VDD C1 C2 CS0 CS1 CS2 CS3 CS4
+ CS5
X0 GND VDD 3 C0 inv $T=8140 700 0 0 $X=8500 $Y=760
X1 GND VDD 13 C1 inv $T=15400 700 0 0 $X=15760 $Y=760
X2 GND VDD 14 C2 inv $T=22660 700 0 0 $X=23020 $Y=760
M9 15 14 16 GND g45n1svt L=4.5e-08 W=1.08e-06 AD=1.512e-13 AS=1.512e-13 PD=2.44e-06 PS=2.44e-06 fw=1.08e-06 sa=1.4e-07 sb=1.4e-07 sca=2.87541 scb=8.38884e-05 scc=2.97061e-09 $X=36480 $Y=4160
M10 17 13 15 GND g45n1svt L=4.5e-08 W=1.08e-06 AD=1.512e-13 AS=1.512e-13 PD=2.44e-06 PS=2.44e-06 fw=1.08e-06 sa=1.4e-07 sb=1.4e-07 sca=2.87541 scb=8.38884e-05 scc=2.97061e-09 $X=37880 $Y=4160
M11 GND 3 17 GND g45n1svt L=4.5e-08 W=1.08e-06 AD=1.512e-13 AS=1.512e-13 PD=2.44e-06 PS=2.44e-06 fw=1.08e-06 sa=1.4e-07 sb=1.4e-07 sca=2.87541 scb=8.38884e-05 scc=2.97061e-09 $X=39280 $Y=4160
M12 GND 16 CS0 GND g45n1svt L=4.5e-08 W=3.6e-07 AD=5.04e-14 AS=5.04e-14 PD=1e-06 PS=1e-06 fw=3.6e-07 sa=1.4e-07 sb=1.4e-07 sca=3.38446 scb=0.000101379 scc=3.37079e-09 $X=40680 $Y=4160
M13 18 14 19 GND g45n1svt L=4.5e-08 W=1.08e-06 AD=1.512e-13 AS=1.512e-13 PD=2.44e-06 PS=2.44e-06 fw=1.08e-06 sa=1.4e-07 sb=1.4e-07 sca=2.87541 scb=8.38884e-05 scc=2.97061e-09 $X=51140 $Y=4160
M14 20 13 18 GND g45n1svt L=4.5e-08 W=1.08e-06 AD=1.512e-13 AS=1.512e-13 PD=2.44e-06 PS=2.44e-06 fw=1.08e-06 sa=1.4e-07 sb=1.4e-07 sca=2.87541 scb=8.38884e-05 scc=2.97061e-09 $X=52540 $Y=4160
M15 GND C0 20 GND g45n1svt L=4.5e-08 W=1.08e-06 AD=1.512e-13 AS=1.512e-13 PD=2.44e-06 PS=2.44e-06 fw=1.08e-06 sa=1.4e-07 sb=1.4e-07 sca=2.87541 scb=8.38884e-05 scc=2.97061e-09 $X=53940 $Y=4160
M16 GND 19 CS1 GND g45n1svt L=4.5e-08 W=3.6e-07 AD=5.04e-14 AS=5.04e-14 PD=1e-06 PS=1e-06 fw=3.6e-07 sa=1.4e-07 sb=1.4e-07 sca=3.38446 scb=0.000101379 scc=3.37079e-09 $X=55340 $Y=4160
M17 21 14 22 GND g45n1svt L=4.5e-08 W=1.08e-06 AD=1.512e-13 AS=1.512e-13 PD=2.44e-06 PS=2.44e-06 fw=1.08e-06 sa=1.4e-07 sb=1.4e-07 sca=2.87541 scb=8.38884e-05 scc=2.97061e-09 $X=65800 $Y=4160
M18 23 C1 21 GND g45n1svt L=4.5e-08 W=1.08e-06 AD=1.512e-13 AS=1.512e-13 PD=2.44e-06 PS=2.44e-06 fw=1.08e-06 sa=1.4e-07 sb=1.4e-07 sca=2.87541 scb=8.38884e-05 scc=2.97061e-09 $X=67200 $Y=4160
M19 GND 3 23 GND g45n1svt L=4.5e-08 W=1.08e-06 AD=1.512e-13 AS=1.512e-13 PD=2.44e-06 PS=2.44e-06 fw=1.08e-06 sa=1.4e-07 sb=1.4e-07 sca=2.87541 scb=8.38884e-05 scc=2.97061e-09 $X=68600 $Y=4160
M20 GND 22 CS2 GND g45n1svt L=4.5e-08 W=3.6e-07 AD=5.04e-14 AS=5.04e-14 PD=1e-06 PS=1e-06 fw=3.6e-07 sa=1.4e-07 sb=1.4e-07 sca=3.38446 scb=0.000101379 scc=3.37079e-09 $X=70000 $Y=4160
M21 24 14 25 GND g45n1svt L=4.5e-08 W=1.08e-06 AD=1.512e-13 AS=1.512e-13 PD=2.44e-06 PS=2.44e-06 fw=1.08e-06 sa=1.4e-07 sb=1.4e-07 sca=2.87541 scb=8.38884e-05 scc=2.97061e-09 $X=80460 $Y=4160
M22 26 C1 24 GND g45n1svt L=4.5e-08 W=1.08e-06 AD=1.512e-13 AS=1.512e-13 PD=2.44e-06 PS=2.44e-06 fw=1.08e-06 sa=1.4e-07 sb=1.4e-07 sca=2.87541 scb=8.38884e-05 scc=2.97061e-09 $X=81860 $Y=4160
M23 GND C0 26 GND g45n1svt L=4.5e-08 W=1.08e-06 AD=1.512e-13 AS=1.512e-13 PD=2.44e-06 PS=2.44e-06 fw=1.08e-06 sa=1.4e-07 sb=1.4e-07 sca=2.87541 scb=8.38884e-05 scc=2.97061e-09 $X=83260 $Y=4160
M24 GND 25 CS3 GND g45n1svt L=4.5e-08 W=3.6e-07 AD=5.04e-14 AS=5.04e-14 PD=1e-06 PS=1e-06 fw=3.6e-07 sa=1.4e-07 sb=1.4e-07 sca=3.38446 scb=0.000101379 scc=3.37079e-09 $X=84660 $Y=4160
M25 27 C2 28 GND g45n1svt L=4.5e-08 W=1.08e-06 AD=1.512e-13 AS=1.512e-13 PD=2.44e-06 PS=2.44e-06 fw=1.08e-06 sa=1.4e-07 sb=1.4e-07 sca=2.87541 scb=8.38884e-05 scc=2.97061e-09 $X=95120 $Y=4160
M26 29 13 27 GND g45n1svt L=4.5e-08 W=1.08e-06 AD=1.512e-13 AS=1.512e-13 PD=2.44e-06 PS=2.44e-06 fw=1.08e-06 sa=1.4e-07 sb=1.4e-07 sca=2.87541 scb=8.38884e-05 scc=2.97061e-09 $X=96520 $Y=4160
M27 GND 3 29 GND g45n1svt L=4.5e-08 W=1.08e-06 AD=1.512e-13 AS=1.512e-13 PD=2.44e-06 PS=2.44e-06 fw=1.08e-06 sa=1.4e-07 sb=1.4e-07 sca=2.87541 scb=8.38884e-05 scc=2.97061e-09 $X=97920 $Y=4160
M28 GND 28 CS4 GND g45n1svt L=4.5e-08 W=3.6e-07 AD=5.04e-14 AS=5.04e-14 PD=1e-06 PS=1e-06 fw=3.6e-07 sa=1.4e-07 sb=1.4e-07 sca=3.38446 scb=0.000101379 scc=3.37079e-09 $X=99320 $Y=4160
M29 30 C2 31 GND g45n1svt L=4.5e-08 W=1.08e-06 AD=1.512e-13 AS=1.512e-13 PD=2.44e-06 PS=2.44e-06 fw=1.08e-06 sa=1.4e-07 sb=1.4e-07 sca=2.87541 scb=8.38884e-05 scc=2.97061e-09 $X=109780 $Y=4160
M30 32 13 30 GND g45n1svt L=4.5e-08 W=1.08e-06 AD=1.512e-13 AS=1.512e-13 PD=2.44e-06 PS=2.44e-06 fw=1.08e-06 sa=1.4e-07 sb=1.4e-07 sca=2.87541 scb=8.38884e-05 scc=2.97061e-09 $X=111180 $Y=4160
M31 GND C0 32 GND g45n1svt L=4.5e-08 W=1.08e-06 AD=1.512e-13 AS=1.512e-13 PD=2.44e-06 PS=2.44e-06 fw=1.08e-06 sa=1.4e-07 sb=1.4e-07 sca=2.87541 scb=8.38884e-05 scc=2.97061e-09 $X=112580 $Y=4160
M32 GND 31 CS5 GND g45n1svt L=4.5e-08 W=3.6e-07 AD=5.04e-14 AS=5.04e-14 PD=1e-06 PS=1e-06 fw=3.6e-07 sa=1.4e-07 sb=1.4e-07 sca=3.38446 scb=0.000101379 scc=3.37079e-09 $X=113980 $Y=4160
M33 VDD 14 16 VDD g45p1svt L=4.5e-08 W=3.6e-07 AD=5.04e-14 AS=5.04e-14 PD=1e-06 PS=1e-06 fw=3.6e-07 sa=1.4e-07 sb=1.4e-07 sca=21.3981 scb=0.0224765 scc=0.00127211 $X=37180 $Y=10260
M34 VDD 13 16 VDD g45p1svt L=4.5e-08 W=3.6e-07 AD=5.04e-14 AS=5.04e-14 PD=1e-06 PS=1e-06 fw=3.6e-07 sa=1.4e-07 sb=1.4e-07 sca=19.771 scb=0.0212746 scc=0.00126961 $X=38580 $Y=10260
M35 VDD 3 16 VDD g45p1svt L=4.5e-08 W=3.6e-07 AD=5.04e-14 AS=5.04e-14 PD=1e-06 PS=1e-06 fw=3.6e-07 sa=1.4e-07 sb=1.4e-07 sca=19.771 scb=0.0212746 scc=0.00126961 $X=39980 $Y=10260
M36 VDD 16 CS0 VDD g45p1svt L=4.5e-08 W=3.6e-07 AD=5.04e-14 AS=5.04e-14 PD=1e-06 PS=1e-06 fw=3.6e-07 sa=1.4e-07 sb=1.4e-07 sca=19.771 scb=0.0212746 scc=0.00126961 $X=41380 $Y=10260
M37 VDD 14 19 VDD g45p1svt L=4.5e-08 W=3.6e-07 AD=5.04e-14 AS=5.04e-14 PD=1e-06 PS=1e-06 fw=3.6e-07 sa=1.4e-07 sb=1.4e-07 sca=21.3981 scb=0.0224765 scc=0.00127211 $X=51840 $Y=10260
M38 VDD 13 19 VDD g45p1svt L=4.5e-08 W=3.6e-07 AD=5.04e-14 AS=5.04e-14 PD=1e-06 PS=1e-06 fw=3.6e-07 sa=1.4e-07 sb=1.4e-07 sca=19.771 scb=0.0212746 scc=0.00126961 $X=53240 $Y=10260
M39 VDD C0 19 VDD g45p1svt L=4.5e-08 W=3.6e-07 AD=5.04e-14 AS=5.04e-14 PD=1e-06 PS=1e-06 fw=3.6e-07 sa=1.4e-07 sb=1.4e-07 sca=19.771 scb=0.0212746 scc=0.00126961 $X=54640 $Y=10260
M40 VDD 19 CS1 VDD g45p1svt L=4.5e-08 W=3.6e-07 AD=5.04e-14 AS=5.04e-14 PD=1e-06 PS=1e-06 fw=3.6e-07 sa=1.4e-07 sb=1.4e-07 sca=19.771 scb=0.0212746 scc=0.00126961 $X=56040 $Y=10260
M41 VDD 14 22 VDD g45p1svt L=4.5e-08 W=3.6e-07 AD=5.04e-14 AS=5.04e-14 PD=1e-06 PS=1e-06 fw=3.6e-07 sa=1.4e-07 sb=1.4e-07 sca=21.3981 scb=0.0224765 scc=0.00127211 $X=66500 $Y=10260
M42 VDD C1 22 VDD g45p1svt L=4.5e-08 W=3.6e-07 AD=5.04e-14 AS=5.04e-14 PD=1e-06 PS=1e-06 fw=3.6e-07 sa=1.4e-07 sb=1.4e-07 sca=19.771 scb=0.0212746 scc=0.00126961 $X=67900 $Y=10260
M43 VDD 3 22 VDD g45p1svt L=4.5e-08 W=3.6e-07 AD=5.04e-14 AS=5.04e-14 PD=1e-06 PS=1e-06 fw=3.6e-07 sa=1.4e-07 sb=1.4e-07 sca=19.771 scb=0.0212746 scc=0.00126961 $X=69300 $Y=10260
M44 VDD 22 CS2 VDD g45p1svt L=4.5e-08 W=3.6e-07 AD=5.04e-14 AS=5.04e-14 PD=1e-06 PS=1e-06 fw=3.6e-07 sa=1.4e-07 sb=1.4e-07 sca=19.771 scb=0.0212746 scc=0.00126961 $X=70700 $Y=10260
M45 VDD 14 25 VDD g45p1svt L=4.5e-08 W=3.6e-07 AD=5.04e-14 AS=5.04e-14 PD=1e-06 PS=1e-06 fw=3.6e-07 sa=1.4e-07 sb=1.4e-07 sca=21.3981 scb=0.0224765 scc=0.00127211 $X=81160 $Y=10260
M46 VDD C1 25 VDD g45p1svt L=4.5e-08 W=3.6e-07 AD=5.04e-14 AS=5.04e-14 PD=1e-06 PS=1e-06 fw=3.6e-07 sa=1.4e-07 sb=1.4e-07 sca=19.771 scb=0.0212746 scc=0.00126961 $X=82560 $Y=10260
M47 VDD C0 25 VDD g45p1svt L=4.5e-08 W=3.6e-07 AD=5.04e-14 AS=5.04e-14 PD=1e-06 PS=1e-06 fw=3.6e-07 sa=1.4e-07 sb=1.4e-07 sca=19.771 scb=0.0212746 scc=0.00126961 $X=83960 $Y=10260
M48 VDD 25 CS3 VDD g45p1svt L=4.5e-08 W=3.6e-07 AD=5.04e-14 AS=5.04e-14 PD=1e-06 PS=1e-06 fw=3.6e-07 sa=1.4e-07 sb=1.4e-07 sca=19.771 scb=0.0212746 scc=0.00126961 $X=85360 $Y=10260
M49 VDD C2 28 VDD g45p1svt L=4.5e-08 W=3.6e-07 AD=5.04e-14 AS=5.04e-14 PD=1e-06 PS=1e-06 fw=3.6e-07 sa=1.4e-07 sb=1.4e-07 sca=21.3981 scb=0.0224765 scc=0.00127211 $X=95820 $Y=10260
M50 VDD 13 28 VDD g45p1svt L=4.5e-08 W=3.6e-07 AD=5.04e-14 AS=5.04e-14 PD=1e-06 PS=1e-06 fw=3.6e-07 sa=1.4e-07 sb=1.4e-07 sca=19.771 scb=0.0212746 scc=0.00126961 $X=97220 $Y=10260
M51 VDD 3 28 VDD g45p1svt L=4.5e-08 W=3.6e-07 AD=5.04e-14 AS=5.04e-14 PD=1e-06 PS=1e-06 fw=3.6e-07 sa=1.4e-07 sb=1.4e-07 sca=19.771 scb=0.0212746 scc=0.00126961 $X=98620 $Y=10260
M52 VDD 28 CS4 VDD g45p1svt L=4.5e-08 W=3.6e-07 AD=5.04e-14 AS=5.04e-14 PD=1e-06 PS=1e-06 fw=3.6e-07 sa=1.4e-07 sb=1.4e-07 sca=19.771 scb=0.0212746 scc=0.00126961 $X=100020 $Y=10260
M53 VDD C2 31 VDD g45p1svt L=4.5e-08 W=3.6e-07 AD=5.04e-14 AS=5.04e-14 PD=1e-06 PS=1e-06 fw=3.6e-07 sa=1.4e-07 sb=1.4e-07 sca=21.3981 scb=0.0224765 scc=0.00127211 $X=110480 $Y=10260
M54 VDD 13 31 VDD g45p1svt L=4.5e-08 W=3.6e-07 AD=5.04e-14 AS=5.04e-14 PD=1e-06 PS=1e-06 fw=3.6e-07 sa=1.4e-07 sb=1.4e-07 sca=19.771 scb=0.0212746 scc=0.00126961 $X=111880 $Y=10260
M55 VDD C0 31 VDD g45p1svt L=4.5e-08 W=3.6e-07 AD=5.04e-14 AS=5.04e-14 PD=1e-06 PS=1e-06 fw=3.6e-07 sa=1.4e-07 sb=1.4e-07 sca=19.771 scb=0.0212746 scc=0.00126961 $X=113280 $Y=10260
M56 VDD 31 CS5 VDD g45p1svt L=4.5e-08 W=3.6e-07 AD=5.04e-14 AS=5.04e-14 PD=1e-06 PS=1e-06 fw=3.6e-07 sa=1.4e-07 sb=1.4e-07 sca=19.771 scb=0.0212746 scc=0.00126961 $X=114680 $Y=10260
** N=32 EP=11 NDC=48 FDC=54 HDC=50
.ends column_decoder
