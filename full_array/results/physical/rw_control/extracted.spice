* +++++++++++++++++++++++++++++++++++++++++++++++++++++
* CDL Netlist:
*
* Cell Name: rw_control
* Netlisted: 2026-11-07 03:32:04
* Pegasus 25.14-s010
* +++++++++++++++++++++++++++++++++++++++++++++++++++++
*.LDD

* +++++++++++++++++++++++++++++++++++++++++++++++++++++
* Sub cell: rw_control
* +++++++++++++++++++++++++++++++++++++++++++++++++++++
.subckt rw_control GND RD VDD CLK1 CLK2 WR C2 C1 WEN WENB
+ REN RENB ROWEN PCB
M13 GND RD 3 GND g45n1svt L=4.5e-08 W=3.6e-07 AD=5.04e-14 AS=5.04e-14 PD=1e-06 PS=1e-06 fw=3.6e-07 sa=1.4e-07 sb=1.4e-07 sca=3.70436 scb=0.000161812 scc=1.4064e-08 $X=13420 $Y=2240
M14 GND WR 16 GND g45n1svt L=4.5e-08 W=3.6e-07 AD=5.04e-14 AS=5.04e-14 PD=1e-06 PS=1e-06 fw=3.6e-07 sa=1.4e-07 sb=1.4e-07 sca=3.70436 scb=0.000161812 scc=1.4064e-08 $X=20680 $Y=2240
M15 GND CLK2 PCB GND g45n1svt L=4.5e-08 W=3.6e-07 AD=5.04e-14 AS=5.04e-14 PD=1e-06 PS=1e-06 fw=3.6e-07 sa=1.4e-07 sb=1.4e-07 sca=3.70436 scb=0.000161812 scc=1.4064e-08 $X=27940 $Y=2240
M16 22 C2 23 GND g45n1svt L=4.5e-08 W=1.08e-06 AD=1.512e-13 AS=1.512e-13 PD=2.44e-06 PS=2.44e-06 fw=1.08e-06 sa=1.4e-07 sb=1.4e-07 sca=2.87541 scb=8.38884e-05 scc=2.97061e-09 $X=38400 $Y=4160
M17 24 C1 22 GND g45n1svt L=4.5e-08 W=1.08e-06 AD=1.512e-13 AS=1.512e-13 PD=2.44e-06 PS=2.44e-06 fw=1.08e-06 sa=1.4e-07 sb=1.4e-07 sca=2.87541 scb=8.38884e-05 scc=2.97061e-09 $X=39800 $Y=4160
M18 GND VDD 24 GND g45n1svt L=4.5e-08 W=1.08e-06 AD=1.512e-13 AS=1.512e-13 PD=2.44e-06 PS=2.44e-06 fw=1.08e-06 sa=1.4e-07 sb=1.4e-07 sca=2.87541 scb=8.38884e-05 scc=2.97061e-09 $X=41200 $Y=4160
M19 GND 23 17 GND g45n1svt L=4.5e-08 W=3.6e-07 AD=5.04e-14 AS=5.04e-14 PD=1e-06 PS=1e-06 fw=3.6e-07 sa=1.4e-07 sb=1.4e-07 sca=3.38446 scb=0.000101379 scc=3.37079e-09 $X=42600 $Y=4160
M20 GND 17 18 GND g45n1svt L=4.5e-08 W=3.6e-07 AD=5.04e-14 AS=5.04e-14 PD=1e-06 PS=1e-06 fw=3.6e-07 sa=1.4e-07 sb=1.4e-07 sca=3.70436 scb=0.000161812 scc=1.4064e-08 $X=49860 $Y=2240
M21 25 WR 26 GND g45n1svt L=4.5e-08 W=1.08e-06 AD=1.512e-13 AS=1.512e-13 PD=2.44e-06 PS=2.44e-06 fw=1.08e-06 sa=1.4e-07 sb=1.4e-07 sca=2.87541 scb=8.38884e-05 scc=2.97061e-09 $X=60320 $Y=4160
M22 27 3 25 GND g45n1svt L=4.5e-08 W=1.08e-06 AD=1.512e-13 AS=1.512e-13 PD=2.44e-06 PS=2.44e-06 fw=1.08e-06 sa=1.4e-07 sb=1.4e-07 sca=2.87541 scb=8.38884e-05 scc=2.97061e-09 $X=61720 $Y=4160
M23 GND CLK1 27 GND g45n1svt L=4.5e-08 W=1.08e-06 AD=1.512e-13 AS=1.512e-13 PD=2.44e-06 PS=2.44e-06 fw=1.08e-06 sa=1.4e-07 sb=1.4e-07 sca=2.87541 scb=8.38884e-05 scc=2.97061e-09 $X=63120 $Y=4160
M24 GND 26 19 GND g45n1svt L=4.5e-08 W=3.6e-07 AD=5.04e-14 AS=5.04e-14 PD=1e-06 PS=1e-06 fw=3.6e-07 sa=1.4e-07 sb=1.4e-07 sca=3.38446 scb=0.000101379 scc=3.37079e-09 $X=64520 $Y=4160
M25 28 RD 29 GND g45n1svt L=4.5e-08 W=1.08e-06 AD=1.512e-13 AS=1.512e-13 PD=2.44e-06 PS=2.44e-06 fw=1.08e-06 sa=1.4e-07 sb=1.4e-07 sca=2.87541 scb=8.38884e-05 scc=2.97061e-09 $X=74980 $Y=4160
M26 30 16 28 GND g45n1svt L=4.5e-08 W=1.08e-06 AD=1.512e-13 AS=1.512e-13 PD=2.44e-06 PS=2.44e-06 fw=1.08e-06 sa=1.4e-07 sb=1.4e-07 sca=2.87541 scb=8.38884e-05 scc=2.97061e-09 $X=76380 $Y=4160
M27 GND CLK1 30 GND g45n1svt L=4.5e-08 W=1.08e-06 AD=1.512e-13 AS=1.512e-13 PD=2.44e-06 PS=2.44e-06 fw=1.08e-06 sa=1.4e-07 sb=1.4e-07 sca=2.87541 scb=8.38884e-05 scc=2.97061e-09 $X=77780 $Y=4160
M28 GND 29 20 GND g45n1svt L=4.5e-08 W=3.6e-07 AD=5.04e-14 AS=5.04e-14 PD=1e-06 PS=1e-06 fw=3.6e-07 sa=1.4e-07 sb=1.4e-07 sca=3.38446 scb=0.000101379 scc=3.37079e-09 $X=79180 $Y=4160
M29 31 19 32 GND g45n1svt L=4.5e-08 W=1.08e-06 AD=1.512e-13 AS=1.512e-13 PD=2.44e-06 PS=2.44e-06 fw=1.08e-06 sa=1.4e-07 sb=1.4e-07 sca=2.87541 scb=8.38884e-05 scc=2.97061e-09 $X=89640 $Y=4160
M30 33 18 31 GND g45n1svt L=4.5e-08 W=1.08e-06 AD=1.512e-13 AS=1.512e-13 PD=2.44e-06 PS=2.44e-06 fw=1.08e-06 sa=1.4e-07 sb=1.4e-07 sca=2.87541 scb=8.38884e-05 scc=2.97061e-09 $X=91040 $Y=4160
M31 GND PCB 33 GND g45n1svt L=4.5e-08 W=1.08e-06 AD=1.512e-13 AS=1.512e-13 PD=2.44e-06 PS=2.44e-06 fw=1.08e-06 sa=1.4e-07 sb=1.4e-07 sca=2.87541 scb=8.38884e-05 scc=2.97061e-09 $X=92440 $Y=4160
M32 GND 32 WEN GND g45n1svt L=4.5e-08 W=3.6e-07 AD=5.04e-14 AS=5.04e-14 PD=1e-06 PS=1e-06 fw=3.6e-07 sa=1.4e-07 sb=1.4e-07 sca=3.38446 scb=0.000101379 scc=3.37079e-09 $X=93840 $Y=4160
M33 34 20 35 GND g45n1svt L=4.5e-08 W=1.08e-06 AD=1.512e-13 AS=1.512e-13 PD=2.44e-06 PS=2.44e-06 fw=1.08e-06 sa=1.4e-07 sb=1.4e-07 sca=2.87541 scb=8.38884e-05 scc=2.97061e-09 $X=104300 $Y=4160
M34 36 18 34 GND g45n1svt L=4.5e-08 W=1.08e-06 AD=1.512e-13 AS=1.512e-13 PD=2.44e-06 PS=2.44e-06 fw=1.08e-06 sa=1.4e-07 sb=1.4e-07 sca=2.87541 scb=8.38884e-05 scc=2.97061e-09 $X=105700 $Y=4160
M35 GND PCB 36 GND g45n1svt L=4.5e-08 W=1.08e-06 AD=1.512e-13 AS=1.512e-13 PD=2.44e-06 PS=2.44e-06 fw=1.08e-06 sa=1.4e-07 sb=1.4e-07 sca=2.87541 scb=8.38884e-05 scc=2.97061e-09 $X=107100 $Y=4160
M36 GND 35 REN GND g45n1svt L=4.5e-08 W=3.6e-07 AD=5.04e-14 AS=5.04e-14 PD=1e-06 PS=1e-06 fw=3.6e-07 sa=1.4e-07 sb=1.4e-07 sca=3.38446 scb=0.000101379 scc=3.37079e-09 $X=108500 $Y=4160
M37 GND WEN WENB GND g45n1svt L=4.5e-08 W=3.6e-07 AD=5.04e-14 AS=5.04e-14 PD=1e-06 PS=1e-06 fw=3.6e-07 sa=1.4e-07 sb=1.4e-07 sca=3.70436 scb=0.000161812 scc=1.4064e-08 $X=115760 $Y=2240
M38 GND REN RENB GND g45n1svt L=4.5e-08 W=3.6e-07 AD=5.04e-14 AS=5.04e-14 PD=1e-06 PS=1e-06 fw=3.6e-07 sa=1.4e-07 sb=1.4e-07 sca=3.70436 scb=0.000161812 scc=1.4064e-08 $X=123020 $Y=2240
M39 37 WENB 38 GND g45n1svt L=4.5e-08 W=1.08e-06 AD=1.512e-13 AS=1.512e-13 PD=2.44e-06 PS=2.44e-06 fw=1.08e-06 sa=1.4e-07 sb=1.4e-07 sca=2.87541 scb=8.38884e-05 scc=2.97061e-09 $X=133480 $Y=4160
M40 39 RENB 37 GND g45n1svt L=4.5e-08 W=1.08e-06 AD=1.512e-13 AS=1.512e-13 PD=2.44e-06 PS=2.44e-06 fw=1.08e-06 sa=1.4e-07 sb=1.4e-07 sca=2.87541 scb=8.38884e-05 scc=2.97061e-09 $X=134880 $Y=4160
M41 GND VDD 39 GND g45n1svt L=4.5e-08 W=1.08e-06 AD=1.512e-13 AS=1.512e-13 PD=2.44e-06 PS=2.44e-06 fw=1.08e-06 sa=1.4e-07 sb=1.4e-07 sca=2.87541 scb=8.38884e-05 scc=2.97061e-09 $X=136280 $Y=4160
M42 GND 38 21 GND g45n1svt L=4.5e-08 W=3.6e-07 AD=5.04e-14 AS=5.04e-14 PD=1e-06 PS=1e-06 fw=3.6e-07 sa=1.4e-07 sb=1.4e-07 sca=3.38446 scb=0.000101379 scc=3.37079e-09 $X=137680 $Y=4160
M43 GND 21 ROWEN GND g45n1svt L=4.5e-08 W=3.6e-07 AD=5.04e-14 AS=5.04e-14 PD=1e-06 PS=1e-06 fw=3.6e-07 sa=1.4e-07 sb=1.4e-07 sca=3.70436 scb=0.000161812 scc=1.4064e-08 $X=144940 $Y=2240
M44 VDD RD 3 VDD g45p1svt L=4.5e-08 W=3.6e-07 AD=5.04e-14 AS=5.04e-14 PD=1e-06 PS=1e-06 fw=3.6e-07 sa=1.4e-07 sb=1.4e-07 sca=21.3981 scb=0.0224765 scc=0.00127211 $X=14120 $Y=4980
M45 VDD WR 16 VDD g45p1svt L=4.5e-08 W=3.6e-07 AD=5.04e-14 AS=5.04e-14 PD=1e-06 PS=1e-06 fw=3.6e-07 sa=1.4e-07 sb=1.4e-07 sca=21.3981 scb=0.0224765 scc=0.00127211 $X=21380 $Y=4980
M46 VDD CLK2 PCB VDD g45p1svt L=4.5e-08 W=3.6e-07 AD=5.04e-14 AS=5.04e-14 PD=1e-06 PS=1e-06 fw=3.6e-07 sa=1.4e-07 sb=1.4e-07 sca=21.3981 scb=0.0224765 scc=0.00127211 $X=28640 $Y=4980
M47 VDD C2 23 VDD g45p1svt L=4.5e-08 W=3.6e-07 AD=5.04e-14 AS=5.04e-14 PD=1e-06 PS=1e-06 fw=3.6e-07 sa=1.4e-07 sb=1.4e-07 sca=21.3981 scb=0.0224765 scc=0.00127211 $X=39100 $Y=10260
M48 VDD C1 23 VDD g45p1svt L=4.5e-08 W=3.6e-07 AD=5.04e-14 AS=5.04e-14 PD=1e-06 PS=1e-06 fw=3.6e-07 sa=1.4e-07 sb=1.4e-07 sca=19.771 scb=0.0212746 scc=0.00126961 $X=40500 $Y=10260
M49 VDD VDD 23 VDD g45p1svt L=4.5e-08 W=3.6e-07 AD=5.04e-14 AS=5.04e-14 PD=1e-06 PS=1e-06 fw=3.6e-07 sa=1.4e-07 sb=1.4e-07 sca=19.771 scb=0.0212746 scc=0.00126961 $X=41900 $Y=10260
M50 VDD 23 17 VDD g45p1svt L=4.5e-08 W=3.6e-07 AD=5.04e-14 AS=5.04e-14 PD=1e-06 PS=1e-06 fw=3.6e-07 sa=1.4e-07 sb=1.4e-07 sca=19.771 scb=0.0212746 scc=0.00126961 $X=43300 $Y=10260
M51 VDD 17 18 VDD g45p1svt L=4.5e-08 W=3.6e-07 AD=5.04e-14 AS=5.04e-14 PD=1e-06 PS=1e-06 fw=3.6e-07 sa=1.4e-07 sb=1.4e-07 sca=21.3981 scb=0.0224765 scc=0.00127211 $X=50560 $Y=4980
M52 VDD WR 26 VDD g45p1svt L=4.5e-08 W=3.6e-07 AD=5.04e-14 AS=5.04e-14 PD=1e-06 PS=1e-06 fw=3.6e-07 sa=1.4e-07 sb=1.4e-07 sca=21.3981 scb=0.0224765 scc=0.00127211 $X=61020 $Y=10260
M53 VDD 3 26 VDD g45p1svt L=4.5e-08 W=3.6e-07 AD=5.04e-14 AS=5.04e-14 PD=1e-06 PS=1e-06 fw=3.6e-07 sa=1.4e-07 sb=1.4e-07 sca=19.771 scb=0.0212746 scc=0.00126961 $X=62420 $Y=10260
M54 VDD CLK1 26 VDD g45p1svt L=4.5e-08 W=3.6e-07 AD=5.04e-14 AS=5.04e-14 PD=1e-06 PS=1e-06 fw=3.6e-07 sa=1.4e-07 sb=1.4e-07 sca=19.771 scb=0.0212746 scc=0.00126961 $X=63820 $Y=10260
M55 VDD 26 19 VDD g45p1svt L=4.5e-08 W=3.6e-07 AD=5.04e-14 AS=5.04e-14 PD=1e-06 PS=1e-06 fw=3.6e-07 sa=1.4e-07 sb=1.4e-07 sca=19.771 scb=0.0212746 scc=0.00126961 $X=65220 $Y=10260
M56 VDD RD 29 VDD g45p1svt L=4.5e-08 W=3.6e-07 AD=5.04e-14 AS=5.04e-14 PD=1e-06 PS=1e-06 fw=3.6e-07 sa=1.4e-07 sb=1.4e-07 sca=21.3981 scb=0.0224765 scc=0.00127211 $X=75680 $Y=10260
M57 VDD 16 29 VDD g45p1svt L=4.5e-08 W=3.6e-07 AD=5.04e-14 AS=5.04e-14 PD=1e-06 PS=1e-06 fw=3.6e-07 sa=1.4e-07 sb=1.4e-07 sca=19.771 scb=0.0212746 scc=0.00126961 $X=77080 $Y=10260
M58 VDD CLK1 29 VDD g45p1svt L=4.5e-08 W=3.6e-07 AD=5.04e-14 AS=5.04e-14 PD=1e-06 PS=1e-06 fw=3.6e-07 sa=1.4e-07 sb=1.4e-07 sca=19.771 scb=0.0212746 scc=0.00126961 $X=78480 $Y=10260
M59 VDD 29 20 VDD g45p1svt L=4.5e-08 W=3.6e-07 AD=5.04e-14 AS=5.04e-14 PD=1e-06 PS=1e-06 fw=3.6e-07 sa=1.4e-07 sb=1.4e-07 sca=19.771 scb=0.0212746 scc=0.00126961 $X=79880 $Y=10260
M60 VDD 19 32 VDD g45p1svt L=4.5e-08 W=3.6e-07 AD=5.04e-14 AS=5.04e-14 PD=1e-06 PS=1e-06 fw=3.6e-07 sa=1.4e-07 sb=1.4e-07 sca=21.3981 scb=0.0224765 scc=0.00127211 $X=90340 $Y=10260
M61 VDD 18 32 VDD g45p1svt L=4.5e-08 W=3.6e-07 AD=5.04e-14 AS=5.04e-14 PD=1e-06 PS=1e-06 fw=3.6e-07 sa=1.4e-07 sb=1.4e-07 sca=19.771 scb=0.0212746 scc=0.00126961 $X=91740 $Y=10260
M62 VDD PCB 32 VDD g45p1svt L=4.5e-08 W=3.6e-07 AD=5.04e-14 AS=5.04e-14 PD=1e-06 PS=1e-06 fw=3.6e-07 sa=1.4e-07 sb=1.4e-07 sca=19.771 scb=0.0212746 scc=0.00126961 $X=93140 $Y=10260
M63 VDD 32 WEN VDD g45p1svt L=4.5e-08 W=3.6e-07 AD=5.04e-14 AS=5.04e-14 PD=1e-06 PS=1e-06 fw=3.6e-07 sa=1.4e-07 sb=1.4e-07 sca=19.771 scb=0.0212746 scc=0.00126961 $X=94540 $Y=10260
M64 VDD 20 35 VDD g45p1svt L=4.5e-08 W=3.6e-07 AD=5.04e-14 AS=5.04e-14 PD=1e-06 PS=1e-06 fw=3.6e-07 sa=1.4e-07 sb=1.4e-07 sca=21.3981 scb=0.0224765 scc=0.00127211 $X=105000 $Y=10260
M65 VDD 18 35 VDD g45p1svt L=4.5e-08 W=3.6e-07 AD=5.04e-14 AS=5.04e-14 PD=1e-06 PS=1e-06 fw=3.6e-07 sa=1.4e-07 sb=1.4e-07 sca=19.771 scb=0.0212746 scc=0.00126961 $X=106400 $Y=10260
M66 VDD PCB 35 VDD g45p1svt L=4.5e-08 W=3.6e-07 AD=5.04e-14 AS=5.04e-14 PD=1e-06 PS=1e-06 fw=3.6e-07 sa=1.4e-07 sb=1.4e-07 sca=19.771 scb=0.0212746 scc=0.00126961 $X=107800 $Y=10260
M67 VDD 35 REN VDD g45p1svt L=4.5e-08 W=3.6e-07 AD=5.04e-14 AS=5.04e-14 PD=1e-06 PS=1e-06 fw=3.6e-07 sa=1.4e-07 sb=1.4e-07 sca=19.771 scb=0.0212746 scc=0.00126961 $X=109200 $Y=10260
M68 VDD WEN WENB VDD g45p1svt L=4.5e-08 W=3.6e-07 AD=5.04e-14 AS=5.04e-14 PD=1e-06 PS=1e-06 fw=3.6e-07 sa=1.4e-07 sb=1.4e-07 sca=21.3981 scb=0.0224765 scc=0.00127211 $X=116460 $Y=4980
M69 VDD REN RENB VDD g45p1svt L=4.5e-08 W=3.6e-07 AD=5.04e-14 AS=5.04e-14 PD=1e-06 PS=1e-06 fw=3.6e-07 sa=1.4e-07 sb=1.4e-07 sca=21.3981 scb=0.0224765 scc=0.00127211 $X=123720 $Y=4980
M70 VDD WENB 38 VDD g45p1svt L=4.5e-08 W=3.6e-07 AD=5.04e-14 AS=5.04e-14 PD=1e-06 PS=1e-06 fw=3.6e-07 sa=1.4e-07 sb=1.4e-07 sca=21.3981 scb=0.0224765 scc=0.00127211 $X=134180 $Y=10260
M71 VDD RENB 38 VDD g45p1svt L=4.5e-08 W=3.6e-07 AD=5.04e-14 AS=5.04e-14 PD=1e-06 PS=1e-06 fw=3.6e-07 sa=1.4e-07 sb=1.4e-07 sca=19.771 scb=0.0212746 scc=0.00126961 $X=135580 $Y=10260
M72 VDD VDD 38 VDD g45p1svt L=4.5e-08 W=3.6e-07 AD=5.04e-14 AS=5.04e-14 PD=1e-06 PS=1e-06 fw=3.6e-07 sa=1.4e-07 sb=1.4e-07 sca=19.771 scb=0.0212746 scc=0.00126961 $X=136980 $Y=10260
M73 VDD 38 21 VDD g45p1svt L=4.5e-08 W=3.6e-07 AD=5.04e-14 AS=5.04e-14 PD=1e-06 PS=1e-06 fw=3.6e-07 sa=1.4e-07 sb=1.4e-07 sca=19.771 scb=0.0212746 scc=0.00126961 $X=138380 $Y=10260
M74 VDD 21 ROWEN VDD g45p1svt L=4.5e-08 W=3.6e-07 AD=5.04e-14 AS=5.04e-14 PD=1e-06 PS=1e-06 fw=3.6e-07 sa=1.4e-07 sb=1.4e-07 sca=21.3981 scb=0.0224765 scc=0.00127211 $X=145640 $Y=4980
** N=39 EP=14 NDC=62 FDC=62 HDC=62
.ends rw_control
