* +++++++++++++++++++++++++++++++++++++++++++++++++++++
* CDL Netlist:
*
* Cell Name: column_mux
* Netlisted: 2026-11-07 03:32:47
* Pegasus 25.14-s010
* +++++++++++++++++++++++++++++++++++++++++++++++++++++
*.LDD

* +++++++++++++++++++++++++++++++++++++++++++++++++++++
* Sub cell: column_mux
* +++++++++++++++++++++++++++++++++++++++++++++++++++++
.subckt column_mux GND CS0 CS1 CS2 CS3 CS4 CS5 BL0 BL1 BL2
+ BL3 BL4 BL5 BLB0 BLB1 BLB2 BLB3 BLB4 BLB5 GBL
+ GBLB VDD
M18 GND CS0 3 GND g45n1svt L=4.5e-08 W=3.6e-07 AD=5.04e-14 AS=5.04e-14 PD=1e-06 PS=1e-06 fw=3.6e-07 sa=1.4e-07 sb=1.4e-07 sca=3.70436 scb=0.000161812 scc=1.4064e-08 $X=18540 $Y=2240
M19 BL0 CS0 GBL GND g45n1svt L=4.5e-08 W=1.08e-06 AD=1.512e-13 AS=1.512e-13 PD=2.44e-06 PS=2.44e-06 fw=1.08e-06 sa=1.4e-07 sb=1.4e-07 sca=3.04786 scb=0.000104839 scc=6.53879e-09 $X=27080 $Y=2240
M20 BLB0 CS0 GBLB GND g45n1svt L=4.5e-08 W=1.08e-06 AD=1.512e-13 AS=1.512e-13 PD=2.44e-06 PS=2.44e-06 fw=1.08e-06 sa=1.4e-07 sb=1.4e-07 sca=3.04786 scb=0.000104839 scc=6.53879e-09 $X=35620 $Y=2240
M21 GND CS1 24 GND g45n1svt L=4.5e-08 W=3.6e-07 AD=5.04e-14 AS=5.04e-14 PD=1e-06 PS=1e-06 fw=3.6e-07 sa=1.4e-07 sb=1.4e-07 sca=3.70436 scb=0.000161812 scc=1.4064e-08 $X=42880 $Y=2240
M22 BL1 CS1 GBL GND g45n1svt L=4.5e-08 W=1.08e-06 AD=1.512e-13 AS=1.512e-13 PD=2.44e-06 PS=2.44e-06 fw=1.08e-06 sa=1.4e-07 sb=1.4e-07 sca=3.04786 scb=0.000104839 scc=6.53879e-09 $X=51420 $Y=2240
M23 BLB1 CS1 GBLB GND g45n1svt L=4.5e-08 W=1.08e-06 AD=1.512e-13 AS=1.512e-13 PD=2.44e-06 PS=2.44e-06 fw=1.08e-06 sa=1.4e-07 sb=1.4e-07 sca=3.04786 scb=0.000104839 scc=6.53879e-09 $X=59960 $Y=2240
M24 GND CS2 25 GND g45n1svt L=4.5e-08 W=3.6e-07 AD=5.04e-14 AS=5.04e-14 PD=1e-06 PS=1e-06 fw=3.6e-07 sa=1.4e-07 sb=1.4e-07 sca=3.70436 scb=0.000161812 scc=1.4064e-08 $X=67220 $Y=2240
M25 BL2 CS2 GBL GND g45n1svt L=4.5e-08 W=1.08e-06 AD=1.512e-13 AS=1.512e-13 PD=2.44e-06 PS=2.44e-06 fw=1.08e-06 sa=1.4e-07 sb=1.4e-07 sca=3.04786 scb=0.000104839 scc=6.53879e-09 $X=75760 $Y=2240
M26 BLB2 CS2 GBLB GND g45n1svt L=4.5e-08 W=1.08e-06 AD=1.512e-13 AS=1.512e-13 PD=2.44e-06 PS=2.44e-06 fw=1.08e-06 sa=1.4e-07 sb=1.4e-07 sca=3.04786 scb=0.000104839 scc=6.53879e-09 $X=84300 $Y=2240
M27 GND CS3 26 GND g45n1svt L=4.5e-08 W=3.6e-07 AD=5.04e-14 AS=5.04e-14 PD=1e-06 PS=1e-06 fw=3.6e-07 sa=1.4e-07 sb=1.4e-07 sca=3.70436 scb=0.000161812 scc=1.4064e-08 $X=91560 $Y=2240
M28 BL3 CS3 GBL GND g45n1svt L=4.5e-08 W=1.08e-06 AD=1.512e-13 AS=1.512e-13 PD=2.44e-06 PS=2.44e-06 fw=1.08e-06 sa=1.4e-07 sb=1.4e-07 sca=3.04786 scb=0.000104839 scc=6.53879e-09 $X=100100 $Y=2240
M29 BLB3 CS3 GBLB GND g45n1svt L=4.5e-08 W=1.08e-06 AD=1.512e-13 AS=1.512e-13 PD=2.44e-06 PS=2.44e-06 fw=1.08e-06 sa=1.4e-07 sb=1.4e-07 sca=3.04786 scb=0.000104839 scc=6.53879e-09 $X=108640 $Y=2240
M30 GND CS4 27 GND g45n1svt L=4.5e-08 W=3.6e-07 AD=5.04e-14 AS=5.04e-14 PD=1e-06 PS=1e-06 fw=3.6e-07 sa=1.4e-07 sb=1.4e-07 sca=3.70436 scb=0.000161812 scc=1.4064e-08 $X=115900 $Y=2240
M31 BL4 CS4 GBL GND g45n1svt L=4.5e-08 W=1.08e-06 AD=1.512e-13 AS=1.512e-13 PD=2.44e-06 PS=2.44e-06 fw=1.08e-06 sa=1.4e-07 sb=1.4e-07 sca=3.04786 scb=0.000104839 scc=6.53879e-09 $X=124440 $Y=2240
M32 BLB4 CS4 GBLB GND g45n1svt L=4.5e-08 W=1.08e-06 AD=1.512e-13 AS=1.512e-13 PD=2.44e-06 PS=2.44e-06 fw=1.08e-06 sa=1.4e-07 sb=1.4e-07 sca=3.04786 scb=0.000104839 scc=6.53879e-09 $X=132980 $Y=2240
M33 GND CS5 28 GND g45n1svt L=4.5e-08 W=3.6e-07 AD=5.04e-14 AS=5.04e-14 PD=1e-06 PS=1e-06 fw=3.6e-07 sa=1.4e-07 sb=1.4e-07 sca=3.70436 scb=0.000161812 scc=1.4064e-08 $X=140240 $Y=2240
M34 BL5 CS5 GBL GND g45n1svt L=4.5e-08 W=1.08e-06 AD=1.512e-13 AS=1.512e-13 PD=2.44e-06 PS=2.44e-06 fw=1.08e-06 sa=1.4e-07 sb=1.4e-07 sca=3.04786 scb=0.000104839 scc=6.53879e-09 $X=148780 $Y=2240
M35 BLB5 CS5 GBLB GND g45n1svt L=4.5e-08 W=1.08e-06 AD=1.512e-13 AS=1.512e-13 PD=2.44e-06 PS=2.44e-06 fw=1.08e-06 sa=1.4e-07 sb=1.4e-07 sca=3.04786 scb=0.000104839 scc=6.53879e-09 $X=157320 $Y=2240
M36 VDD CS0 3 VDD g45p1svt L=4.5e-08 W=3.6e-07 AD=5.04e-14 AS=5.04e-14 PD=1e-06 PS=1e-06 fw=3.6e-07 sa=1.4e-07 sb=1.4e-07 sca=21.3981 scb=0.0224765 scc=0.00127211 $X=19240 $Y=4980
M37 BL0 3 GBL VDD g45p1svt L=4.5e-08 W=1.08e-06 AD=1.512e-13 AS=1.512e-13 PD=2.44e-06 PS=2.44e-06 fw=1.08e-06 sa=1.4e-07 sb=1.4e-07 sca=11.3534 scb=0.00879444 scc=0.000426483 $X=27780 $Y=6420
M38 BLB0 3 GBLB VDD g45p1svt L=4.5e-08 W=1.08e-06 AD=1.512e-13 AS=1.512e-13 PD=2.44e-06 PS=2.44e-06 fw=1.08e-06 sa=1.4e-07 sb=1.4e-07 sca=11.3534 scb=0.00879444 scc=0.000426483 $X=36320 $Y=6420
M39 VDD CS1 24 VDD g45p1svt L=4.5e-08 W=3.6e-07 AD=5.04e-14 AS=5.04e-14 PD=1e-06 PS=1e-06 fw=3.6e-07 sa=1.4e-07 sb=1.4e-07 sca=21.3981 scb=0.0224765 scc=0.00127211 $X=43580 $Y=4980
M40 BL1 24 GBL VDD g45p1svt L=4.5e-08 W=1.08e-06 AD=1.512e-13 AS=1.512e-13 PD=2.44e-06 PS=2.44e-06 fw=1.08e-06 sa=1.4e-07 sb=1.4e-07 sca=11.3534 scb=0.00879444 scc=0.000426483 $X=52120 $Y=6420
M41 BLB1 24 GBLB VDD g45p1svt L=4.5e-08 W=1.08e-06 AD=1.512e-13 AS=1.512e-13 PD=2.44e-06 PS=2.44e-06 fw=1.08e-06 sa=1.4e-07 sb=1.4e-07 sca=11.3534 scb=0.00879444 scc=0.000426483 $X=60660 $Y=6420
M42 VDD CS2 25 VDD g45p1svt L=4.5e-08 W=3.6e-07 AD=5.04e-14 AS=5.04e-14 PD=1e-06 PS=1e-06 fw=3.6e-07 sa=1.4e-07 sb=1.4e-07 sca=21.3981 scb=0.0224765 scc=0.00127211 $X=67920 $Y=4980
M43 BL2 25 GBL VDD g45p1svt L=4.5e-08 W=1.08e-06 AD=1.512e-13 AS=1.512e-13 PD=2.44e-06 PS=2.44e-06 fw=1.08e-06 sa=1.4e-07 sb=1.4e-07 sca=11.3534 scb=0.00879444 scc=0.000426483 $X=76460 $Y=6420
M44 BLB2 25 GBLB VDD g45p1svt L=4.5e-08 W=1.08e-06 AD=1.512e-13 AS=1.512e-13 PD=2.44e-06 PS=2.44e-06 fw=1.08e-06 sa=1.4e-07 sb=1.4e-07 sca=11.3534 scb=0.00879444 scc=0.000426483 $X=85000 $Y=6420
M45 VDD CS3 26 VDD g45p1svt L=4.5e-08 W=3.6e-07 AD=5.04e-14 AS=5.04e-14 PD=1e-06 PS=1e-06 fw=3.6e-07 sa=1.4e-07 sb=1.4e-07 sca=21.3981 scb=0.0224765 scc=0.00127211 $X=92260 $Y=4980
M46 BL3 26 GBL VDD g45p1svt L=4.5e-08 W=1.08e-06 AD=1.512e-13 AS=1.512e-13 PD=2.44e-06 PS=2.44e-06 fw=1.08e-06 sa=1.4e-07 sb=1.4e-07 sca=11.3534 scb=0.00879444 scc=0.000426483 $X=100800 $Y=6420
M47 BLB3 26 GBLB VDD g45p1svt L=4.5e-08 W=1.08e-06 AD=1.512e-13 AS=1.512e-13 PD=2.44e-06 PS=2.44e-06 fw=1.08e-06 sa=1.4e-07 sb=1.4e-07 sca=11.3534 scb=0.00879444 scc=0.000426483 $X=109340 $Y=6420
M48 VDD CS4 27 VDD g45p1svt L=4.5e-08 W=3.6e-07 AD=5.04e-14 AS=5.04e-14 PD=1e-06 PS=1e-06 fw=3.6e-07 sa=1.4e-07 sb=1.4e-07 sca=21.3981 scb=0.0224765 scc=0.00127211 $X=116600 $Y=4980
M49 BL4 27 GBL VDD g45p1svt L=4.5e-08 W=1.08e-06 AD=1.512e-13 AS=1.512e-13 PD=2.44e-06 PS=2.44e-06 fw=1.08e-06 sa=1.4e-07 sb=1.4e-07 sca=11.3534 scb=0.00879444 scc=0.000426483 $X=125140 $Y=6420
M50 BLB4 27 GBLB VDD g45p1svt L=4.5e-08 W=1.08e-06 AD=1.512e-13 AS=1.512e-13 PD=2.44e-06 PS=2.44e-06 fw=1.08e-06 sa=1.4e-07 sb=1.4e-07 sca=11.3534 scb=0.00879444 scc=0.000426483 $X=133680 $Y=6420
M51 VDD CS5 28 VDD g45p1svt L=4.5e-08 W=3.6e-07 AD=5.04e-14 AS=5.04e-14 PD=1e-06 PS=1e-06 fw=3.6e-07 sa=1.4e-07 sb=1.4e-07 sca=21.3981 scb=0.0224765 scc=0.00127211 $X=140940 $Y=4980
M52 BL5 28 GBL VDD g45p1svt L=4.5e-08 W=1.08e-06 AD=1.512e-13 AS=1.512e-13 PD=2.44e-06 PS=2.44e-06 fw=1.08e-06 sa=1.4e-07 sb=1.4e-07 sca=11.3534 scb=0.00879444 scc=0.000426483 $X=149480 $Y=6420
M53 BLB5 28 GBLB VDD g45p1svt L=4.5e-08 W=1.08e-06 AD=1.512e-13 AS=1.512e-13 PD=2.44e-06 PS=2.44e-06 fw=1.08e-06 sa=1.4e-07 sb=1.4e-07 sca=11.3534 scb=0.00879444 scc=0.000426483 $X=158020 $Y=6420
** N=28 EP=22 NDC=36 FDC=36 HDC=36
.ends column_mux
