** Layout Netlist, pegasus precompare
**

.subckt column_mux GND CS0 CS1 CS2 CS3 CS4 CS5 BL0 BL1 BL2 BL3 BL4 BL5 BLB0 BLB1 BLB2 BLB3 BLB4 BLB5 GBL
+ GBLB VDD
MM18 GND CS0 3 GND G45N1SVT L=4.5e-08 W=3.6e-07 AD=5.04e-14 AS=5.04e-14 PD=1e-06 PS=1e-06 m=1
MM19 BL0 CS0 GBL GND G45N1SVT L=4.5e-08 W=1.08e-06 AD=1.512e-13 AS=1.512e-13 PD=2.44e-06 PS=2.44e-06 m=1
MM20 BLB0 CS0 GBLB GND G45N1SVT L=4.5e-08 W=1.08e-06 AD=1.512e-13 AS=1.512e-13 PD=2.44e-06 PS=2.44e-06 m=1
MM21 GND CS1 24 GND G45N1SVT L=4.5e-08 W=3.6e-07 AD=5.04e-14 AS=5.04e-14 PD=1e-06 PS=1e-06 m=1
MM22 BL1 CS1 GBL GND G45N1SVT L=4.5e-08 W=1.08e-06 AD=1.512e-13 AS=1.512e-13 PD=2.44e-06 PS=2.44e-06 m=1
MM23 BLB1 CS1 GBLB GND G45N1SVT L=4.5e-08 W=1.08e-06 AD=1.512e-13 AS=1.512e-13 PD=2.44e-06 PS=2.44e-06 m=1
MM24 GND CS2 25 GND G45N1SVT L=4.5e-08 W=3.6e-07 AD=5.04e-14 AS=5.04e-14 PD=1e-06 PS=1e-06 m=1
MM25 BL2 CS2 GBL GND G45N1SVT L=4.5e-08 W=1.08e-06 AD=1.512e-13 AS=1.512e-13 PD=2.44e-06 PS=2.44e-06 m=1
MM26 BLB2 CS2 GBLB GND G45N1SVT L=4.5e-08 W=1.08e-06 AD=1.512e-13 AS=1.512e-13 PD=2.44e-06 PS=2.44e-06 m=1
MM27 GND CS3 26 GND G45N1SVT L=4.5e-08 W=3.6e-07 AD=5.04e-14 AS=5.04e-14 PD=1e-06 PS=1e-06 m=1
MM28 BL3 CS3 GBL GND G45N1SVT L=4.5e-08 W=1.08e-06 AD=1.512e-13 AS=1.512e-13 PD=2.44e-06 PS=2.44e-06 m=1
MM29 BLB3 CS3 GBLB GND G45N1SVT L=4.5e-08 W=1.08e-06 AD=1.512e-13 AS=1.512e-13 PD=2.44e-06 PS=2.44e-06 m=1
MM30 GND CS4 27 GND G45N1SVT L=4.5e-08 W=3.6e-07 AD=5.04e-14 AS=5.04e-14 PD=1e-06 PS=1e-06 m=1
MM31 BL4 CS4 GBL GND G45N1SVT L=4.5e-08 W=1.08e-06 AD=1.512e-13 AS=1.512e-13 PD=2.44e-06 PS=2.44e-06 m=1
MM32 BLB4 CS4 GBLB GND G45N1SVT L=4.5e-08 W=1.08e-06 AD=1.512e-13 AS=1.512e-13 PD=2.44e-06 PS=2.44e-06 m=1
MM33 GND CS5 28 GND G45N1SVT L=4.5e-08 W=3.6e-07 AD=5.04e-14 AS=5.04e-14 PD=1e-06 PS=1e-06 m=1
MM34 BL5 CS5 GBL GND G45N1SVT L=4.5e-08 W=1.08e-06 AD=1.512e-13 AS=1.512e-13 PD=2.44e-06 PS=2.44e-06 m=1
MM35 BLB5 CS5 GBLB GND G45N1SVT L=4.5e-08 W=1.08e-06 AD=1.512e-13 AS=1.512e-13 PD=2.44e-06 PS=2.44e-06 m=1
MM36 VDD CS0 3 VDD G45P1SVT L=4.5e-08 W=3.6e-07 AD=5.04e-14 AS=5.04e-14 PD=1e-06 PS=1e-06 m=1
MM37 BL0 3 GBL VDD G45P1SVT L=4.5e-08 W=1.08e-06 AD=1.512e-13 AS=1.512e-13 PD=2.44e-06 PS=2.44e-06 m=1
MM38 BLB0 3 GBLB VDD G45P1SVT L=4.5e-08 W=1.08e-06 AD=1.512e-13 AS=1.512e-13 PD=2.44e-06 PS=2.44e-06 m=1
MM39 VDD CS1 24 VDD G45P1SVT L=4.5e-08 W=3.6e-07 AD=5.04e-14 AS=5.04e-14 PD=1e-06 PS=1e-06 m=1
MM40 BL1 24 GBL VDD G45P1SVT L=4.5e-08 W=1.08e-06 AD=1.512e-13 AS=1.512e-13 PD=2.44e-06 PS=2.44e-06 m=1
MM41 BLB1 24 GBLB VDD G45P1SVT L=4.5e-08 W=1.08e-06 AD=1.512e-13 AS=1.512e-13 PD=2.44e-06 PS=2.44e-06 m=1
MM42 VDD CS2 25 VDD G45P1SVT L=4.5e-08 W=3.6e-07 AD=5.04e-14 AS=5.04e-14 PD=1e-06 PS=1e-06 m=1
MM43 BL2 25 GBL VDD G45P1SVT L=4.5e-08 W=1.08e-06 AD=1.512e-13 AS=1.512e-13 PD=2.44e-06 PS=2.44e-06 m=1
MM44 BLB2 25 GBLB VDD G45P1SVT L=4.5e-08 W=1.08e-06 AD=1.512e-13 AS=1.512e-13 PD=2.44e-06 PS=2.44e-06 m=1
MM45 VDD CS3 26 VDD G45P1SVT L=4.5e-08 W=3.6e-07 AD=5.04e-14 AS=5.04e-14 PD=1e-06 PS=1e-06 m=1
MM46 BL3 26 GBL VDD G45P1SVT L=4.5e-08 W=1.08e-06 AD=1.512e-13 AS=1.512e-13 PD=2.44e-06 PS=2.44e-06 m=1
MM47 BLB3 26 GBLB VDD G45P1SVT L=4.5e-08 W=1.08e-06 AD=1.512e-13 AS=1.512e-13 PD=2.44e-06 PS=2.44e-06 m=1
MM48 VDD CS4 27 VDD G45P1SVT L=4.5e-08 W=3.6e-07 AD=5.04e-14 AS=5.04e-14 PD=1e-06 PS=1e-06 m=1
MM49 BL4 27 GBL VDD G45P1SVT L=4.5e-08 W=1.08e-06 AD=1.512e-13 AS=1.512e-13 PD=2.44e-06 PS=2.44e-06 m=1
MM50 BLB4 27 GBLB VDD G45P1SVT L=4.5e-08 W=1.08e-06 AD=1.512e-13 AS=1.512e-13 PD=2.44e-06 PS=2.44e-06 m=1
MM51 VDD CS5 28 VDD G45P1SVT L=4.5e-08 W=3.6e-07 AD=5.04e-14 AS=5.04e-14 PD=1e-06 PS=1e-06 m=1
MM52 BL5 28 GBL VDD G45P1SVT L=4.5e-08 W=1.08e-06 AD=1.512e-13 AS=1.512e-13 PD=2.44e-06 PS=2.44e-06 m=1
MM53 BLB5 28 GBLB VDD G45P1SVT L=4.5e-08 W=1.08e-06 AD=1.512e-13 AS=1.512e-13 PD=2.44e-06 PS=2.44e-06 m=1
.ends
