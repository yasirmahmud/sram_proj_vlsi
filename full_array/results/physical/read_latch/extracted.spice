* +++++++++++++++++++++++++++++++++++++++++++++++++++++
* CDL Netlist:
*
* Cell Name: read_latch
* Netlisted: 2026-11-07 03:31:18
* Pegasus 25.14-s010
* +++++++++++++++++++++++++++++++++++++++++++++++++++++
*.LDD

* +++++++++++++++++++++++++++++++++++++++++++++++++++++
* Sub cell: inv
* +++++++++++++++++++++++++++++++++++++++++++++++++++++
.subckt inv GND VDD OUT IN
M0 GND IN OUT GND g45n1svt L=4.5e-08 W=3.6e-07 AD=5.04e-14 AS=5.04e-14 PD=1e-06 PS=1e-06 fw=3.6e-07 sa=1.4e-07 sb=1.4e-07 sca=3.70436 scb=0.000161812 scc=1.4064e-08 $X=3360 $Y=1540
M1 VDD IN OUT VDD g45p1svt L=4.5e-08 W=3.6e-07 AD=5.04e-14 AS=5.04e-14 PD=1e-06 PS=1e-06 fw=3.6e-07 sa=1.4e-07 sb=1.4e-07 sca=21.3981 scb=0.0224765 scc=0.00127211 $X=4060 $Y=4280
** N=4 EP=4 NDC=2 FDC=2 HDC=2
.ends inv

* +++++++++++++++++++++++++++++++++++++++++++++++++++++
* Sub cell: read_latch
* +++++++++++++++++++++++++++++++++++++++++++++++++++++
.subckt read_latch GND VDD D EN ENB Q
X1 GND VDD 3 2 inv $T=13480 700 0 0 $X=13840 $Y=760
X2 GND VDD Q 3 inv $T=20740 700 0 0 $X=21100 $Y=760
M4 D EN 2 GND g45n1svt L=4.5e-08 W=1.08e-06 AD=1.512e-13 AS=1.512e-13 PD=2.44e-06 PS=2.44e-06 fw=1.08e-06 sa=1.4e-07 sb=1.4e-07 sca=3.04786 scb=0.000104839 scc=6.53879e-09 $X=9580 $Y=2240
M5 Q ENB 2 GND g45n1svt L=4.5e-08 W=1.08e-06 AD=1.512e-13 AS=1.512e-13 PD=2.44e-06 PS=2.44e-06 fw=1.08e-06 sa=1.4e-07 sb=1.4e-07 sca=3.04786 scb=0.000104839 scc=6.53879e-09 $X=32640 $Y=2240
M6 D ENB 2 VDD g45p1svt L=4.5e-08 W=1.08e-06 AD=1.512e-13 AS=1.512e-13 PD=2.44e-06 PS=2.44e-06 fw=1.08e-06 sa=1.4e-07 sb=1.4e-07 sca=11.3534 scb=0.00879444 scc=0.000426483 $X=10280 $Y=6420
M7 Q EN 2 VDD g45p1svt L=4.5e-08 W=1.08e-06 AD=1.512e-13 AS=1.512e-13 PD=2.44e-06 PS=2.44e-06 fw=1.08e-06 sa=1.4e-07 sb=1.4e-07 sca=11.3534 scb=0.00879444 scc=0.000426483 $X=33340 $Y=6420
** N=8 EP=6 NDC=4 FDC=8 HDC=6
.ends read_latch
