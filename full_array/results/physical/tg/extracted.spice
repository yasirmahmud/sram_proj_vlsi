* +++++++++++++++++++++++++++++++++++++++++++++++++++++
* CDL Netlist:
*
* Cell Name: tg
* Netlisted: 2026-11-07 03:30:31
* Pegasus 25.14-s010
* +++++++++++++++++++++++++++++++++++++++++++++++++++++
*.LDD

* +++++++++++++++++++++++++++++++++++++++++++++++++++++
* Sub cell: tg
* +++++++++++++++++++++++++++++++++++++++++++++++++++++
.subckt tg GND VDD A B EN ENB
M0 A EN B GND g45n1svt L=4.5e-08 W=1.08e-06 AD=1.512e-13 AS=1.512e-13 PD=2.44e-06 PS=2.44e-06 fw=1.08e-06 sa=1.4e-07 sb=1.4e-07 sca=3.04786 scb=0.000104839 scc=6.53879e-09 $X=4640 $Y=1540
M1 A ENB B VDD g45p1svt L=4.5e-08 W=1.08e-06 AD=1.512e-13 AS=1.512e-13 PD=2.44e-06 PS=2.44e-06 fw=1.08e-06 sa=1.4e-07 sb=1.4e-07 sca=11.3534 scb=0.00879444 scc=0.000426483 $X=5340 $Y=5720
** N=6 EP=6 NDC=2 FDC=2 HDC=2
.ends tg
