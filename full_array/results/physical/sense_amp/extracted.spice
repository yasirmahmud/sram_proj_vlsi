* +++++++++++++++++++++++++++++++++++++++++++++++++++++
* CDL Netlist:
*
* Cell Name: sense_amp
* Netlisted: 2026-11-07 03:31:17
* Pegasus 25.14-s010
* +++++++++++++++++++++++++++++++++++++++++++++++++++++
*.LDD

* +++++++++++++++++++++++++++++++++++++++++++++++++++++
* Sub cell: nmos1v_CDNS_794040246031
* +++++++++++++++++++++++++++++++++++++++++++++++++++++
.subckt nmos1v_CDNS_794040246031 1 2 3
M0 1 2 3 1 g45n1svt L=4.5e-08 W=3.6e-07 AD=5.04e-14 AS=5.04e-14 PD=1e-06 PS=1e-06 fw=3.6e-07 sa=1.4e-07 sb=1.4e-07 sca=3.38446 scb=0.000101379 scc=3.37079e-09 $X=0 $Y=0
** N=3 EP=3 NDC=1 FDC=1 HDC=1
.ends nmos1v_CDNS_794040246031

* +++++++++++++++++++++++++++++++++++++++++++++++++++++
* Sub cell: nmos1v_CDNS_794040246030
* +++++++++++++++++++++++++++++++++++++++++++++++++++++
.subckt nmos1v_CDNS_794040246030 1 2 3 4
M0 3 2 4 1 g45n1svt L=4.5e-08 W=2.4e-07 AD=3.36e-14 AS=3.36e-14 PD=7.6e-07 PS=7.6e-07 fw=2.4e-07 sa=1.4e-07 sb=1.4e-07 sca=3.52678 scb=0.000111658 scc=3.66286e-09 $X=0 $Y=0
** N=4 EP=4 NDC=1 FDC=1 HDC=1
.ends nmos1v_CDNS_794040246030

* +++++++++++++++++++++++++++++++++++++++++++++++++++++
* Sub cell: sense_amp
* +++++++++++++++++++++++++++++++++++++++++++++++++++++
.subckt sense_amp GND VDD AMP_OUT BIT BIT_bar RE
X0 GND BIT 3 4 nmos1v_CDNS_794040246030 $T=6560 3460 0 0 $X=6140 $Y=3260
X1 GND BIT_bar 3 5 nmos1v_CDNS_794040246030 $T=7960 3460 0 0 $X=7540 $Y=3260
X2 GND 4 AMP_OUT nmos1v_CDNS_794040246031 $T=9360 3460 0 0 $X=8940 $Y=3260
X3 GND RE 3 nmos1v_CDNS_794040246031 $T=10760 3460 0 0 $X=10340 $Y=3260
M6 VDD 5 5 VDD g45p1svt L=4.5e-08 W=1.44e-06 AD=2.016e-13 AS=2.016e-13 PD=3.16e-06 PS=3.16e-06 fw=1.44e-06 sa=1.4e-07 sb=1.4e-07 sca=9.63848 scb=0.00691547 scc=0.00032049 $X=7260 $Y=7800
M7 VDD 5 4 VDD g45p1svt L=4.5e-08 W=1.44e-06 AD=2.016e-13 AS=2.016e-13 PD=3.16e-06 PS=3.16e-06 fw=1.44e-06 sa=1.4e-07 sb=1.4e-07 sca=8.01144 scb=0.00571359 scc=0.000317983 $X=8660 $Y=7800
M8 VDD 4 AMP_OUT VDD g45p1svt L=4.5e-08 W=3.6e-07 AD=5.04e-14 AS=5.04e-14 PD=1e-06 PS=1e-06 fw=3.6e-07 sa=1.4e-07 sb=1.4e-07 sca=11.5777 scb=0.010688 scc=0.000634804 $X=10060 $Y=7800
** N=9 EP=6 NDC=3 FDC=7 HDC=5
.ends sense_amp
