** Layout Netlist, pegasus precompare
**

.subckt sense_amp GND VDD AMP_OUT BIT BIT_bar RE
MX2/M0 GND 4 AMP_OUT GND G45N1SVT L=4.5e-08 W=3.6e-07 AD=5.04e-14 AS=5.04e-14 PD=1e-06 PS=1e-06 m=1
MX3/M0 GND RE 3 GND G45N1SVT L=4.5e-08 W=3.6e-07 AD=5.04e-14 AS=5.04e-14 PD=1e-06 PS=1e-06 m=1
MX0/M0 3 BIT 4 GND G45N1SVT L=4.5e-08 W=2.4e-07 AD=3.36e-14 AS=3.36e-14 PD=7.6e-07 PS=7.6e-07 m=1
MX1/M0 3 BIT_bar 5 GND G45N1SVT L=4.5e-08 W=2.4e-07 AD=3.36e-14 AS=3.36e-14 PD=7.6e-07 PS=7.6e-07 m=1
MM6 VDD 5 5 VDD G45P1SVT L=4.5e-08 W=1.44e-06 AD=2.016e-13 AS=2.016e-13 PD=3.16e-06 PS=3.16e-06 m=1
MM7 VDD 5 4 VDD G45P1SVT L=4.5e-08 W=1.44e-06 AD=2.016e-13 AS=2.016e-13 PD=3.16e-06 PS=3.16e-06 m=1
MM8 VDD 4 AMP_OUT VDD G45P1SVT L=4.5e-08 W=3.6e-07 AD=5.04e-14 AS=5.04e-14 PD=1e-06 PS=1e-06 m=1
.ends
