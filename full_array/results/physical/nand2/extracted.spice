* +++++++++++++++++++++++++++++++++++++++++++++++++++++
* CDL Netlist:
*
* Cell Name: nand2
* Netlisted: 2026-11-07 03:30:30
* Pegasus 25.14-s010
* +++++++++++++++++++++++++++++++++++++++++++++++++++++
*.LDD

* +++++++++++++++++++++++++++++++++++++++++++++++++++++
* Sub cell: nmos1v_CDNS_794040200140
* +++++++++++++++++++++++++++++++++++++++++++++++++++++
.subckt nmos1v_CDNS_794040200140 1 2 3 4
M0 3 2 4 1 g45n1svt L=4.5e-08 W=7.2e-07 AD=1.008e-13 AS=1.008e-13 PD=1.72e-06 PS=1.72e-06 fw=7.2e-07 sa=1.4e-07 sb=1.4e-07 sca=3.07667 scb=8.84957e-05 scc=3.0708e-09 $X=0 $Y=0
** N=4 EP=4 NDC=1 FDC=1 HDC=1
.ends nmos1v_CDNS_794040200140

* +++++++++++++++++++++++++++++++++++++++++++++++++++++
* Sub cell: nand2
* +++++++++++++++++++++++++++++++++++++++++++++++++++++
.subckt nand2 GND VDD Y A B
X0 GND A 3 Y nmos1v_CDNS_794040200140 $T=4640 2180 0 0 $X=4220 $Y=1980
X1 GND B GND 3 nmos1v_CDNS_794040200140 $T=6040 2180 0 0 $X=5620 $Y=1980
M4 VDD A Y VDD g45p1svt L=4.5e-08 W=3.6e-07 AD=5.04e-14 AS=5.04e-14 PD=1e-06 PS=1e-06 fw=3.6e-07 sa=1.4e-07 sb=1.4e-07 sca=21.3981 scb=0.0224765 scc=0.00127211 $X=5340 $Y=6280
M5 VDD B Y VDD g45p1svt L=4.5e-08 W=3.6e-07 AD=5.04e-14 AS=5.04e-14 PD=1e-06 PS=1e-06 fw=3.6e-07 sa=1.4e-07 sb=1.4e-07 sca=19.771 scb=0.0212746 scc=0.00126961 $X=6740 $Y=6280
** N=6 EP=5 NDC=2 FDC=4 HDC=3
.ends nand2
