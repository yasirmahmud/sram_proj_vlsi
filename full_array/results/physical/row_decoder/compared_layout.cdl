** Layout Netlist, pegasus precompare
**

.subckt row_decoder GND R0 VDD R1 EN WL0 WL1 WL2 WL3
MX0/M2 GND R0 3 GND G45N1SVT L=4.5e-08 W=3.6e-07 AD=5.04e-14 AS=5.04e-14 PD=1e-06 PS=1e-06 m=1
MX0/M3 VDD R0 3 VDD G45P1SVT L=4.5e-08 W=3.6e-07 AD=5.04e-14 AS=5.04e-14 PD=1e-06 PS=1e-06 m=1
MX1/M2 GND R1 6 GND G45N1SVT L=4.5e-08 W=3.6e-07 AD=5.04e-14 AS=5.04e-14 PD=1e-06 PS=1e-06 m=1
MX1/M3 VDD R1 6 VDD G45P1SVT L=4.5e-08 W=3.6e-07 AD=5.04e-14 AS=5.04e-14 PD=1e-06 PS=1e-06 m=1
MM6 12 6 13 GND G45N1SVT L=4.5e-08 W=1.08e-06 AD=1.512e-13 AS=1.512e-13 PD=2.44e-06 PS=2.44e-06 m=1
MM7 14 3 12 GND G45N1SVT L=4.5e-08 W=1.08e-06 AD=1.512e-13 AS=1.512e-13 PD=2.44e-06 PS=2.44e-06 m=1
MM8 GND EN 14 GND G45N1SVT L=4.5e-08 W=1.08e-06 AD=1.512e-13 AS=1.512e-13 PD=2.44e-06 PS=2.44e-06 m=1
MM9 GND 13 WL0 GND G45N1SVT L=4.5e-08 W=3.6e-07 AD=5.04e-14 AS=5.04e-14 PD=1e-06 PS=1e-06 m=1
MM10 15 6 16 GND G45N1SVT L=4.5e-08 W=1.08e-06 AD=1.512e-13 AS=1.512e-13 PD=2.44e-06 PS=2.44e-06 m=1
MM11 17 R0 15 GND G45N1SVT L=4.5e-08 W=1.08e-06 AD=1.512e-13 AS=1.512e-13 PD=2.44e-06 PS=2.44e-06 m=1
MM12 GND EN 17 GND G45N1SVT L=4.5e-08 W=1.08e-06 AD=1.512e-13 AS=1.512e-13 PD=2.44e-06 PS=2.44e-06 m=1
MM13 GND 16 WL1 GND G45N1SVT L=4.5e-08 W=3.6e-07 AD=5.04e-14 AS=5.04e-14 PD=1e-06 PS=1e-06 m=1
MM14 18 R1 19 GND G45N1SVT L=4.5e-08 W=1.08e-06 AD=1.512e-13 AS=1.512e-13 PD=2.44e-06 PS=2.44e-06 m=1
MM15 20 3 18 GND G45N1SVT L=4.5e-08 W=1.08e-06 AD=1.512e-13 AS=1.512e-13 PD=2.44e-06 PS=2.44e-06 m=1
MM16 GND EN 20 GND G45N1SVT L=4.5e-08 W=1.08e-06 AD=1.512e-13 AS=1.512e-13 PD=2.44e-06 PS=2.44e-06 m=1
MM17 GND 19 WL2 GND G45N1SVT L=4.5e-08 W=3.6e-07 AD=5.04e-14 AS=5.04e-14 PD=1e-06 PS=1e-06 m=1
MM18 21 R1 22 GND G45N1SVT L=4.5e-08 W=1.08e-06 AD=1.512e-13 AS=1.512e-13 PD=2.44e-06 PS=2.44e-06 m=1
MM19 23 R0 21 GND G45N1SVT L=4.5e-08 W=1.08e-06 AD=1.512e-13 AS=1.512e-13 PD=2.44e-06 PS=2.44e-06 m=1
MM20 GND EN 23 GND G45N1SVT L=4.5e-08 W=1.08e-06 AD=1.512e-13 AS=1.512e-13 PD=2.44e-06 PS=2.44e-06 m=1
MM21 GND 22 WL3 GND G45N1SVT L=4.5e-08 W=3.6e-07 AD=5.04e-14 AS=5.04e-14 PD=1e-06 PS=1e-06 m=1
MM22 VDD 6 13 VDD G45P1SVT L=4.5e-08 W=3.6e-07 AD=5.04e-14 AS=5.04e-14 PD=1e-06 PS=1e-06 m=1
MM23 VDD 3 13 VDD G45P1SVT L=4.5e-08 W=3.6e-07 AD=5.04e-14 AS=5.04e-14 PD=1e-06 PS=1e-06 m=1
MM24 VDD EN 13 VDD G45P1SVT L=4.5e-08 W=3.6e-07 AD=5.04e-14 AS=5.04e-14 PD=1e-06 PS=1e-06 m=1
MM25 VDD 13 WL0 VDD G45P1SVT L=4.5e-08 W=3.6e-07 AD=5.04e-14 AS=5.04e-14 PD=1e-06 PS=1e-06 m=1
MM26 VDD 6 16 VDD G45P1SVT L=4.5e-08 W=3.6e-07 AD=5.04e-14 AS=5.04e-14 PD=1e-06 PS=1e-06 m=1
MM27 VDD R0 16 VDD G45P1SVT L=4.5e-08 W=3.6e-07 AD=5.04e-14 AS=5.04e-14 PD=1e-06 PS=1e-06 m=1
MM28 VDD EN 16 VDD G45P1SVT L=4.5e-08 W=3.6e-07 AD=5.04e-14 AS=5.04e-14 PD=1e-06 PS=1e-06 m=1
MM29 VDD 16 WL1 VDD G45P1SVT L=4.5e-08 W=3.6e-07 AD=5.04e-14 AS=5.04e-14 PD=1e-06 PS=1e-06 m=1
MM30 VDD R1 19 VDD G45P1SVT L=4.5e-08 W=3.6e-07 AD=5.04e-14 AS=5.04e-14 PD=1e-06 PS=1e-06 m=1
MM31 VDD 3 19 VDD G45P1SVT L=4.5e-08 W=3.6e-07 AD=5.04e-14 AS=5.04e-14 PD=1e-06 PS=1e-06 m=1
MM32 VDD EN 19 VDD G45P1SVT L=4.5e-08 W=3.6e-07 AD=5.04e-14 AS=5.04e-14 PD=1e-06 PS=1e-06 m=1
MM33 VDD 19 WL2 VDD G45P1SVT L=4.5e-08 W=3.6e-07 AD=5.04e-14 AS=5.04e-14 PD=1e-06 PS=1e-06 m=1
MM34 VDD R1 22 VDD G45P1SVT L=4.5e-08 W=3.6e-07 AD=5.04e-14 AS=5.04e-14 PD=1e-06 PS=1e-06 m=1
MM35 VDD R0 22 VDD G45P1SVT L=4.5e-08 W=3.6e-07 AD=5.04e-14 AS=5.04e-14 PD=1e-06 PS=1e-06 m=1
MM36 VDD EN 22 VDD G45P1SVT L=4.5e-08 W=3.6e-07 AD=5.04e-14 AS=5.04e-14 PD=1e-06 PS=1e-06 m=1
MM37 VDD 22 WL3 VDD G45P1SVT L=4.5e-08 W=3.6e-07 AD=5.04e-14 AS=5.04e-14 PD=1e-06 PS=1e-06 m=1
.ends
