* +++++++++++++++++++++++++++++++++++++++++++++++++++++
* CDL Netlist:
*
* Cell Name: row_decoder
* Netlisted: 2026-11-07 03:31:19
* Pegasus 25.14-s010
* +++++++++++++++++++++++++++++++++++++++++++++++++++++
*.LDD

* +++++++++++++++++++++++++++++++++++++++++++++++++++++
* Sub cell: inv
* +++++++++++++++++++++++++++++++++++++++++++++++++++++
.subckt inv GND VDD OUT IN
M2 GND IN OUT GND g45n1svt L=4.5e-08 W=3.6e-07 AD=5.04e-14 AS=5.04e-14 PD=1e-06 PS=1e-06 fw=3.6e-07 sa=1.4e-07 sb=1.4e-07 sca=3.70436 scb=0.000161812 scc=1.4064e-08 $X=3360 $Y=1540
M3 VDD IN OUT VDD g45p1svt L=4.5e-08 W=3.6e-07 AD=5.04e-14 AS=5.04e-14 PD=1e-06 PS=1e-06 fw=3.6e-07 sa=1.4e-07 sb=1.4e-07 sca=21.3981 scb=0.0224765 scc=0.00127211 $X=4060 $Y=4280
** N=4 EP=4 NDC=2 FDC=2 HDC=2
.ends inv

* +++++++++++++++++++++++++++++++++++++++++++++++++++++
* Sub cell: row_decoder
* +++++++++++++++++++++++++++++++++++++++++++++++++++++
.subckt row_decoder GND R0 VDD R1 EN WL0 WL1 WL2 WL3
X0 GND VDD 3 R0 inv $T=6860 700 0 0 $X=7220 $Y=760
X1 GND VDD 6 R1 inv $T=14120 700 0 0 $X=14480 $Y=760
M6 12 6 13 GND g45n1svt L=4.5e-08 W=1.08e-06 AD=1.512e-13 AS=1.512e-13 PD=2.44e-06 PS=2.44e-06 fw=1.08e-06 sa=1.4e-07 sb=1.4e-07 sca=2.87541 scb=8.38884e-05 scc=2.97061e-09 $X=27940 $Y=4160
M7 14 3 12 GND g45n1svt L=4.5e-08 W=1.08e-06 AD=1.512e-13 AS=1.512e-13 PD=2.44e-06 PS=2.44e-06 fw=1.08e-06 sa=1.4e-07 sb=1.4e-07 sca=2.87541 scb=8.38884e-05 scc=2.97061e-09 $X=29340 $Y=4160
M8 GND EN 14 GND g45n1svt L=4.5e-08 W=1.08e-06 AD=1.512e-13 AS=1.512e-13 PD=2.44e-06 PS=2.44e-06 fw=1.08e-06 sa=1.4e-07 sb=1.4e-07 sca=2.87541 scb=8.38884e-05 scc=2.97061e-09 $X=30740 $Y=4160
M9 GND 13 WL0 GND g45n1svt L=4.5e-08 W=3.6e-07 AD=5.04e-14 AS=5.04e-14 PD=1e-06 PS=1e-06 fw=3.6e-07 sa=1.4e-07 sb=1.4e-07 sca=3.38446 scb=0.000101379 scc=3.37079e-09 $X=32140 $Y=4160
M10 15 6 16 GND g45n1svt L=4.5e-08 W=1.08e-06 AD=1.512e-13 AS=1.512e-13 PD=2.44e-06 PS=2.44e-06 fw=1.08e-06 sa=1.4e-07 sb=1.4e-07 sca=2.87541 scb=8.38884e-05 scc=2.97061e-09 $X=42600 $Y=4160
M11 17 R0 15 GND g45n1svt L=4.5e-08 W=1.08e-06 AD=1.512e-13 AS=1.512e-13 PD=2.44e-06 PS=2.44e-06 fw=1.08e-06 sa=1.4e-07 sb=1.4e-07 sca=2.87541 scb=8.38884e-05 scc=2.97061e-09 $X=44000 $Y=4160
M12 GND EN 17 GND g45n1svt L=4.5e-08 W=1.08e-06 AD=1.512e-13 AS=1.512e-13 PD=2.44e-06 PS=2.44e-06 fw=1.08e-06 sa=1.4e-07 sb=1.4e-07 sca=2.87541 scb=8.38884e-05 scc=2.97061e-09 $X=45400 $Y=4160
M13 GND 16 WL1 GND g45n1svt L=4.5e-08 W=3.6e-07 AD=5.04e-14 AS=5.04e-14 PD=1e-06 PS=1e-06 fw=3.6e-07 sa=1.4e-07 sb=1.4e-07 sca=3.38446 scb=0.000101379 scc=3.37079e-09 $X=46800 $Y=4160
M14 18 R1 19 GND g45n1svt L=4.5e-08 W=1.08e-06 AD=1.512e-13 AS=1.512e-13 PD=2.44e-06 PS=2.44e-06 fw=1.08e-06 sa=1.4e-07 sb=1.4e-07 sca=2.87541 scb=8.38884e-05 scc=2.97061e-09 $X=57260 $Y=4160
M15 20 3 18 GND g45n1svt L=4.5e-08 W=1.08e-06 AD=1.512e-13 AS=1.512e-13 PD=2.44e-06 PS=2.44e-06 fw=1.08e-06 sa=1.4e-07 sb=1.4e-07 sca=2.87541 scb=8.38884e-05 scc=2.97061e-09 $X=58660 $Y=4160
M16 GND EN 20 GND g45n1svt L=4.5e-08 W=1.08e-06 AD=1.512e-13 AS=1.512e-13 PD=2.44e-06 PS=2.44e-06 fw=1.08e-06 sa=1.4e-07 sb=1.4e-07 sca=2.87541 scb=8.38884e-05 scc=2.97061e-09 $X=60060 $Y=4160
M17 GND 19 WL2 GND g45n1svt L=4.5e-08 W=3.6e-07 AD=5.04e-14 AS=5.04e-14 PD=1e-06 PS=1e-06 fw=3.6e-07 sa=1.4e-07 sb=1.4e-07 sca=3.38446 scb=0.000101379 scc=3.37079e-09 $X=61460 $Y=4160
M18 21 R1 22 GND g45n1svt L=4.5e-08 W=1.08e-06 AD=1.512e-13 AS=1.512e-13 PD=2.44e-06 PS=2.44e-06 fw=1.08e-06 sa=1.4e-07 sb=1.4e-07 sca=2.87541 scb=8.38884e-05 scc=2.97061e-09 $X=71920 $Y=4160
M19 23 R0 21 GND g45n1svt L=4.5e-08 W=1.08e-06 AD=1.512e-13 AS=1.512e-13 PD=2.44e-06 PS=2.44e-06 fw=1.08e-06 sa=1.4e-07 sb=1.4e-07 sca=2.87541 scb=8.38884e-05 scc=2.97061e-09 $X=73320 $Y=4160
M20 GND EN 23 GND g45n1svt L=4.5e-08 W=1.08e-06 AD=1.512e-13 AS=1.512e-13 PD=2.44e-06 PS=2.44e-06 fw=1.08e-06 sa=1.4e-07 sb=1.4e-07 sca=2.87541 scb=8.38884e-05 scc=2.97061e-09 $X=74720 $Y=4160
M21 GND 22 WL3 GND g45n1svt L=4.5e-08 W=3.6e-07 AD=5.04e-14 AS=5.04e-14 PD=1e-06 PS=1e-06 fw=3.6e-07 sa=1.4e-07 sb=1.4e-07 sca=3.38446 scb=0.000101379 scc=3.37079e-09 $X=76120 $Y=4160
M22 VDD 6 13 VDD g45p1svt L=4.5e-08 W=3.6e-07 AD=5.04e-14 AS=5.04e-14 PD=1e-06 PS=1e-06 fw=3.6e-07 sa=1.4e-07 sb=1.4e-07 sca=21.3981 scb=0.0224765 scc=0.00127211 $X=28640 $Y=10260
M23 VDD 3 13 VDD g45p1svt L=4.5e-08 W=3.6e-07 AD=5.04e-14 AS=5.04e-14 PD=1e-06 PS=1e-06 fw=3.6e-07 sa=1.4e-07 sb=1.4e-07 sca=19.771 scb=0.0212746 scc=0.00126961 $X=30040 $Y=10260
M24 VDD EN 13 VDD g45p1svt L=4.5e-08 W=3.6e-07 AD=5.04e-14 AS=5.04e-14 PD=1e-06 PS=1e-06 fw=3.6e-07 sa=1.4e-07 sb=1.4e-07 sca=19.771 scb=0.0212746 scc=0.00126961 $X=31440 $Y=10260
M25 VDD 13 WL0 VDD g45p1svt L=4.5e-08 W=3.6e-07 AD=5.04e-14 AS=5.04e-14 PD=1e-06 PS=1e-06 fw=3.6e-07 sa=1.4e-07 sb=1.4e-07 sca=19.771 scb=0.0212746 scc=0.00126961 $X=32840 $Y=10260
M26 VDD 6 16 VDD g45p1svt L=4.5e-08 W=3.6e-07 AD=5.04e-14 AS=5.04e-14 PD=1e-06 PS=1e-06 fw=3.6e-07 sa=1.4e-07 sb=1.4e-07 sca=21.3981 scb=0.0224765 scc=0.00127211 $X=43300 $Y=10260
M27 VDD R0 16 VDD g45p1svt L=4.5e-08 W=3.6e-07 AD=5.04e-14 AS=5.04e-14 PD=1e-06 PS=1e-06 fw=3.6e-07 sa=1.4e-07 sb=1.4e-07 sca=19.771 scb=0.0212746 scc=0.00126961 $X=44700 $Y=10260
M28 VDD EN 16 VDD g45p1svt L=4.5e-08 W=3.6e-07 AD=5.04e-14 AS=5.04e-14 PD=1e-06 PS=1e-06 fw=3.6e-07 sa=1.4e-07 sb=1.4e-07 sca=19.771 scb=0.0212746 scc=0.00126961 $X=46100 $Y=10260
M29 VDD 16 WL1 VDD g45p1svt L=4.5e-08 W=3.6e-07 AD=5.04e-14 AS=5.04e-14 PD=1e-06 PS=1e-06 fw=3.6e-07 sa=1.4e-07 sb=1.4e-07 sca=19.771 scb=0.0212746 scc=0.00126961 $X=47500 $Y=10260
M30 VDD R1 19 VDD g45p1svt L=4.5e-08 W=3.6e-07 AD=5.04e-14 AS=5.04e-14 PD=1e-06 PS=1e-06 fw=3.6e-07 sa=1.4e-07 sb=1.4e-07 sca=21.3981 scb=0.0224765 scc=0.00127211 $X=57960 $Y=10260
M31 VDD 3 19 VDD g45p1svt L=4.5e-08 W=3.6e-07 AD=5.04e-14 AS=5.04e-14 PD=1e-06 PS=1e-06 fw=3.6e-07 sa=1.4e-07 sb=1.4e-07 sca=19.771 scb=0.0212746 scc=0.00126961 $X=59360 $Y=10260
M32 VDD EN 19 VDD g45p1svt L=4.5e-08 W=3.6e-07 AD=5.04e-14 AS=5.04e-14 PD=1e-06 PS=1e-06 fw=3.6e-07 sa=1.4e-07 sb=1.4e-07 sca=19.771 scb=0.0212746 scc=0.00126961 $X=60760 $Y=10260
M33 VDD 19 WL2 VDD g45p1svt L=4.5e-08 W=3.6e-07 AD=5.04e-14 AS=5.04e-14 PD=1e-06 PS=1e-06 fw=3.6e-07 sa=1.4e-07 sb=1.4e-07 sca=19.771 scb=0.0212746 scc=0.00126961 $X=62160 $Y=10260
M34 VDD R1 22 VDD g45p1svt L=4.5e-08 W=3.6e-07 AD=5.04e-14 AS=5.04e-14 PD=1e-06 PS=1e-06 fw=3.6e-07 sa=1.4e-07 sb=1.4e-07 sca=21.3981 scb=0.0224765 scc=0.00127211 $X=72620 $Y=10260
M35 VDD R0 22 VDD g45p1svt L=4.5e-08 W=3.6e-07 AD=5.04e-14 AS=5.04e-14 PD=1e-06 PS=1e-06 fw=3.6e-07 sa=1.4e-07 sb=1.4e-07 sca=19.771 scb=0.0212746 scc=0.00126961 $X=74020 $Y=10260
M36 VDD EN 22 VDD g45p1svt L=4.5e-08 W=3.6e-07 AD=5.04e-14 AS=5.04e-14 PD=1e-06 PS=1e-06 fw=3.6e-07 sa=1.4e-07 sb=1.4e-07 sca=19.771 scb=0.0212746 scc=0.00126961 $X=75420 $Y=10260
M37 VDD 22 WL3 VDD g45p1svt L=4.5e-08 W=3.6e-07 AD=5.04e-14 AS=5.04e-14 PD=1e-06 PS=1e-06 fw=3.6e-07 sa=1.4e-07 sb=1.4e-07 sca=19.771 scb=0.0212746 scc=0.00126961 $X=76820 $Y=10260
** N=23 EP=9 NDC=32 FDC=36 HDC=34
.ends row_decoder
