* +++++++++++++++++++++++++++++++++++++++++++++++++++++
* CDL Netlist:
*
* Cell Name: and3
* Netlisted: 2026-11-07 03:29:46
* Pegasus 25.14-s010
* +++++++++++++++++++++++++++++++++++++++++++++++++++++
*.LDD

* +++++++++++++++++++++++++++++++++++++++++++++++++++++
* Sub cell: nmos1v_CDNS_794040155650
* +++++++++++++++++++++++++++++++++++++++++++++++++++++
.subckt nmos1v_CDNS_794040155650 1 2 3 4
M0 3 2 4 1 g45n1svt L=4.5e-08 W=1.08e-06 AD=1.512e-13 AS=1.512e-13 PD=2.44e-06 PS=2.44e-06 fw=1.08e-06 sa=1.4e-07 sb=1.4e-07 sca=2.87541 scb=8.38884e-05 scc=2.97061e-09 $X=0 $Y=0
** N=4 EP=4 NDC=1 FDC=1 HDC=1
.ends nmos1v_CDNS_794040155650

* +++++++++++++++++++++++++++++++++++++++++++++++++++++
* Sub cell: and3
* +++++++++++++++++++++++++++++++++++++++++++++++++++++
.subckt and3 GND VDD Y A B E
X0 GND A 3 4 nmos1v_CDNS_794040155650 $T=6560 3460 0 0 $X=6140 $Y=3260
X1 GND B 5 3 nmos1v_CDNS_794040155650 $T=7960 3460 0 0 $X=7540 $Y=3260
X2 GND E GND 5 nmos1v_CDNS_794040155650 $T=9360 3460 0 0 $X=8940 $Y=3260
M7 GND 4 Y GND g45n1svt L=4.5e-08 W=3.6e-07 AD=5.04e-14 AS=5.04e-14 PD=1e-06 PS=1e-06 fw=3.6e-07 sa=1.4e-07 sb=1.4e-07 sca=3.38446 scb=0.000101379 scc=3.37079e-09 $X=10760 $Y=3460
M8 VDD A 4 VDD g45p1svt L=4.5e-08 W=3.6e-07 AD=5.04e-14 AS=5.04e-14 PD=1e-06 PS=1e-06 fw=3.6e-07 sa=1.4e-07 sb=1.4e-07 sca=21.3981 scb=0.0224765 scc=0.00127211 $X=7260 $Y=9560
M9 VDD B 4 VDD g45p1svt L=4.5e-08 W=3.6e-07 AD=5.04e-14 AS=5.04e-14 PD=1e-06 PS=1e-06 fw=3.6e-07 sa=1.4e-07 sb=1.4e-07 sca=19.771 scb=0.0212746 scc=0.00126961 $X=8660 $Y=9560
M10 VDD E 4 VDD g45p1svt L=4.5e-08 W=3.6e-07 AD=5.04e-14 AS=5.04e-14 PD=1e-06 PS=1e-06 fw=3.6e-07 sa=1.4e-07 sb=1.4e-07 sca=19.771 scb=0.0212746 scc=0.00126961 $X=10060 $Y=9560
M11 VDD 4 Y VDD g45p1svt L=4.5e-08 W=3.6e-07 AD=5.04e-14 AS=5.04e-14 PD=1e-06 PS=1e-06 fw=3.6e-07 sa=1.4e-07 sb=1.4e-07 sca=19.771 scb=0.0212746 scc=0.00126961 $X=11460 $Y=9560
** N=9 EP=6 NDC=5 FDC=8 HDC=6
.ends and3
