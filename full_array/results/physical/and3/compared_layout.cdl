** Layout Netlist, pegasus precompare
**

.subckt and3 GND VDD Y A B E
MX0/M0 3 A 4 GND G45N1SVT L=4.5e-08 W=1.08e-06 AD=1.512e-13 AS=1.512e-13 PD=2.44e-06 PS=2.44e-06 m=1
MX1/M0 5 B 3 GND G45N1SVT L=4.5e-08 W=1.08e-06 AD=1.512e-13 AS=1.512e-13 PD=2.44e-06 PS=2.44e-06 m=1
MX2/M0 GND E 5 GND G45N1SVT L=4.5e-08 W=1.08e-06 AD=1.512e-13 AS=1.512e-13 PD=2.44e-06 PS=2.44e-06 m=1
MM7 GND 4 Y GND G45N1SVT L=4.5e-08 W=3.6e-07 AD=5.04e-14 AS=5.04e-14 PD=1e-06 PS=1e-06 m=1
MM8 VDD A 4 VDD G45P1SVT L=4.5e-08 W=3.6e-07 AD=5.04e-14 AS=5.04e-14 PD=1e-06 PS=1e-06 m=1
MM9 VDD B 4 VDD G45P1SVT L=4.5e-08 W=3.6e-07 AD=5.04e-14 AS=5.04e-14 PD=1e-06 PS=1e-06 m=1
MM10 VDD E 4 VDD G45P1SVT L=4.5e-08 W=3.6e-07 AD=5.04e-14 AS=5.04e-14 PD=1e-06 PS=1e-06 m=1
MM11 VDD 4 Y VDD G45P1SVT L=4.5e-08 W=3.6e-07 AD=5.04e-14 AS=5.04e-14 PD=1e-06 PS=1e-06 m=1
.ends
