* +++++++++++++++++++++++++++++++++++++++++++++++++++++
* CDL Netlist:
*
* Cell Name: precharge
* Netlisted: 2026-11-07 03:32:49
* Pegasus 25.14-s010
* +++++++++++++++++++++++++++++++++++++++++++++++++++++
*.LDD

* +++++++++++++++++++++++++++++++++++++++++++++++++++++
* Sub cell: precharge
* +++++++++++++++++++++++++++++++++++++++++++++++++++++
.subckt precharge GND BL0 BLB0 PCB VDD BL1 BL2 BL3 BL4 BL5
+ BLB1 BLB2 BLB3 BLB4 BLB5
M6 VDD PCB BL0 VDD g45p1svt L=4.5e-08 W=1.08e-06 AD=1.512e-13 AS=1.512e-13 PD=2.44e-06 PS=2.44e-06 fw=1.08e-06 sa=1.4e-07 sb=1.4e-07 sca=11.3534 scb=0.00879444 scc=0.000426483 $X=15400 $Y=3940
M7 VDD PCB BLB0 VDD g45p1svt L=4.5e-08 W=1.08e-06 AD=1.512e-13 AS=1.512e-13 PD=2.44e-06 PS=2.44e-06 fw=1.08e-06 sa=1.4e-07 sb=1.4e-07 sca=9.72638 scb=0.00759256 scc=0.000423976 $X=16800 $Y=3940
M8 BLB0 PCB BL0 VDD g45p1svt L=4.5e-08 W=1.08e-06 AD=1.512e-13 AS=1.512e-13 PD=2.44e-06 PS=2.44e-06 fw=1.08e-06 sa=1.4e-07 sb=1.4e-07 sca=9.72638 scb=0.00759256 scc=0.000423976 $X=18200 $Y=3940
M9 VDD PCB BL1 VDD g45p1svt L=4.5e-08 W=1.08e-06 AD=1.512e-13 AS=1.512e-13 PD=2.44e-06 PS=2.44e-06 fw=1.08e-06 sa=1.4e-07 sb=1.4e-07 sca=11.3534 scb=0.00879444 scc=0.000426483 $X=26100 $Y=3940
M10 VDD PCB BLB1 VDD g45p1svt L=4.5e-08 W=1.08e-06 AD=1.512e-13 AS=1.512e-13 PD=2.44e-06 PS=2.44e-06 fw=1.08e-06 sa=1.4e-07 sb=1.4e-07 sca=9.72638 scb=0.00759256 scc=0.000423976 $X=27500 $Y=3940
M11 BLB1 PCB BL1 VDD g45p1svt L=4.5e-08 W=1.08e-06 AD=1.512e-13 AS=1.512e-13 PD=2.44e-06 PS=2.44e-06 fw=1.08e-06 sa=1.4e-07 sb=1.4e-07 sca=9.72638 scb=0.00759256 scc=0.000423976 $X=28900 $Y=3940
M12 VDD PCB BL2 VDD g45p1svt L=4.5e-08 W=1.08e-06 AD=1.512e-13 AS=1.512e-13 PD=2.44e-06 PS=2.44e-06 fw=1.08e-06 sa=1.4e-07 sb=1.4e-07 sca=11.3534 scb=0.00879444 scc=0.000426483 $X=36800 $Y=3940
M13 VDD PCB BLB2 VDD g45p1svt L=4.5e-08 W=1.08e-06 AD=1.512e-13 AS=1.512e-13 PD=2.44e-06 PS=2.44e-06 fw=1.08e-06 sa=1.4e-07 sb=1.4e-07 sca=9.72638 scb=0.00759256 scc=0.000423976 $X=38200 $Y=3940
M14 BLB2 PCB BL2 VDD g45p1svt L=4.5e-08 W=1.08e-06 AD=1.512e-13 AS=1.512e-13 PD=2.44e-06 PS=2.44e-06 fw=1.08e-06 sa=1.4e-07 sb=1.4e-07 sca=9.72638 scb=0.00759256 scc=0.000423976 $X=39600 $Y=3940
M15 VDD PCB BL3 VDD g45p1svt L=4.5e-08 W=1.08e-06 AD=1.512e-13 AS=1.512e-13 PD=2.44e-06 PS=2.44e-06 fw=1.08e-06 sa=1.4e-07 sb=1.4e-07 sca=11.3534 scb=0.00879444 scc=0.000426483 $X=47500 $Y=3940
M16 VDD PCB BLB3 VDD g45p1svt L=4.5e-08 W=1.08e-06 AD=1.512e-13 AS=1.512e-13 PD=2.44e-06 PS=2.44e-06 fw=1.08e-06 sa=1.4e-07 sb=1.4e-07 sca=9.72638 scb=0.00759256 scc=0.000423976 $X=48900 $Y=3940
M17 BLB3 PCB BL3 VDD g45p1svt L=4.5e-08 W=1.08e-06 AD=1.512e-13 AS=1.512e-13 PD=2.44e-06 PS=2.44e-06 fw=1.08e-06 sa=1.4e-07 sb=1.4e-07 sca=9.72638 scb=0.00759256 scc=0.000423976 $X=50300 $Y=3940
M18 VDD PCB BL4 VDD g45p1svt L=4.5e-08 W=1.08e-06 AD=1.512e-13 AS=1.512e-13 PD=2.44e-06 PS=2.44e-06 fw=1.08e-06 sa=1.4e-07 sb=1.4e-07 sca=11.3534 scb=0.00879444 scc=0.000426483 $X=58200 $Y=3940
M19 VDD PCB BLB4 VDD g45p1svt L=4.5e-08 W=1.08e-06 AD=1.512e-13 AS=1.512e-13 PD=2.44e-06 PS=2.44e-06 fw=1.08e-06 sa=1.4e-07 sb=1.4e-07 sca=9.72638 scb=0.00759256 scc=0.000423976 $X=59600 $Y=3940
M20 BLB4 PCB BL4 VDD g45p1svt L=4.5e-08 W=1.08e-06 AD=1.512e-13 AS=1.512e-13 PD=2.44e-06 PS=2.44e-06 fw=1.08e-06 sa=1.4e-07 sb=1.4e-07 sca=9.72638 scb=0.00759256 scc=0.000423976 $X=61000 $Y=3940
M21 VDD PCB BL5 VDD g45p1svt L=4.5e-08 W=1.08e-06 AD=1.512e-13 AS=1.512e-13 PD=2.44e-06 PS=2.44e-06 fw=1.08e-06 sa=1.4e-07 sb=1.4e-07 sca=11.3534 scb=0.00879444 scc=0.000426483 $X=68900 $Y=3940
M22 VDD PCB BLB5 VDD g45p1svt L=4.5e-08 W=1.08e-06 AD=1.512e-13 AS=1.512e-13 PD=2.44e-06 PS=2.44e-06 fw=1.08e-06 sa=1.4e-07 sb=1.4e-07 sca=9.72638 scb=0.00759256 scc=0.000423976 $X=70300 $Y=3940
M23 BLB5 PCB BL5 VDD g45p1svt L=4.5e-08 W=1.08e-06 AD=1.512e-13 AS=1.512e-13 PD=2.44e-06 PS=2.44e-06 fw=1.08e-06 sa=1.4e-07 sb=1.4e-07 sca=9.72638 scb=0.00759256 scc=0.000423976 $X=71700 $Y=3940
** N=15 EP=15 NDC=18 FDC=18 HDC=18
.ends precharge
