w=deOpenCellView("sram_project" "inv" "schematic" "schematic" nil "r")
hiExportImage(?fileName "/ecel/UFAD/ymahmud/vlsi_sram_project/project_file/full_array/results/figures/inv_schematic.png" ?window w ?exportRegion 'entireDesign ?width 2400)
w=deOpenCellView("sram_project" "inv" "symbol" "schematicSymbol" nil "r")
hiExportImage(?fileName "/ecel/UFAD/ymahmud/vlsi_sram_project/project_file/full_array/results/figures/inv_symbol.png" ?window w ?exportRegion 'entireDesign ?width 1000)
w=deOpenCellView("sram_project" "inv" "layout" "maskLayout" nil "r")
geSetAreaViewLevel(w w~>cellView~>bBox 0 32)
foreach(layer '("Metal1" "Metal2" "Metal3" "Metal4" "Metal5" "Metal6" "Metal7") leSetLayerVisible(list(layer "pin") nil) leSetLayerVisible(list(layer "label") nil))
hiExportImage(?fileName "/ecel/UFAD/ymahmud/vlsi_sram_project/project_file/full_array/results/figures/inv_layout.png" ?window w ?exportRegion 'entireDesign ?width 2400)
w=deOpenCellView("sram_project" "nand2" "schematic" "schematic" nil "r")
hiExportImage(?fileName "/ecel/UFAD/ymahmud/vlsi_sram_project/project_file/full_array/results/figures/nand2_schematic.png" ?window w ?exportRegion 'entireDesign ?width 2400)
w=deOpenCellView("sram_project" "nand2" "symbol" "schematicSymbol" nil "r")
hiExportImage(?fileName "/ecel/UFAD/ymahmud/vlsi_sram_project/project_file/full_array/results/figures/nand2_symbol.png" ?window w ?exportRegion 'entireDesign ?width 1000)
w=deOpenCellView("sram_project" "nand2" "layout" "maskLayout" nil "r")
geSetAreaViewLevel(w w~>cellView~>bBox 0 32)
foreach(layer '("Metal1" "Metal2" "Metal3" "Metal4" "Metal5" "Metal6" "Metal7") leSetLayerVisible(list(layer "pin") nil) leSetLayerVisible(list(layer "label") nil))
hiExportImage(?fileName "/ecel/UFAD/ymahmud/vlsi_sram_project/project_file/full_array/results/figures/nand2_layout.png" ?window w ?exportRegion 'entireDesign ?width 2400)
w=deOpenCellView("sram_project" "nand3" "schematic" "schematic" nil "r")
hiExportImage(?fileName "/ecel/UFAD/ymahmud/vlsi_sram_project/project_file/full_array/results/figures/nand3_schematic.png" ?window w ?exportRegion 'entireDesign ?width 2400)
w=deOpenCellView("sram_project" "nand3" "symbol" "schematicSymbol" nil "r")
hiExportImage(?fileName "/ecel/UFAD/ymahmud/vlsi_sram_project/project_file/full_array/results/figures/nand3_symbol.png" ?window w ?exportRegion 'entireDesign ?width 1000)
w=deOpenCellView("sram_project" "nand3" "layout" "maskLayout" nil "r")
geSetAreaViewLevel(w w~>cellView~>bBox 0 32)
foreach(layer '("Metal1" "Metal2" "Metal3" "Metal4" "Metal5" "Metal6" "Metal7") leSetLayerVisible(list(layer "pin") nil) leSetLayerVisible(list(layer "label") nil))
hiExportImage(?fileName "/ecel/UFAD/ymahmud/vlsi_sram_project/project_file/full_array/results/figures/nand3_layout.png" ?window w ?exportRegion 'entireDesign ?width 2400)
w=deOpenCellView("sram_project" "and3" "schematic" "schematic" nil "r")
hiExportImage(?fileName "/ecel/UFAD/ymahmud/vlsi_sram_project/project_file/full_array/results/figures/and3_schematic.png" ?window w ?exportRegion 'entireDesign ?width 2400)
w=deOpenCellView("sram_project" "and3" "symbol" "schematicSymbol" nil "r")
hiExportImage(?fileName "/ecel/UFAD/ymahmud/vlsi_sram_project/project_file/full_array/results/figures/and3_symbol.png" ?window w ?exportRegion 'entireDesign ?width 1000)
w=deOpenCellView("sram_project" "and3" "layout" "maskLayout" nil "r")
geSetAreaViewLevel(w w~>cellView~>bBox 0 32)
foreach(layer '("Metal1" "Metal2" "Metal3" "Metal4" "Metal5" "Metal6" "Metal7") leSetLayerVisible(list(layer "pin") nil) leSetLayerVisible(list(layer "label") nil))
hiExportImage(?fileName "/ecel/UFAD/ymahmud/vlsi_sram_project/project_file/full_array/results/figures/and3_layout.png" ?window w ?exportRegion 'entireDesign ?width 2400)
w=deOpenCellView("sram_project" "bitcell" "schematic" "schematic" nil "r")
hiExportImage(?fileName "/ecel/UFAD/ymahmud/vlsi_sram_project/project_file/full_array/results/figures/bitcell_schematic.png" ?window w ?exportRegion 'entireDesign ?width 2400)
w=deOpenCellView("sram_project" "bitcell" "symbol" "schematicSymbol" nil "r")
hiExportImage(?fileName "/ecel/UFAD/ymahmud/vlsi_sram_project/project_file/full_array/results/figures/bitcell_symbol.png" ?window w ?exportRegion 'entireDesign ?width 1000)
w=deOpenCellView("sram_project" "bitcell" "layout" "maskLayout" nil "r")
geSetAreaViewLevel(w w~>cellView~>bBox 0 32)
foreach(layer '("Metal1" "Metal2" "Metal3" "Metal4" "Metal5" "Metal6" "Metal7") leSetLayerVisible(list(layer "pin") nil) leSetLayerVisible(list(layer "label") nil))
hiExportImage(?fileName "/ecel/UFAD/ymahmud/vlsi_sram_project/project_file/full_array/results/figures/bitcell_layout.png" ?window w ?exportRegion 'entireDesign ?width 2400)
w=deOpenCellView("sram_project" "row_decoder" "schematic" "schematic" nil "r")
hiExportImage(?fileName "/ecel/UFAD/ymahmud/vlsi_sram_project/project_file/full_array/results/figures/row_decoder_schematic.png" ?window w ?exportRegion 'entireDesign ?width 2400)
w=deOpenCellView("sram_project" "row_decoder" "symbol" "schematicSymbol" nil "r")
hiExportImage(?fileName "/ecel/UFAD/ymahmud/vlsi_sram_project/project_file/full_array/results/figures/row_decoder_symbol.png" ?window w ?exportRegion 'entireDesign ?width 1000)
w=deOpenCellView("sram_project" "row_decoder" "layout" "maskLayout" nil "r")
geSetAreaViewLevel(w w~>cellView~>bBox 0 32)
foreach(layer '("Metal1" "Metal2" "Metal3" "Metal4" "Metal5" "Metal6" "Metal7") leSetLayerVisible(list(layer "pin") nil) leSetLayerVisible(list(layer "label") nil))
hiExportImage(?fileName "/ecel/UFAD/ymahmud/vlsi_sram_project/project_file/full_array/results/figures/row_decoder_layout.png" ?window w ?exportRegion 'entireDesign ?width 2400)
w=deOpenCellView("sram_project" "column_decoder" "schematic" "schematic" nil "r")
hiExportImage(?fileName "/ecel/UFAD/ymahmud/vlsi_sram_project/project_file/full_array/results/figures/column_decoder_schematic.png" ?window w ?exportRegion 'entireDesign ?width 2400)
w=deOpenCellView("sram_project" "column_decoder" "symbol" "schematicSymbol" nil "r")
hiExportImage(?fileName "/ecel/UFAD/ymahmud/vlsi_sram_project/project_file/full_array/results/figures/column_decoder_symbol.png" ?window w ?exportRegion 'entireDesign ?width 1000)
w=deOpenCellView("sram_project" "column_decoder" "layout" "maskLayout" nil "r")
geSetAreaViewLevel(w w~>cellView~>bBox 0 32)
foreach(layer '("Metal1" "Metal2" "Metal3" "Metal4" "Metal5" "Metal6" "Metal7") leSetLayerVisible(list(layer "pin") nil) leSetLayerVisible(list(layer "label") nil))
hiExportImage(?fileName "/ecel/UFAD/ymahmud/vlsi_sram_project/project_file/full_array/results/figures/column_decoder_layout.png" ?window w ?exportRegion 'entireDesign ?width 2400)
w=deOpenCellView("sram_project" "rw_control" "schematic" "schematic" nil "r")
hiExportImage(?fileName "/ecel/UFAD/ymahmud/vlsi_sram_project/project_file/full_array/results/figures/rw_control_schematic.png" ?window w ?exportRegion 'entireDesign ?width 2400)
w=deOpenCellView("sram_project" "rw_control" "symbol" "schematicSymbol" nil "r")
hiExportImage(?fileName "/ecel/UFAD/ymahmud/vlsi_sram_project/project_file/full_array/results/figures/rw_control_symbol.png" ?window w ?exportRegion 'entireDesign ?width 1000)
w=deOpenCellView("sram_project" "rw_control" "layout" "maskLayout" nil "r")
geSetAreaViewLevel(w w~>cellView~>bBox 0 32)
foreach(layer '("Metal1" "Metal2" "Metal3" "Metal4" "Metal5" "Metal6" "Metal7") leSetLayerVisible(list(layer "pin") nil) leSetLayerVisible(list(layer "label") nil))
hiExportImage(?fileName "/ecel/UFAD/ymahmud/vlsi_sram_project/project_file/full_array/results/figures/rw_control_layout.png" ?window w ?exportRegion 'entireDesign ?width 2400)
w=deOpenCellView("sram_project" "write_driver" "schematic" "schematic" nil "r")
hiExportImage(?fileName "/ecel/UFAD/ymahmud/vlsi_sram_project/project_file/full_array/results/figures/write_driver_schematic.png" ?window w ?exportRegion 'entireDesign ?width 2400)
w=deOpenCellView("sram_project" "write_driver" "symbol" "schematicSymbol" nil "r")
hiExportImage(?fileName "/ecel/UFAD/ymahmud/vlsi_sram_project/project_file/full_array/results/figures/write_driver_symbol.png" ?window w ?exportRegion 'entireDesign ?width 1000)
w=deOpenCellView("sram_project" "write_driver" "layout" "maskLayout" nil "r")
geSetAreaViewLevel(w w~>cellView~>bBox 0 32)
foreach(layer '("Metal1" "Metal2" "Metal3" "Metal4" "Metal5" "Metal6" "Metal7") leSetLayerVisible(list(layer "pin") nil) leSetLayerVisible(list(layer "label") nil))
hiExportImage(?fileName "/ecel/UFAD/ymahmud/vlsi_sram_project/project_file/full_array/results/figures/write_driver_layout.png" ?window w ?exportRegion 'entireDesign ?width 2400)
w=deOpenCellView("sram_project" "column_mux" "schematic" "schematic" nil "r")
hiExportImage(?fileName "/ecel/UFAD/ymahmud/vlsi_sram_project/project_file/full_array/results/figures/column_mux_schematic.png" ?window w ?exportRegion 'entireDesign ?width 2400)
w=deOpenCellView("sram_project" "column_mux" "symbol" "schematicSymbol" nil "r")
hiExportImage(?fileName "/ecel/UFAD/ymahmud/vlsi_sram_project/project_file/full_array/results/figures/column_mux_symbol.png" ?window w ?exportRegion 'entireDesign ?width 1000)
w=deOpenCellView("sram_project" "column_mux" "layout" "maskLayout" nil "r")
geSetAreaViewLevel(w w~>cellView~>bBox 0 32)
foreach(layer '("Metal1" "Metal2" "Metal3" "Metal4" "Metal5" "Metal6" "Metal7") leSetLayerVisible(list(layer "pin") nil) leSetLayerVisible(list(layer "label") nil))
hiExportImage(?fileName "/ecel/UFAD/ymahmud/vlsi_sram_project/project_file/full_array/results/figures/column_mux_layout.png" ?window w ?exportRegion 'entireDesign ?width 2400)
w=deOpenCellView("sram_project" "precharge_unit" "schematic" "schematic" nil "r")
hiExportImage(?fileName "/ecel/UFAD/ymahmud/vlsi_sram_project/project_file/full_array/results/figures/precharge_unit_schematic.png" ?window w ?exportRegion 'entireDesign ?width 2400)
w=deOpenCellView("sram_project" "precharge_unit" "symbol" "schematicSymbol" nil "r")
hiExportImage(?fileName "/ecel/UFAD/ymahmud/vlsi_sram_project/project_file/full_array/results/figures/precharge_unit_symbol.png" ?window w ?exportRegion 'entireDesign ?width 1000)
w=deOpenCellView("sram_project" "precharge_unit" "layout" "maskLayout" nil "r")
geSetAreaViewLevel(w w~>cellView~>bBox 0 32)
foreach(layer '("Metal1" "Metal2" "Metal3" "Metal4" "Metal5" "Metal6" "Metal7") leSetLayerVisible(list(layer "pin") nil) leSetLayerVisible(list(layer "label") nil))
hiExportImage(?fileName "/ecel/UFAD/ymahmud/vlsi_sram_project/project_file/full_array/results/figures/precharge_unit_layout.png" ?window w ?exportRegion 'entireDesign ?width 2400)
w=deOpenCellView("sram_project" "precharge" "schematic" "schematic" nil "r")
hiExportImage(?fileName "/ecel/UFAD/ymahmud/vlsi_sram_project/project_file/full_array/results/figures/precharge_schematic.png" ?window w ?exportRegion 'entireDesign ?width 2400)
w=deOpenCellView("sram_project" "precharge" "symbol" "schematicSymbol" nil "r")
hiExportImage(?fileName "/ecel/UFAD/ymahmud/vlsi_sram_project/project_file/full_array/results/figures/precharge_symbol.png" ?window w ?exportRegion 'entireDesign ?width 1000)
w=deOpenCellView("sram_project" "precharge" "layout" "maskLayout" nil "r")
geSetAreaViewLevel(w w~>cellView~>bBox 0 32)
foreach(layer '("Metal1" "Metal2" "Metal3" "Metal4" "Metal5" "Metal6" "Metal7") leSetLayerVisible(list(layer "pin") nil) leSetLayerVisible(list(layer "label") nil))
hiExportImage(?fileName "/ecel/UFAD/ymahmud/vlsi_sram_project/project_file/full_array/results/figures/precharge_layout.png" ?window w ?exportRegion 'entireDesign ?width 2400)
w=deOpenCellView("sram_project" "sense_amp" "schematic" "schematic" nil "r")
hiExportImage(?fileName "/ecel/UFAD/ymahmud/vlsi_sram_project/project_file/full_array/results/figures/sense_amp_schematic.png" ?window w ?exportRegion 'entireDesign ?width 2400)
w=deOpenCellView("sram_project" "sense_amp" "symbol" "schematicSymbol" nil "r")
hiExportImage(?fileName "/ecel/UFAD/ymahmud/vlsi_sram_project/project_file/full_array/results/figures/sense_amp_symbol.png" ?window w ?exportRegion 'entireDesign ?width 1000)
w=deOpenCellView("sram_project" "sense_amp" "layout" "maskLayout" nil "r")
geSetAreaViewLevel(w w~>cellView~>bBox 0 32)
foreach(layer '("Metal1" "Metal2" "Metal3" "Metal4" "Metal5" "Metal6" "Metal7") leSetLayerVisible(list(layer "pin") nil) leSetLayerVisible(list(layer "label") nil))
hiExportImage(?fileName "/ecel/UFAD/ymahmud/vlsi_sram_project/project_file/full_array/results/figures/sense_amp_layout.png" ?window w ?exportRegion 'entireDesign ?width 2400)
w=deOpenCellView("sram_project" "read_latch" "schematic" "schematic" nil "r")
hiExportImage(?fileName "/ecel/UFAD/ymahmud/vlsi_sram_project/project_file/full_array/results/figures/read_latch_schematic.png" ?window w ?exportRegion 'entireDesign ?width 2400)
w=deOpenCellView("sram_project" "read_latch" "symbol" "schematicSymbol" nil "r")
hiExportImage(?fileName "/ecel/UFAD/ymahmud/vlsi_sram_project/project_file/full_array/results/figures/read_latch_symbol.png" ?window w ?exportRegion 'entireDesign ?width 1000)
w=deOpenCellView("sram_project" "read_latch" "layout" "maskLayout" nil "r")
geSetAreaViewLevel(w w~>cellView~>bBox 0 32)
foreach(layer '("Metal1" "Metal2" "Metal3" "Metal4" "Metal5" "Metal6" "Metal7") leSetLayerVisible(list(layer "pin") nil) leSetLayerVisible(list(layer "label") nil))
hiExportImage(?fileName "/ecel/UFAD/ymahmud/vlsi_sram_project/project_file/full_array/results/figures/read_latch_layout.png" ?window w ?exportRegion 'entireDesign ?width 2400)
w=deOpenCellView("sram_project" "bit_array" "schematic" "schematic" nil "r")
hiExportImage(?fileName "/ecel/UFAD/ymahmud/vlsi_sram_project/project_file/full_array/results/figures/bit_array_schematic.png" ?window w ?exportRegion 'entireDesign ?width 2400)
w=deOpenCellView("sram_project" "bit_array" "symbol" "schematicSymbol" nil "r")
hiExportImage(?fileName "/ecel/UFAD/ymahmud/vlsi_sram_project/project_file/full_array/results/figures/bit_array_symbol.png" ?window w ?exportRegion 'entireDesign ?width 1000)
w=deOpenCellView("sram_project" "bit_array" "layout" "maskLayout" nil "r")
geSetAreaViewLevel(w w~>cellView~>bBox 0 32)
foreach(layer '("Metal1" "Metal2" "Metal3" "Metal4" "Metal5" "Metal6" "Metal7") leSetLayerVisible(list(layer "pin") nil) leSetLayerVisible(list(layer "label") nil))
hiExportImage(?fileName "/ecel/UFAD/ymahmud/vlsi_sram_project/project_file/full_array/results/figures/bit_array_layout.png" ?window w ?exportRegion 'entireDesign ?width 2400)
w=deOpenCellView("sram_project" "sram_4x6" "schematic" "schematic" nil "r")
hiExportImage(?fileName "/ecel/UFAD/ymahmud/vlsi_sram_project/project_file/full_array/results/figures/sram_4x6_schematic.png" ?window w ?exportRegion 'entireDesign ?width 2400)
w=deOpenCellView("sram_project" "sram_4x6" "symbol" "schematicSymbol" nil "r")
hiExportImage(?fileName "/ecel/UFAD/ymahmud/vlsi_sram_project/project_file/full_array/results/figures/sram_4x6_symbol.png" ?window w ?exportRegion 'entireDesign ?width 1000)
w=deOpenCellView("sram_project" "sram_4x6" "layout" "maskLayout" nil "r")
geSetAreaViewLevel(w w~>cellView~>bBox 0 32)
foreach(layer '("Metal1" "Metal2" "Metal3" "Metal4" "Metal5" "Metal6" "Metal7") leSetLayerVisible(list(layer "pin") nil) leSetLayerVisible(list(layer "label") nil))
hiExportImage(?fileName "/ecel/UFAD/ymahmud/vlsi_sram_project/project_file/full_array/results/figures/sram_4x6_layout.png" ?window w ?exportRegion 'entireDesign ?width 2400)
exit()
