procedure(stub(cv inst pinName netName)
 let((te pos end delta wires)
 te=dbFindTermByName(inst~>master pinName)
 unless(te error("Missing pin %s/%s" inst~>cellName pinName))
 pos=dbTransformPoint(centerBox(car(te~>pins)~>fig~>bBox) inst~>transform)
 delta=cond((pinName=="D" list(0.0 .35)) (pinName=="S" list(0.0 -.35)) (pinName=="B" list(.40 0.0)) (t list(-.40 0.0)))
 when(inst~>cellName=="pmos1v"
  when(pinName=="D" delta=list(0.0 -.35))
  when(pinName=="S" delta=list(0.0 .35)))
 when(inst~>libName=="sram_project"
   delta=if(te~>direction=="output" || member(pinName '("Q" "Q_bar")) then list(.40 0.0) else list(-.40 0.0))
   when(pinName=="VDD" delta=list(0.0 .40))
   when(pinName=="GND" delta=list(0.0 -.40)))
 end=list(car(pos)+car(delta) cadr(pos)+cadr(delta))
 wires=schCreateWire(cv "draw" "direct" list(pos end) .0625 .0625 0.0)
 schCreateWireLabel(cv car(dbGetOverlaps(cv list(end end) '("wire" "drawing"))) end netName "lowerLeft" "R0" "stick" .10 nil) end))

s=dbOpenCellViewByType("sram_project" "inv" "symbol" "schematicSymbol" "w")
dbCreateRect(s '("device" "drawing") list(list(0.0 0.0) list(4.0 2.0)))
dbCreateLabel(s '("device" "drawing") list(2.0 1.0) "inv" "centerCenter" "R0" "roman" .18)
schCreateSymbolPin(s dbOpenCellViewByType("basic" "sympin" "symbol" "" "r") "IN" "input" list(-0.25 1.5) "R0" t nil nil "signal")
dbCreateLine(s '("device" "drawing") list(list(-0.25 1.5) list(0 1.5)))
dbCreateLabel(s '("device" "drawing") list(0.1 1.5) "IN" "centerLeft" "R0" "roman" .14)
schCreateSymbolPin(s dbOpenCellViewByType("basic" "sympin" "symbol" "" "r") "OUT" "output" list(4.25 1.5) "R0" t nil nil "signal")
dbCreateLine(s '("device" "drawing") list(list(4.25 1.5) list(4 1.5)))
dbCreateLabel(s '("device" "drawing") list(3.9 1.5) "OUT" "centerRight" "R0" "roman" .14)
schCreateSymbolPin(s dbOpenCellViewByType("basic" "sympin" "symbol" "" "r") "VDD" "input" list(2 2.25) "R0" t nil nil "power")
dbCreateLine(s '("device" "drawing") list(list(2 2.25) list(2 2.0)))
dbCreateLabel(s '("device" "drawing") list(2 1.8) "VDD" "centerCenter" "R0" "roman" .14)
schCreateSymbolPin(s dbOpenCellViewByType("basic" "sympin" "symbol" "" "r") "GND" "input" list(2 -0.25) "R0" t nil nil "ground")
dbCreateLine(s '("device" "drawing") list(list(2 -0.25) list(2 0)))
dbCreateLabel(s '("device" "drawing") list(2 0.2) "GND" "centerCenter" "R0" "roman" .14)
dbSave(s) dbClose(s)
s=dbOpenCellViewByType("sram_project" "nand3" "symbol" "schematicSymbol" "w")
dbCreateRect(s '("device" "drawing") list(list(0.0 0.0) list(4.0 2.5)))
dbCreateLabel(s '("device" "drawing") list(2.0 1.25) "nand3" "centerCenter" "R0" "roman" .18)
schCreateSymbolPin(s dbOpenCellViewByType("basic" "sympin" "symbol" "" "r") "A" "input" list(-0.25 2.0) "R0" t nil nil "signal")
dbCreateLine(s '("device" "drawing") list(list(-0.25 2.0) list(0 2.0)))
dbCreateLabel(s '("device" "drawing") list(0.1 2.0) "A" "centerLeft" "R0" "roman" .14)
schCreateSymbolPin(s dbOpenCellViewByType("basic" "sympin" "symbol" "" "r") "B" "input" list(-0.25 1.5) "R0" t nil nil "signal")
dbCreateLine(s '("device" "drawing") list(list(-0.25 1.5) list(0 1.5)))
dbCreateLabel(s '("device" "drawing") list(0.1 1.5) "B" "centerLeft" "R0" "roman" .14)
schCreateSymbolPin(s dbOpenCellViewByType("basic" "sympin" "symbol" "" "r") "E" "input" list(-0.25 1.0) "R0" t nil nil "signal")
dbCreateLine(s '("device" "drawing") list(list(-0.25 1.0) list(0 1.0)))
dbCreateLabel(s '("device" "drawing") list(0.1 1.0) "E" "centerLeft" "R0" "roman" .14)
schCreateSymbolPin(s dbOpenCellViewByType("basic" "sympin" "symbol" "" "r") "Y" "output" list(4.25 2.0) "R0" t nil nil "signal")
dbCreateLine(s '("device" "drawing") list(list(4.25 2.0) list(4 2.0)))
dbCreateLabel(s '("device" "drawing") list(3.9 2.0) "Y" "centerRight" "R0" "roman" .14)
schCreateSymbolPin(s dbOpenCellViewByType("basic" "sympin" "symbol" "" "r") "VDD" "input" list(2 2.75) "R0" t nil nil "power")
dbCreateLine(s '("device" "drawing") list(list(2 2.75) list(2 2.5)))
dbCreateLabel(s '("device" "drawing") list(2 2.3) "VDD" "centerCenter" "R0" "roman" .14)
schCreateSymbolPin(s dbOpenCellViewByType("basic" "sympin" "symbol" "" "r") "GND" "input" list(2 -0.25) "R0" t nil nil "ground")
dbCreateLine(s '("device" "drawing") list(list(2 -0.25) list(2 0)))
dbCreateLabel(s '("device" "drawing") list(2 0.2) "GND" "centerCenter" "R0" "roman" .14)
dbSave(s) dbClose(s)
s=dbOpenCellViewByType("sram_project" "and3" "symbol" "schematicSymbol" "w")
dbCreateRect(s '("device" "drawing") list(list(0.0 0.0) list(4.0 2.5)))
dbCreateLabel(s '("device" "drawing") list(2.0 1.25) "and3" "centerCenter" "R0" "roman" .18)
schCreateSymbolPin(s dbOpenCellViewByType("basic" "sympin" "symbol" "" "r") "A" "input" list(-0.25 2.0) "R0" t nil nil "signal")
dbCreateLine(s '("device" "drawing") list(list(-0.25 2.0) list(0 2.0)))
dbCreateLabel(s '("device" "drawing") list(0.1 2.0) "A" "centerLeft" "R0" "roman" .14)
schCreateSymbolPin(s dbOpenCellViewByType("basic" "sympin" "symbol" "" "r") "B" "input" list(-0.25 1.5) "R0" t nil nil "signal")
dbCreateLine(s '("device" "drawing") list(list(-0.25 1.5) list(0 1.5)))
dbCreateLabel(s '("device" "drawing") list(0.1 1.5) "B" "centerLeft" "R0" "roman" .14)
schCreateSymbolPin(s dbOpenCellViewByType("basic" "sympin" "symbol" "" "r") "E" "input" list(-0.25 1.0) "R0" t nil nil "signal")
dbCreateLine(s '("device" "drawing") list(list(-0.25 1.0) list(0 1.0)))
dbCreateLabel(s '("device" "drawing") list(0.1 1.0) "E" "centerLeft" "R0" "roman" .14)
schCreateSymbolPin(s dbOpenCellViewByType("basic" "sympin" "symbol" "" "r") "Y" "output" list(4.25 2.0) "R0" t nil nil "signal")
dbCreateLine(s '("device" "drawing") list(list(4.25 2.0) list(4 2.0)))
dbCreateLabel(s '("device" "drawing") list(3.9 2.0) "Y" "centerRight" "R0" "roman" .14)
schCreateSymbolPin(s dbOpenCellViewByType("basic" "sympin" "symbol" "" "r") "VDD" "input" list(2 2.75) "R0" t nil nil "power")
dbCreateLine(s '("device" "drawing") list(list(2 2.75) list(2 2.5)))
dbCreateLabel(s '("device" "drawing") list(2 2.3) "VDD" "centerCenter" "R0" "roman" .14)
schCreateSymbolPin(s dbOpenCellViewByType("basic" "sympin" "symbol" "" "r") "GND" "input" list(2 -0.25) "R0" t nil nil "ground")
dbCreateLine(s '("device" "drawing") list(list(2 -0.25) list(2 0)))
dbCreateLabel(s '("device" "drawing") list(2 0.2) "GND" "centerCenter" "R0" "roman" .14)
dbSave(s) dbClose(s)
s=dbOpenCellViewByType("sram_project" "nand2" "symbol" "schematicSymbol" "w")
dbCreateRect(s '("device" "drawing") list(list(0.0 0.0) list(4.0 2.0)))
dbCreateLabel(s '("device" "drawing") list(2.0 1.0) "nand2" "centerCenter" "R0" "roman" .18)
schCreateSymbolPin(s dbOpenCellViewByType("basic" "sympin" "symbol" "" "r") "A" "input" list(-0.25 1.5) "R0" t nil nil "signal")
dbCreateLine(s '("device" "drawing") list(list(-0.25 1.5) list(0 1.5)))
dbCreateLabel(s '("device" "drawing") list(0.1 1.5) "A" "centerLeft" "R0" "roman" .14)
schCreateSymbolPin(s dbOpenCellViewByType("basic" "sympin" "symbol" "" "r") "B" "input" list(-0.25 1.0) "R0" t nil nil "signal")
dbCreateLine(s '("device" "drawing") list(list(-0.25 1.0) list(0 1.0)))
dbCreateLabel(s '("device" "drawing") list(0.1 1.0) "B" "centerLeft" "R0" "roman" .14)
schCreateSymbolPin(s dbOpenCellViewByType("basic" "sympin" "symbol" "" "r") "Y" "output" list(4.25 1.5) "R0" t nil nil "signal")
dbCreateLine(s '("device" "drawing") list(list(4.25 1.5) list(4 1.5)))
dbCreateLabel(s '("device" "drawing") list(3.9 1.5) "Y" "centerRight" "R0" "roman" .14)
schCreateSymbolPin(s dbOpenCellViewByType("basic" "sympin" "symbol" "" "r") "VDD" "input" list(2 2.25) "R0" t nil nil "power")
dbCreateLine(s '("device" "drawing") list(list(2 2.25) list(2 2.0)))
dbCreateLabel(s '("device" "drawing") list(2 1.8) "VDD" "centerCenter" "R0" "roman" .14)
schCreateSymbolPin(s dbOpenCellViewByType("basic" "sympin" "symbol" "" "r") "GND" "input" list(2 -0.25) "R0" t nil nil "ground")
dbCreateLine(s '("device" "drawing") list(list(2 -0.25) list(2 0)))
dbCreateLabel(s '("device" "drawing") list(2 0.2) "GND" "centerCenter" "R0" "roman" .14)
dbSave(s) dbClose(s)
s=dbOpenCellViewByType("sram_project" "tg" "symbol" "schematicSymbol" "w")
dbCreateRect(s '("device" "drawing") list(list(0.0 0.0) list(4.0 3.0)))
dbCreateLabel(s '("device" "drawing") list(2.0 1.5) "tg" "centerCenter" "R0" "roman" .18)
schCreateSymbolPin(s dbOpenCellViewByType("basic" "sympin" "symbol" "" "r") "A" "inputOutput" list(-0.25 2.5) "R0" t nil nil "signal")
dbCreateLine(s '("device" "drawing") list(list(-0.25 2.5) list(0 2.5)))
dbCreateLabel(s '("device" "drawing") list(0.1 2.5) "A" "centerLeft" "R0" "roman" .14)
schCreateSymbolPin(s dbOpenCellViewByType("basic" "sympin" "symbol" "" "r") "B" "inputOutput" list(-0.25 2.0) "R0" t nil nil "signal")
dbCreateLine(s '("device" "drawing") list(list(-0.25 2.0) list(0 2.0)))
dbCreateLabel(s '("device" "drawing") list(0.1 2.0) "B" "centerLeft" "R0" "roman" .14)
schCreateSymbolPin(s dbOpenCellViewByType("basic" "sympin" "symbol" "" "r") "EN" "input" list(-0.25 1.5) "R0" t nil nil "signal")
dbCreateLine(s '("device" "drawing") list(list(-0.25 1.5) list(0 1.5)))
dbCreateLabel(s '("device" "drawing") list(0.1 1.5) "EN" "centerLeft" "R0" "roman" .14)
schCreateSymbolPin(s dbOpenCellViewByType("basic" "sympin" "symbol" "" "r") "ENB" "input" list(-0.25 1.0) "R0" t nil nil "signal")
dbCreateLine(s '("device" "drawing") list(list(-0.25 1.0) list(0 1.0)))
dbCreateLabel(s '("device" "drawing") list(0.1 1.0) "ENB" "centerLeft" "R0" "roman" .14)
schCreateSymbolPin(s dbOpenCellViewByType("basic" "sympin" "symbol" "" "r") "VDD" "input" list(2 3.25) "R0" t nil nil "power")
dbCreateLine(s '("device" "drawing") list(list(2 3.25) list(2 3.0)))
dbCreateLabel(s '("device" "drawing") list(2 2.8) "VDD" "centerCenter" "R0" "roman" .14)
schCreateSymbolPin(s dbOpenCellViewByType("basic" "sympin" "symbol" "" "r") "GND" "input" list(2 -0.25) "R0" t nil nil "ground")
dbCreateLine(s '("device" "drawing") list(list(2 -0.25) list(2 0)))
dbCreateLabel(s '("device" "drawing") list(2 0.2) "GND" "centerCenter" "R0" "roman" .14)
dbSave(s) dbClose(s)
s=dbOpenCellViewByType("sram_project" "precharge_unit" "symbol" "schematicSymbol" "w")
dbCreateRect(s '("device" "drawing") list(list(0.0 0.0) list(4.0 2.5)))
dbCreateLabel(s '("device" "drawing") list(2.0 1.25) "precharge_unit" "centerCenter" "R0" "roman" .18)
schCreateSymbolPin(s dbOpenCellViewByType("basic" "sympin" "symbol" "" "r") "BL" "inputOutput" list(-0.25 2.0) "R0" t nil nil "signal")
dbCreateLine(s '("device" "drawing") list(list(-0.25 2.0) list(0 2.0)))
dbCreateLabel(s '("device" "drawing") list(0.1 2.0) "BL" "centerLeft" "R0" "roman" .14)
schCreateSymbolPin(s dbOpenCellViewByType("basic" "sympin" "symbol" "" "r") "BLB" "inputOutput" list(-0.25 1.5) "R0" t nil nil "signal")
dbCreateLine(s '("device" "drawing") list(list(-0.25 1.5) list(0 1.5)))
dbCreateLabel(s '("device" "drawing") list(0.1 1.5) "BLB" "centerLeft" "R0" "roman" .14)
schCreateSymbolPin(s dbOpenCellViewByType("basic" "sympin" "symbol" "" "r") "PCB" "input" list(-0.25 1.0) "R0" t nil nil "signal")
dbCreateLine(s '("device" "drawing") list(list(-0.25 1.0) list(0 1.0)))
dbCreateLabel(s '("device" "drawing") list(0.1 1.0) "PCB" "centerLeft" "R0" "roman" .14)
schCreateSymbolPin(s dbOpenCellViewByType("basic" "sympin" "symbol" "" "r") "VDD" "input" list(2 2.75) "R0" t nil nil "power")
dbCreateLine(s '("device" "drawing") list(list(2 2.75) list(2 2.5)))
dbCreateLabel(s '("device" "drawing") list(2 2.3) "VDD" "centerCenter" "R0" "roman" .14)
schCreateSymbolPin(s dbOpenCellViewByType("basic" "sympin" "symbol" "" "r") "GND" "input" list(2 -0.25) "R0" t nil nil "ground")
dbCreateLine(s '("device" "drawing") list(list(2 -0.25) list(2 0)))
dbCreateLabel(s '("device" "drawing") list(2 0.2) "GND" "centerCenter" "R0" "roman" .14)
dbSave(s) dbClose(s)
s=dbOpenCellViewByType("sram_project" "sense_amp" "symbol" "schematicSymbol" "w")
dbCreateRect(s '("device" "drawing") list(list(0.0 0.0) list(4.0 2.5)))
dbCreateLabel(s '("device" "drawing") list(2.0 1.25) "sense_amp" "centerCenter" "R0" "roman" .18)
schCreateSymbolPin(s dbOpenCellViewByType("basic" "sympin" "symbol" "" "r") "BIT" "input" list(-0.25 2.0) "R0" t nil nil "signal")
dbCreateLine(s '("device" "drawing") list(list(-0.25 2.0) list(0 2.0)))
dbCreateLabel(s '("device" "drawing") list(0.1 2.0) "BIT" "centerLeft" "R0" "roman" .14)
schCreateSymbolPin(s dbOpenCellViewByType("basic" "sympin" "symbol" "" "r") "BIT_bar" "input" list(-0.25 1.5) "R0" t nil nil "signal")
dbCreateLine(s '("device" "drawing") list(list(-0.25 1.5) list(0 1.5)))
dbCreateLabel(s '("device" "drawing") list(0.1 1.5) "BIT_bar" "centerLeft" "R0" "roman" .14)
schCreateSymbolPin(s dbOpenCellViewByType("basic" "sympin" "symbol" "" "r") "RE" "input" list(-0.25 1.0) "R0" t nil nil "signal")
dbCreateLine(s '("device" "drawing") list(list(-0.25 1.0) list(0 1.0)))
dbCreateLabel(s '("device" "drawing") list(0.1 1.0) "RE" "centerLeft" "R0" "roman" .14)
schCreateSymbolPin(s dbOpenCellViewByType("basic" "sympin" "symbol" "" "r") "AMP_OUT" "output" list(4.25 2.0) "R0" t nil nil "signal")
dbCreateLine(s '("device" "drawing") list(list(4.25 2.0) list(4 2.0)))
dbCreateLabel(s '("device" "drawing") list(3.9 2.0) "AMP_OUT" "centerRight" "R0" "roman" .14)
schCreateSymbolPin(s dbOpenCellViewByType("basic" "sympin" "symbol" "" "r") "VDD" "input" list(2 2.75) "R0" t nil nil "power")
dbCreateLine(s '("device" "drawing") list(list(2 2.75) list(2 2.5)))
dbCreateLabel(s '("device" "drawing") list(2 2.3) "VDD" "centerCenter" "R0" "roman" .14)
schCreateSymbolPin(s dbOpenCellViewByType("basic" "sympin" "symbol" "" "r") "GND" "input" list(2 -0.25) "R0" t nil nil "ground")
dbCreateLine(s '("device" "drawing") list(list(2 -0.25) list(2 0)))
dbCreateLabel(s '("device" "drawing") list(2 0.2) "GND" "centerCenter" "R0" "roman" .14)
dbSave(s) dbClose(s)
s=dbOpenCellViewByType("sram_project" "read_latch" "symbol" "schematicSymbol" "w")
dbCreateRect(s '("device" "drawing") list(list(0.0 0.0) list(4.0 2.5)))
dbCreateLabel(s '("device" "drawing") list(2.0 1.25) "read_latch" "centerCenter" "R0" "roman" .18)
schCreateSymbolPin(s dbOpenCellViewByType("basic" "sympin" "symbol" "" "r") "D" "input" list(-0.25 2.0) "R0" t nil nil "signal")
dbCreateLine(s '("device" "drawing") list(list(-0.25 2.0) list(0 2.0)))
dbCreateLabel(s '("device" "drawing") list(0.1 2.0) "D" "centerLeft" "R0" "roman" .14)
schCreateSymbolPin(s dbOpenCellViewByType("basic" "sympin" "symbol" "" "r") "EN" "input" list(-0.25 1.5) "R0" t nil nil "signal")
dbCreateLine(s '("device" "drawing") list(list(-0.25 1.5) list(0 1.5)))
dbCreateLabel(s '("device" "drawing") list(0.1 1.5) "EN" "centerLeft" "R0" "roman" .14)
schCreateSymbolPin(s dbOpenCellViewByType("basic" "sympin" "symbol" "" "r") "ENB" "input" list(-0.25 1.0) "R0" t nil nil "signal")
dbCreateLine(s '("device" "drawing") list(list(-0.25 1.0) list(0 1.0)))
dbCreateLabel(s '("device" "drawing") list(0.1 1.0) "ENB" "centerLeft" "R0" "roman" .14)
schCreateSymbolPin(s dbOpenCellViewByType("basic" "sympin" "symbol" "" "r") "Q" "output" list(4.25 2.0) "R0" t nil nil "signal")
dbCreateLine(s '("device" "drawing") list(list(4.25 2.0) list(4 2.0)))
dbCreateLabel(s '("device" "drawing") list(3.9 2.0) "Q" "centerRight" "R0" "roman" .14)
schCreateSymbolPin(s dbOpenCellViewByType("basic" "sympin" "symbol" "" "r") "VDD" "input" list(2 2.75) "R0" t nil nil "power")
dbCreateLine(s '("device" "drawing") list(list(2 2.75) list(2 2.5)))
dbCreateLabel(s '("device" "drawing") list(2 2.3) "VDD" "centerCenter" "R0" "roman" .14)
schCreateSymbolPin(s dbOpenCellViewByType("basic" "sympin" "symbol" "" "r") "GND" "input" list(2 -0.25) "R0" t nil nil "ground")
dbCreateLine(s '("device" "drawing") list(list(2 -0.25) list(2 0)))
dbCreateLabel(s '("device" "drawing") list(2 0.2) "GND" "centerCenter" "R0" "roman" .14)
dbSave(s) dbClose(s)
s=dbOpenCellViewByType("sram_project" "row_decoder" "symbol" "schematicSymbol" "w")
dbCreateRect(s '("device" "drawing") list(list(0.0 0.0) list(4.0 3.0)))
dbCreateLabel(s '("device" "drawing") list(2.0 1.5) "row_decoder" "centerCenter" "R0" "roman" .18)
schCreateSymbolPin(s dbOpenCellViewByType("basic" "sympin" "symbol" "" "r") "R1" "input" list(-0.25 2.5) "R0" t nil nil "signal")
dbCreateLine(s '("device" "drawing") list(list(-0.25 2.5) list(0 2.5)))
dbCreateLabel(s '("device" "drawing") list(0.1 2.5) "R1" "centerLeft" "R0" "roman" .14)
schCreateSymbolPin(s dbOpenCellViewByType("basic" "sympin" "symbol" "" "r") "R0" "input" list(-0.25 2.0) "R0" t nil nil "signal")
dbCreateLine(s '("device" "drawing") list(list(-0.25 2.0) list(0 2.0)))
dbCreateLabel(s '("device" "drawing") list(0.1 2.0) "R0" "centerLeft" "R0" "roman" .14)
schCreateSymbolPin(s dbOpenCellViewByType("basic" "sympin" "symbol" "" "r") "EN" "input" list(-0.25 1.5) "R0" t nil nil "signal")
dbCreateLine(s '("device" "drawing") list(list(-0.25 1.5) list(0 1.5)))
dbCreateLabel(s '("device" "drawing") list(0.1 1.5) "EN" "centerLeft" "R0" "roman" .14)
schCreateSymbolPin(s dbOpenCellViewByType("basic" "sympin" "symbol" "" "r") "WL0" "output" list(4.25 2.5) "R0" t nil nil "signal")
dbCreateLine(s '("device" "drawing") list(list(4.25 2.5) list(4 2.5)))
dbCreateLabel(s '("device" "drawing") list(3.9 2.5) "WL0" "centerRight" "R0" "roman" .14)
schCreateSymbolPin(s dbOpenCellViewByType("basic" "sympin" "symbol" "" "r") "WL1" "output" list(4.25 2.0) "R0" t nil nil "signal")
dbCreateLine(s '("device" "drawing") list(list(4.25 2.0) list(4 2.0)))
dbCreateLabel(s '("device" "drawing") list(3.9 2.0) "WL1" "centerRight" "R0" "roman" .14)
schCreateSymbolPin(s dbOpenCellViewByType("basic" "sympin" "symbol" "" "r") "WL2" "output" list(4.25 1.5) "R0" t nil nil "signal")
dbCreateLine(s '("device" "drawing") list(list(4.25 1.5) list(4 1.5)))
dbCreateLabel(s '("device" "drawing") list(3.9 1.5) "WL2" "centerRight" "R0" "roman" .14)
schCreateSymbolPin(s dbOpenCellViewByType("basic" "sympin" "symbol" "" "r") "WL3" "output" list(4.25 1.0) "R0" t nil nil "signal")
dbCreateLine(s '("device" "drawing") list(list(4.25 1.0) list(4 1.0)))
dbCreateLabel(s '("device" "drawing") list(3.9 1.0) "WL3" "centerRight" "R0" "roman" .14)
schCreateSymbolPin(s dbOpenCellViewByType("basic" "sympin" "symbol" "" "r") "VDD" "input" list(2 3.25) "R0" t nil nil "power")
dbCreateLine(s '("device" "drawing") list(list(2 3.25) list(2 3.0)))
dbCreateLabel(s '("device" "drawing") list(2 2.8) "VDD" "centerCenter" "R0" "roman" .14)
schCreateSymbolPin(s dbOpenCellViewByType("basic" "sympin" "symbol" "" "r") "GND" "input" list(2 -0.25) "R0" t nil nil "ground")
dbCreateLine(s '("device" "drawing") list(list(2 -0.25) list(2 0)))
dbCreateLabel(s '("device" "drawing") list(2 0.2) "GND" "centerCenter" "R0" "roman" .14)
dbSave(s) dbClose(s)
s=dbOpenCellViewByType("sram_project" "column_decoder" "symbol" "schematicSymbol" "w")
dbCreateRect(s '("device" "drawing") list(list(0.0 0.0) list(4.0 4.0)))
dbCreateLabel(s '("device" "drawing") list(2.0 2.0) "column_decoder" "centerCenter" "R0" "roman" .18)
schCreateSymbolPin(s dbOpenCellViewByType("basic" "sympin" "symbol" "" "r") "C2" "input" list(-0.25 3.5) "R0" t nil nil "signal")
dbCreateLine(s '("device" "drawing") list(list(-0.25 3.5) list(0 3.5)))
dbCreateLabel(s '("device" "drawing") list(0.1 3.5) "C2" "centerLeft" "R0" "roman" .14)
schCreateSymbolPin(s dbOpenCellViewByType("basic" "sympin" "symbol" "" "r") "C1" "input" list(-0.25 3.0) "R0" t nil nil "signal")
dbCreateLine(s '("device" "drawing") list(list(-0.25 3.0) list(0 3.0)))
dbCreateLabel(s '("device" "drawing") list(0.1 3.0) "C1" "centerLeft" "R0" "roman" .14)
schCreateSymbolPin(s dbOpenCellViewByType("basic" "sympin" "symbol" "" "r") "C0" "input" list(-0.25 2.5) "R0" t nil nil "signal")
dbCreateLine(s '("device" "drawing") list(list(-0.25 2.5) list(0 2.5)))
dbCreateLabel(s '("device" "drawing") list(0.1 2.5) "C0" "centerLeft" "R0" "roman" .14)
schCreateSymbolPin(s dbOpenCellViewByType("basic" "sympin" "symbol" "" "r") "CS0" "output" list(4.25 3.5) "R0" t nil nil "signal")
dbCreateLine(s '("device" "drawing") list(list(4.25 3.5) list(4 3.5)))
dbCreateLabel(s '("device" "drawing") list(3.9 3.5) "CS0" "centerRight" "R0" "roman" .14)
schCreateSymbolPin(s dbOpenCellViewByType("basic" "sympin" "symbol" "" "r") "CS1" "output" list(4.25 3.0) "R0" t nil nil "signal")
dbCreateLine(s '("device" "drawing") list(list(4.25 3.0) list(4 3.0)))
dbCreateLabel(s '("device" "drawing") list(3.9 3.0) "CS1" "centerRight" "R0" "roman" .14)
schCreateSymbolPin(s dbOpenCellViewByType("basic" "sympin" "symbol" "" "r") "CS2" "output" list(4.25 2.5) "R0" t nil nil "signal")
dbCreateLine(s '("device" "drawing") list(list(4.25 2.5) list(4 2.5)))
dbCreateLabel(s '("device" "drawing") list(3.9 2.5) "CS2" "centerRight" "R0" "roman" .14)
schCreateSymbolPin(s dbOpenCellViewByType("basic" "sympin" "symbol" "" "r") "CS3" "output" list(4.25 2.0) "R0" t nil nil "signal")
dbCreateLine(s '("device" "drawing") list(list(4.25 2.0) list(4 2.0)))
dbCreateLabel(s '("device" "drawing") list(3.9 2.0) "CS3" "centerRight" "R0" "roman" .14)
schCreateSymbolPin(s dbOpenCellViewByType("basic" "sympin" "symbol" "" "r") "CS4" "output" list(4.25 1.5) "R0" t nil nil "signal")
dbCreateLine(s '("device" "drawing") list(list(4.25 1.5) list(4 1.5)))
dbCreateLabel(s '("device" "drawing") list(3.9 1.5) "CS4" "centerRight" "R0" "roman" .14)
schCreateSymbolPin(s dbOpenCellViewByType("basic" "sympin" "symbol" "" "r") "CS5" "output" list(4.25 1.0) "R0" t nil nil "signal")
dbCreateLine(s '("device" "drawing") list(list(4.25 1.0) list(4 1.0)))
dbCreateLabel(s '("device" "drawing") list(3.9 1.0) "CS5" "centerRight" "R0" "roman" .14)
schCreateSymbolPin(s dbOpenCellViewByType("basic" "sympin" "symbol" "" "r") "VDD" "input" list(2 4.25) "R0" t nil nil "power")
dbCreateLine(s '("device" "drawing") list(list(2 4.25) list(2 4.0)))
dbCreateLabel(s '("device" "drawing") list(2 3.8) "VDD" "centerCenter" "R0" "roman" .14)
schCreateSymbolPin(s dbOpenCellViewByType("basic" "sympin" "symbol" "" "r") "GND" "input" list(2 -0.25) "R0" t nil nil "ground")
dbCreateLine(s '("device" "drawing") list(list(2 -0.25) list(2 0)))
dbCreateLabel(s '("device" "drawing") list(2 0.2) "GND" "centerCenter" "R0" "roman" .14)
dbSave(s) dbClose(s)
s=dbOpenCellViewByType("sram_project" "rw_control" "symbol" "schematicSymbol" "w")
dbCreateRect(s '("device" "drawing") list(list(0.0 0.0) list(4.0 4.0)))
dbCreateLabel(s '("device" "drawing") list(2.0 2.0) "rw_control" "centerCenter" "R0" "roman" .18)
schCreateSymbolPin(s dbOpenCellViewByType("basic" "sympin" "symbol" "" "r") "CLK1" "input" list(-0.25 3.5) "R0" t nil nil "signal")
dbCreateLine(s '("device" "drawing") list(list(-0.25 3.5) list(0 3.5)))
dbCreateLabel(s '("device" "drawing") list(0.1 3.5) "CLK1" "centerLeft" "R0" "roman" .14)
schCreateSymbolPin(s dbOpenCellViewByType("basic" "sympin" "symbol" "" "r") "CLK2" "input" list(-0.25 3.0) "R0" t nil nil "signal")
dbCreateLine(s '("device" "drawing") list(list(-0.25 3.0) list(0 3.0)))
dbCreateLabel(s '("device" "drawing") list(0.1 3.0) "CLK2" "centerLeft" "R0" "roman" .14)
schCreateSymbolPin(s dbOpenCellViewByType("basic" "sympin" "symbol" "" "r") "WR" "input" list(-0.25 2.5) "R0" t nil nil "signal")
dbCreateLine(s '("device" "drawing") list(list(-0.25 2.5) list(0 2.5)))
dbCreateLabel(s '("device" "drawing") list(0.1 2.5) "WR" "centerLeft" "R0" "roman" .14)
schCreateSymbolPin(s dbOpenCellViewByType("basic" "sympin" "symbol" "" "r") "RD" "input" list(-0.25 2.0) "R0" t nil nil "signal")
dbCreateLine(s '("device" "drawing") list(list(-0.25 2.0) list(0 2.0)))
dbCreateLabel(s '("device" "drawing") list(0.1 2.0) "RD" "centerLeft" "R0" "roman" .14)
schCreateSymbolPin(s dbOpenCellViewByType("basic" "sympin" "symbol" "" "r") "C2" "input" list(-0.25 1.5) "R0" t nil nil "signal")
dbCreateLine(s '("device" "drawing") list(list(-0.25 1.5) list(0 1.5)))
dbCreateLabel(s '("device" "drawing") list(0.1 1.5) "C2" "centerLeft" "R0" "roman" .14)
schCreateSymbolPin(s dbOpenCellViewByType("basic" "sympin" "symbol" "" "r") "C1" "input" list(-0.25 1.0) "R0" t nil nil "signal")
dbCreateLine(s '("device" "drawing") list(list(-0.25 1.0) list(0 1.0)))
dbCreateLabel(s '("device" "drawing") list(0.1 1.0) "C1" "centerLeft" "R0" "roman" .14)
schCreateSymbolPin(s dbOpenCellViewByType("basic" "sympin" "symbol" "" "r") "WEN" "output" list(4.25 3.5) "R0" t nil nil "signal")
dbCreateLine(s '("device" "drawing") list(list(4.25 3.5) list(4 3.5)))
dbCreateLabel(s '("device" "drawing") list(3.9 3.5) "WEN" "centerRight" "R0" "roman" .14)
schCreateSymbolPin(s dbOpenCellViewByType("basic" "sympin" "symbol" "" "r") "WENB" "output" list(4.25 3.0) "R0" t nil nil "signal")
dbCreateLine(s '("device" "drawing") list(list(4.25 3.0) list(4 3.0)))
dbCreateLabel(s '("device" "drawing") list(3.9 3.0) "WENB" "centerRight" "R0" "roman" .14)
schCreateSymbolPin(s dbOpenCellViewByType("basic" "sympin" "symbol" "" "r") "REN" "output" list(4.25 2.5) "R0" t nil nil "signal")
dbCreateLine(s '("device" "drawing") list(list(4.25 2.5) list(4 2.5)))
dbCreateLabel(s '("device" "drawing") list(3.9 2.5) "REN" "centerRight" "R0" "roman" .14)
schCreateSymbolPin(s dbOpenCellViewByType("basic" "sympin" "symbol" "" "r") "RENB" "output" list(4.25 2.0) "R0" t nil nil "signal")
dbCreateLine(s '("device" "drawing") list(list(4.25 2.0) list(4 2.0)))
dbCreateLabel(s '("device" "drawing") list(3.9 2.0) "RENB" "centerRight" "R0" "roman" .14)
schCreateSymbolPin(s dbOpenCellViewByType("basic" "sympin" "symbol" "" "r") "ROWEN" "output" list(4.25 1.5) "R0" t nil nil "signal")
dbCreateLine(s '("device" "drawing") list(list(4.25 1.5) list(4 1.5)))
dbCreateLabel(s '("device" "drawing") list(3.9 1.5) "ROWEN" "centerRight" "R0" "roman" .14)
schCreateSymbolPin(s dbOpenCellViewByType("basic" "sympin" "symbol" "" "r") "PCB" "output" list(4.25 1.0) "R0" t nil nil "signal")
dbCreateLine(s '("device" "drawing") list(list(4.25 1.0) list(4 1.0)))
dbCreateLabel(s '("device" "drawing") list(3.9 1.0) "PCB" "centerRight" "R0" "roman" .14)
schCreateSymbolPin(s dbOpenCellViewByType("basic" "sympin" "symbol" "" "r") "VDD" "input" list(2 4.25) "R0" t nil nil "power")
dbCreateLine(s '("device" "drawing") list(list(2 4.25) list(2 4.0)))
dbCreateLabel(s '("device" "drawing") list(2 3.8) "VDD" "centerCenter" "R0" "roman" .14)
schCreateSymbolPin(s dbOpenCellViewByType("basic" "sympin" "symbol" "" "r") "GND" "input" list(2 -0.25) "R0" t nil nil "ground")
dbCreateLine(s '("device" "drawing") list(list(2 -0.25) list(2 0)))
dbCreateLabel(s '("device" "drawing") list(2 0.2) "GND" "centerCenter" "R0" "roman" .14)
dbSave(s) dbClose(s)
s=dbOpenCellViewByType("sram_project" "write_driver" "symbol" "schematicSymbol" "w")
dbCreateRect(s '("device" "drawing") list(list(0.0 0.0) list(4.0 3.5)))
dbCreateLabel(s '("device" "drawing") list(2.0 1.75) "write_driver" "centerCenter" "R0" "roman" .18)
schCreateSymbolPin(s dbOpenCellViewByType("basic" "sympin" "symbol" "" "r") "DIN" "input" list(-0.25 3.0) "R0" t nil nil "signal")
dbCreateLine(s '("device" "drawing") list(list(-0.25 3.0) list(0 3.0)))
dbCreateLabel(s '("device" "drawing") list(0.1 3.0) "DIN" "centerLeft" "R0" "roman" .14)
schCreateSymbolPin(s dbOpenCellViewByType("basic" "sympin" "symbol" "" "r") "WEN" "input" list(-0.25 2.5) "R0" t nil nil "signal")
dbCreateLine(s '("device" "drawing") list(list(-0.25 2.5) list(0 2.5)))
dbCreateLabel(s '("device" "drawing") list(0.1 2.5) "WEN" "centerLeft" "R0" "roman" .14)
schCreateSymbolPin(s dbOpenCellViewByType("basic" "sympin" "symbol" "" "r") "WENB" "input" list(-0.25 2.0) "R0" t nil nil "signal")
dbCreateLine(s '("device" "drawing") list(list(-0.25 2.0) list(0 2.0)))
dbCreateLabel(s '("device" "drawing") list(0.1 2.0) "WENB" "centerLeft" "R0" "roman" .14)
schCreateSymbolPin(s dbOpenCellViewByType("basic" "sympin" "symbol" "" "r") "GBL" "inputOutput" list(-0.25 1.5) "R0" t nil nil "signal")
dbCreateLine(s '("device" "drawing") list(list(-0.25 1.5) list(0 1.5)))
dbCreateLabel(s '("device" "drawing") list(0.1 1.5) "GBL" "centerLeft" "R0" "roman" .14)
schCreateSymbolPin(s dbOpenCellViewByType("basic" "sympin" "symbol" "" "r") "GBLB" "inputOutput" list(-0.25 1.0) "R0" t nil nil "signal")
dbCreateLine(s '("device" "drawing") list(list(-0.25 1.0) list(0 1.0)))
dbCreateLabel(s '("device" "drawing") list(0.1 1.0) "GBLB" "centerLeft" "R0" "roman" .14)
schCreateSymbolPin(s dbOpenCellViewByType("basic" "sympin" "symbol" "" "r") "VDD" "input" list(2 3.75) "R0" t nil nil "power")
dbCreateLine(s '("device" "drawing") list(list(2 3.75) list(2 3.5)))
dbCreateLabel(s '("device" "drawing") list(2 3.3) "VDD" "centerCenter" "R0" "roman" .14)
schCreateSymbolPin(s dbOpenCellViewByType("basic" "sympin" "symbol" "" "r") "GND" "input" list(2 -0.25) "R0" t nil nil "ground")
dbCreateLine(s '("device" "drawing") list(list(2 -0.25) list(2 0)))
dbCreateLabel(s '("device" "drawing") list(2 0.2) "GND" "centerCenter" "R0" "roman" .14)
dbSave(s) dbClose(s)
s=dbOpenCellViewByType("sram_project" "column_mux" "symbol" "schematicSymbol" "w")
dbCreateRect(s '("device" "drawing") list(list(0.0 0.0) list(4.0 11.0)))
dbCreateLabel(s '("device" "drawing") list(2.0 5.5) "column_mux" "centerCenter" "R0" "roman" .18)
schCreateSymbolPin(s dbOpenCellViewByType("basic" "sympin" "symbol" "" "r") "CS0" "input" list(-0.25 10.5) "R0" t nil nil "signal")
dbCreateLine(s '("device" "drawing") list(list(-0.25 10.5) list(0 10.5)))
dbCreateLabel(s '("device" "drawing") list(0.1 10.5) "CS0" "centerLeft" "R0" "roman" .14)
schCreateSymbolPin(s dbOpenCellViewByType("basic" "sympin" "symbol" "" "r") "CS1" "input" list(-0.25 10.0) "R0" t nil nil "signal")
dbCreateLine(s '("device" "drawing") list(list(-0.25 10.0) list(0 10.0)))
dbCreateLabel(s '("device" "drawing") list(0.1 10.0) "CS1" "centerLeft" "R0" "roman" .14)
schCreateSymbolPin(s dbOpenCellViewByType("basic" "sympin" "symbol" "" "r") "CS2" "input" list(-0.25 9.5) "R0" t nil nil "signal")
dbCreateLine(s '("device" "drawing") list(list(-0.25 9.5) list(0 9.5)))
dbCreateLabel(s '("device" "drawing") list(0.1 9.5) "CS2" "centerLeft" "R0" "roman" .14)
schCreateSymbolPin(s dbOpenCellViewByType("basic" "sympin" "symbol" "" "r") "CS3" "input" list(-0.25 9.0) "R0" t nil nil "signal")
dbCreateLine(s '("device" "drawing") list(list(-0.25 9.0) list(0 9.0)))
dbCreateLabel(s '("device" "drawing") list(0.1 9.0) "CS3" "centerLeft" "R0" "roman" .14)
schCreateSymbolPin(s dbOpenCellViewByType("basic" "sympin" "symbol" "" "r") "CS4" "input" list(-0.25 8.5) "R0" t nil nil "signal")
dbCreateLine(s '("device" "drawing") list(list(-0.25 8.5) list(0 8.5)))
dbCreateLabel(s '("device" "drawing") list(0.1 8.5) "CS4" "centerLeft" "R0" "roman" .14)
schCreateSymbolPin(s dbOpenCellViewByType("basic" "sympin" "symbol" "" "r") "CS5" "input" list(-0.25 8.0) "R0" t nil nil "signal")
dbCreateLine(s '("device" "drawing") list(list(-0.25 8.0) list(0 8.0)))
dbCreateLabel(s '("device" "drawing") list(0.1 8.0) "CS5" "centerLeft" "R0" "roman" .14)
schCreateSymbolPin(s dbOpenCellViewByType("basic" "sympin" "symbol" "" "r") "BL0" "inputOutput" list(-0.25 7.5) "R0" t nil nil "signal")
dbCreateLine(s '("device" "drawing") list(list(-0.25 7.5) list(0 7.5)))
dbCreateLabel(s '("device" "drawing") list(0.1 7.5) "BL0" "centerLeft" "R0" "roman" .14)
schCreateSymbolPin(s dbOpenCellViewByType("basic" "sympin" "symbol" "" "r") "BL1" "inputOutput" list(-0.25 7.0) "R0" t nil nil "signal")
dbCreateLine(s '("device" "drawing") list(list(-0.25 7.0) list(0 7.0)))
dbCreateLabel(s '("device" "drawing") list(0.1 7.0) "BL1" "centerLeft" "R0" "roman" .14)
schCreateSymbolPin(s dbOpenCellViewByType("basic" "sympin" "symbol" "" "r") "BL2" "inputOutput" list(-0.25 6.5) "R0" t nil nil "signal")
dbCreateLine(s '("device" "drawing") list(list(-0.25 6.5) list(0 6.5)))
dbCreateLabel(s '("device" "drawing") list(0.1 6.5) "BL2" "centerLeft" "R0" "roman" .14)
schCreateSymbolPin(s dbOpenCellViewByType("basic" "sympin" "symbol" "" "r") "BL3" "inputOutput" list(-0.25 6.0) "R0" t nil nil "signal")
dbCreateLine(s '("device" "drawing") list(list(-0.25 6.0) list(0 6.0)))
dbCreateLabel(s '("device" "drawing") list(0.1 6.0) "BL3" "centerLeft" "R0" "roman" .14)
schCreateSymbolPin(s dbOpenCellViewByType("basic" "sympin" "symbol" "" "r") "BL4" "inputOutput" list(-0.25 5.5) "R0" t nil nil "signal")
dbCreateLine(s '("device" "drawing") list(list(-0.25 5.5) list(0 5.5)))
dbCreateLabel(s '("device" "drawing") list(0.1 5.5) "BL4" "centerLeft" "R0" "roman" .14)
schCreateSymbolPin(s dbOpenCellViewByType("basic" "sympin" "symbol" "" "r") "BL5" "inputOutput" list(-0.25 5.0) "R0" t nil nil "signal")
dbCreateLine(s '("device" "drawing") list(list(-0.25 5.0) list(0 5.0)))
dbCreateLabel(s '("device" "drawing") list(0.1 5.0) "BL5" "centerLeft" "R0" "roman" .14)
schCreateSymbolPin(s dbOpenCellViewByType("basic" "sympin" "symbol" "" "r") "BLB0" "inputOutput" list(-0.25 4.5) "R0" t nil nil "signal")
dbCreateLine(s '("device" "drawing") list(list(-0.25 4.5) list(0 4.5)))
dbCreateLabel(s '("device" "drawing") list(0.1 4.5) "BLB0" "centerLeft" "R0" "roman" .14)
schCreateSymbolPin(s dbOpenCellViewByType("basic" "sympin" "symbol" "" "r") "BLB1" "inputOutput" list(-0.25 4.0) "R0" t nil nil "signal")
dbCreateLine(s '("device" "drawing") list(list(-0.25 4.0) list(0 4.0)))
dbCreateLabel(s '("device" "drawing") list(0.1 4.0) "BLB1" "centerLeft" "R0" "roman" .14)
schCreateSymbolPin(s dbOpenCellViewByType("basic" "sympin" "symbol" "" "r") "BLB2" "inputOutput" list(-0.25 3.5) "R0" t nil nil "signal")
dbCreateLine(s '("device" "drawing") list(list(-0.25 3.5) list(0 3.5)))
dbCreateLabel(s '("device" "drawing") list(0.1 3.5) "BLB2" "centerLeft" "R0" "roman" .14)
schCreateSymbolPin(s dbOpenCellViewByType("basic" "sympin" "symbol" "" "r") "BLB3" "inputOutput" list(-0.25 3.0) "R0" t nil nil "signal")
dbCreateLine(s '("device" "drawing") list(list(-0.25 3.0) list(0 3.0)))
dbCreateLabel(s '("device" "drawing") list(0.1 3.0) "BLB3" "centerLeft" "R0" "roman" .14)
schCreateSymbolPin(s dbOpenCellViewByType("basic" "sympin" "symbol" "" "r") "BLB4" "inputOutput" list(-0.25 2.5) "R0" t nil nil "signal")
dbCreateLine(s '("device" "drawing") list(list(-0.25 2.5) list(0 2.5)))
dbCreateLabel(s '("device" "drawing") list(0.1 2.5) "BLB4" "centerLeft" "R0" "roman" .14)
schCreateSymbolPin(s dbOpenCellViewByType("basic" "sympin" "symbol" "" "r") "BLB5" "inputOutput" list(-0.25 2.0) "R0" t nil nil "signal")
dbCreateLine(s '("device" "drawing") list(list(-0.25 2.0) list(0 2.0)))
dbCreateLabel(s '("device" "drawing") list(0.1 2.0) "BLB5" "centerLeft" "R0" "roman" .14)
schCreateSymbolPin(s dbOpenCellViewByType("basic" "sympin" "symbol" "" "r") "GBL" "inputOutput" list(-0.25 1.5) "R0" t nil nil "signal")
dbCreateLine(s '("device" "drawing") list(list(-0.25 1.5) list(0 1.5)))
dbCreateLabel(s '("device" "drawing") list(0.1 1.5) "GBL" "centerLeft" "R0" "roman" .14)
schCreateSymbolPin(s dbOpenCellViewByType("basic" "sympin" "symbol" "" "r") "GBLB" "inputOutput" list(-0.25 1.0) "R0" t nil nil "signal")
dbCreateLine(s '("device" "drawing") list(list(-0.25 1.0) list(0 1.0)))
dbCreateLabel(s '("device" "drawing") list(0.1 1.0) "GBLB" "centerLeft" "R0" "roman" .14)
schCreateSymbolPin(s dbOpenCellViewByType("basic" "sympin" "symbol" "" "r") "VDD" "input" list(2 11.25) "R0" t nil nil "power")
dbCreateLine(s '("device" "drawing") list(list(2 11.25) list(2 11.0)))
dbCreateLabel(s '("device" "drawing") list(2 10.8) "VDD" "centerCenter" "R0" "roman" .14)
schCreateSymbolPin(s dbOpenCellViewByType("basic" "sympin" "symbol" "" "r") "GND" "input" list(2 -0.25) "R0" t nil nil "ground")
dbCreateLine(s '("device" "drawing") list(list(2 -0.25) list(2 0)))
dbCreateLabel(s '("device" "drawing") list(2 0.2) "GND" "centerCenter" "R0" "roman" .14)
dbSave(s) dbClose(s)
s=dbOpenCellViewByType("sram_project" "precharge" "symbol" "schematicSymbol" "w")
dbCreateRect(s '("device" "drawing") list(list(0.0 0.0) list(4.0 7.5)))
dbCreateLabel(s '("device" "drawing") list(2.0 3.75) "precharge" "centerCenter" "R0" "roman" .18)
schCreateSymbolPin(s dbOpenCellViewByType("basic" "sympin" "symbol" "" "r") "BL0" "inputOutput" list(-0.25 7.0) "R0" t nil nil "signal")
dbCreateLine(s '("device" "drawing") list(list(-0.25 7.0) list(0 7.0)))
dbCreateLabel(s '("device" "drawing") list(0.1 7.0) "BL0" "centerLeft" "R0" "roman" .14)
schCreateSymbolPin(s dbOpenCellViewByType("basic" "sympin" "symbol" "" "r") "BL1" "inputOutput" list(-0.25 6.5) "R0" t nil nil "signal")
dbCreateLine(s '("device" "drawing") list(list(-0.25 6.5) list(0 6.5)))
dbCreateLabel(s '("device" "drawing") list(0.1 6.5) "BL1" "centerLeft" "R0" "roman" .14)
schCreateSymbolPin(s dbOpenCellViewByType("basic" "sympin" "symbol" "" "r") "BL2" "inputOutput" list(-0.25 6.0) "R0" t nil nil "signal")
dbCreateLine(s '("device" "drawing") list(list(-0.25 6.0) list(0 6.0)))
dbCreateLabel(s '("device" "drawing") list(0.1 6.0) "BL2" "centerLeft" "R0" "roman" .14)
schCreateSymbolPin(s dbOpenCellViewByType("basic" "sympin" "symbol" "" "r") "BL3" "inputOutput" list(-0.25 5.5) "R0" t nil nil "signal")
dbCreateLine(s '("device" "drawing") list(list(-0.25 5.5) list(0 5.5)))
dbCreateLabel(s '("device" "drawing") list(0.1 5.5) "BL3" "centerLeft" "R0" "roman" .14)
schCreateSymbolPin(s dbOpenCellViewByType("basic" "sympin" "symbol" "" "r") "BL4" "inputOutput" list(-0.25 5.0) "R0" t nil nil "signal")
dbCreateLine(s '("device" "drawing") list(list(-0.25 5.0) list(0 5.0)))
dbCreateLabel(s '("device" "drawing") list(0.1 5.0) "BL4" "centerLeft" "R0" "roman" .14)
schCreateSymbolPin(s dbOpenCellViewByType("basic" "sympin" "symbol" "" "r") "BL5" "inputOutput" list(-0.25 4.5) "R0" t nil nil "signal")
dbCreateLine(s '("device" "drawing") list(list(-0.25 4.5) list(0 4.5)))
dbCreateLabel(s '("device" "drawing") list(0.1 4.5) "BL5" "centerLeft" "R0" "roman" .14)
schCreateSymbolPin(s dbOpenCellViewByType("basic" "sympin" "symbol" "" "r") "BLB0" "inputOutput" list(-0.25 4.0) "R0" t nil nil "signal")
dbCreateLine(s '("device" "drawing") list(list(-0.25 4.0) list(0 4.0)))
dbCreateLabel(s '("device" "drawing") list(0.1 4.0) "BLB0" "centerLeft" "R0" "roman" .14)
schCreateSymbolPin(s dbOpenCellViewByType("basic" "sympin" "symbol" "" "r") "BLB1" "inputOutput" list(-0.25 3.5) "R0" t nil nil "signal")
dbCreateLine(s '("device" "drawing") list(list(-0.25 3.5) list(0 3.5)))
dbCreateLabel(s '("device" "drawing") list(0.1 3.5) "BLB1" "centerLeft" "R0" "roman" .14)
schCreateSymbolPin(s dbOpenCellViewByType("basic" "sympin" "symbol" "" "r") "BLB2" "inputOutput" list(-0.25 3.0) "R0" t nil nil "signal")
dbCreateLine(s '("device" "drawing") list(list(-0.25 3.0) list(0 3.0)))
dbCreateLabel(s '("device" "drawing") list(0.1 3.0) "BLB2" "centerLeft" "R0" "roman" .14)
schCreateSymbolPin(s dbOpenCellViewByType("basic" "sympin" "symbol" "" "r") "BLB3" "inputOutput" list(-0.25 2.5) "R0" t nil nil "signal")
dbCreateLine(s '("device" "drawing") list(list(-0.25 2.5) list(0 2.5)))
dbCreateLabel(s '("device" "drawing") list(0.1 2.5) "BLB3" "centerLeft" "R0" "roman" .14)
schCreateSymbolPin(s dbOpenCellViewByType("basic" "sympin" "symbol" "" "r") "BLB4" "inputOutput" list(-0.25 2.0) "R0" t nil nil "signal")
dbCreateLine(s '("device" "drawing") list(list(-0.25 2.0) list(0 2.0)))
dbCreateLabel(s '("device" "drawing") list(0.1 2.0) "BLB4" "centerLeft" "R0" "roman" .14)
schCreateSymbolPin(s dbOpenCellViewByType("basic" "sympin" "symbol" "" "r") "BLB5" "inputOutput" list(-0.25 1.5) "R0" t nil nil "signal")
dbCreateLine(s '("device" "drawing") list(list(-0.25 1.5) list(0 1.5)))
dbCreateLabel(s '("device" "drawing") list(0.1 1.5) "BLB5" "centerLeft" "R0" "roman" .14)
schCreateSymbolPin(s dbOpenCellViewByType("basic" "sympin" "symbol" "" "r") "PCB" "input" list(-0.25 1.0) "R0" t nil nil "signal")
dbCreateLine(s '("device" "drawing") list(list(-0.25 1.0) list(0 1.0)))
dbCreateLabel(s '("device" "drawing") list(0.1 1.0) "PCB" "centerLeft" "R0" "roman" .14)
schCreateSymbolPin(s dbOpenCellViewByType("basic" "sympin" "symbol" "" "r") "VDD" "input" list(2 7.75) "R0" t nil nil "power")
dbCreateLine(s '("device" "drawing") list(list(2 7.75) list(2 7.5)))
dbCreateLabel(s '("device" "drawing") list(2 7.3) "VDD" "centerCenter" "R0" "roman" .14)
schCreateSymbolPin(s dbOpenCellViewByType("basic" "sympin" "symbol" "" "r") "GND" "input" list(2 -0.25) "R0" t nil nil "ground")
dbCreateLine(s '("device" "drawing") list(list(2 -0.25) list(2 0)))
dbCreateLabel(s '("device" "drawing") list(2 0.2) "GND" "centerCenter" "R0" "roman" .14)
dbSave(s) dbClose(s)
s=dbOpenCellViewByType("sram_project" "bitcell" "symbol" "schematicSymbol" "w")
dbCreateRect(s '("device" "drawing") list(list(0.0 0.0) list(4.0 2.5)))
dbCreateLabel(s '("device" "drawing") list(2.0 1.25) "bitcell" "centerCenter" "R0" "roman" .18)
schCreateSymbolPin(s dbOpenCellViewByType("basic" "sympin" "symbol" "" "r") "BL" "inputOutput" list(-0.25 2.0) "R0" t nil nil "signal")
dbCreateLine(s '("device" "drawing") list(list(-0.25 2.0) list(0 2.0)))
dbCreateLabel(s '("device" "drawing") list(0.1 2.0) "BL" "centerLeft" "R0" "roman" .14)
schCreateSymbolPin(s dbOpenCellViewByType("basic" "sympin" "symbol" "" "r") "BL_bar" "inputOutput" list(-0.25 1.5) "R0" t nil nil "signal")
dbCreateLine(s '("device" "drawing") list(list(-0.25 1.5) list(0 1.5)))
dbCreateLabel(s '("device" "drawing") list(0.1 1.5) "BL_bar" "centerLeft" "R0" "roman" .14)
schCreateSymbolPin(s dbOpenCellViewByType("basic" "sympin" "symbol" "" "r") "WL" "input" list(-0.25 1.0) "R0" t nil nil "signal")
dbCreateLine(s '("device" "drawing") list(list(-0.25 1.0) list(0 1.0)))
dbCreateLabel(s '("device" "drawing") list(0.1 1.0) "WL" "centerLeft" "R0" "roman" .14)
schCreateSymbolPin(s dbOpenCellViewByType("basic" "sympin" "symbol" "" "r") "Q" "inputOutput" list(4.25 2.0) "R0" t nil nil "signal")
dbCreateLine(s '("device" "drawing") list(list(4.25 2.0) list(4 2.0)))
dbCreateLabel(s '("device" "drawing") list(3.9 2.0) "Q" "centerRight" "R0" "roman" .14)
schCreateSymbolPin(s dbOpenCellViewByType("basic" "sympin" "symbol" "" "r") "Q_bar" "inputOutput" list(4.25 1.5) "R0" t nil nil "signal")
dbCreateLine(s '("device" "drawing") list(list(4.25 1.5) list(4 1.5)))
dbCreateLabel(s '("device" "drawing") list(3.9 1.5) "Q_bar" "centerRight" "R0" "roman" .14)
schCreateSymbolPin(s dbOpenCellViewByType("basic" "sympin" "symbol" "" "r") "VDD" "input" list(2 2.75) "R0" t nil nil "power")
dbCreateLine(s '("device" "drawing") list(list(2 2.75) list(2 2.5)))
dbCreateLabel(s '("device" "drawing") list(2 2.3) "VDD" "centerCenter" "R0" "roman" .14)
schCreateSymbolPin(s dbOpenCellViewByType("basic" "sympin" "symbol" "" "r") "GND" "input" list(2 -0.25) "R0" t nil nil "ground")
dbCreateLine(s '("device" "drawing") list(list(2 -0.25) list(2 0)))
dbCreateLabel(s '("device" "drawing") list(2 0.2) "GND" "centerCenter" "R0" "roman" .14)
dbSave(s) dbClose(s)
s=dbOpenCellViewByType("sram_project" "bit_array" "symbol" "schematicSymbol" "w")
dbCreateRect(s '("device" "drawing") list(list(0.0 0.0) list(4.0 9.0)))
dbCreateLabel(s '("device" "drawing") list(2.0 4.5) "bit_array" "centerCenter" "R0" "roman" .18)
schCreateSymbolPin(s dbOpenCellViewByType("basic" "sympin" "symbol" "" "r") "WL0" "input" list(-0.25 8.5) "R0" t nil nil "signal")
dbCreateLine(s '("device" "drawing") list(list(-0.25 8.5) list(0 8.5)))
dbCreateLabel(s '("device" "drawing") list(0.1 8.5) "WL0" "centerLeft" "R0" "roman" .14)
schCreateSymbolPin(s dbOpenCellViewByType("basic" "sympin" "symbol" "" "r") "WL1" "input" list(-0.25 8.0) "R0" t nil nil "signal")
dbCreateLine(s '("device" "drawing") list(list(-0.25 8.0) list(0 8.0)))
dbCreateLabel(s '("device" "drawing") list(0.1 8.0) "WL1" "centerLeft" "R0" "roman" .14)
schCreateSymbolPin(s dbOpenCellViewByType("basic" "sympin" "symbol" "" "r") "WL2" "input" list(-0.25 7.5) "R0" t nil nil "signal")
dbCreateLine(s '("device" "drawing") list(list(-0.25 7.5) list(0 7.5)))
dbCreateLabel(s '("device" "drawing") list(0.1 7.5) "WL2" "centerLeft" "R0" "roman" .14)
schCreateSymbolPin(s dbOpenCellViewByType("basic" "sympin" "symbol" "" "r") "WL3" "input" list(-0.25 7.0) "R0" t nil nil "signal")
dbCreateLine(s '("device" "drawing") list(list(-0.25 7.0) list(0 7.0)))
dbCreateLabel(s '("device" "drawing") list(0.1 7.0) "WL3" "centerLeft" "R0" "roman" .14)
schCreateSymbolPin(s dbOpenCellViewByType("basic" "sympin" "symbol" "" "r") "BL0" "inputOutput" list(-0.25 6.5) "R0" t nil nil "signal")
dbCreateLine(s '("device" "drawing") list(list(-0.25 6.5) list(0 6.5)))
dbCreateLabel(s '("device" "drawing") list(0.1 6.5) "BL0" "centerLeft" "R0" "roman" .14)
schCreateSymbolPin(s dbOpenCellViewByType("basic" "sympin" "symbol" "" "r") "BL1" "inputOutput" list(-0.25 6.0) "R0" t nil nil "signal")
dbCreateLine(s '("device" "drawing") list(list(-0.25 6.0) list(0 6.0)))
dbCreateLabel(s '("device" "drawing") list(0.1 6.0) "BL1" "centerLeft" "R0" "roman" .14)
schCreateSymbolPin(s dbOpenCellViewByType("basic" "sympin" "symbol" "" "r") "BL2" "inputOutput" list(-0.25 5.5) "R0" t nil nil "signal")
dbCreateLine(s '("device" "drawing") list(list(-0.25 5.5) list(0 5.5)))
dbCreateLabel(s '("device" "drawing") list(0.1 5.5) "BL2" "centerLeft" "R0" "roman" .14)
schCreateSymbolPin(s dbOpenCellViewByType("basic" "sympin" "symbol" "" "r") "BL3" "inputOutput" list(-0.25 5.0) "R0" t nil nil "signal")
dbCreateLine(s '("device" "drawing") list(list(-0.25 5.0) list(0 5.0)))
dbCreateLabel(s '("device" "drawing") list(0.1 5.0) "BL3" "centerLeft" "R0" "roman" .14)
schCreateSymbolPin(s dbOpenCellViewByType("basic" "sympin" "symbol" "" "r") "BL4" "inputOutput" list(-0.25 4.5) "R0" t nil nil "signal")
dbCreateLine(s '("device" "drawing") list(list(-0.25 4.5) list(0 4.5)))
dbCreateLabel(s '("device" "drawing") list(0.1 4.5) "BL4" "centerLeft" "R0" "roman" .14)
schCreateSymbolPin(s dbOpenCellViewByType("basic" "sympin" "symbol" "" "r") "BL5" "inputOutput" list(-0.25 4.0) "R0" t nil nil "signal")
dbCreateLine(s '("device" "drawing") list(list(-0.25 4.0) list(0 4.0)))
dbCreateLabel(s '("device" "drawing") list(0.1 4.0) "BL5" "centerLeft" "R0" "roman" .14)
schCreateSymbolPin(s dbOpenCellViewByType("basic" "sympin" "symbol" "" "r") "BLB0" "inputOutput" list(-0.25 3.5) "R0" t nil nil "signal")
dbCreateLine(s '("device" "drawing") list(list(-0.25 3.5) list(0 3.5)))
dbCreateLabel(s '("device" "drawing") list(0.1 3.5) "BLB0" "centerLeft" "R0" "roman" .14)
schCreateSymbolPin(s dbOpenCellViewByType("basic" "sympin" "symbol" "" "r") "BLB1" "inputOutput" list(-0.25 3.0) "R0" t nil nil "signal")
dbCreateLine(s '("device" "drawing") list(list(-0.25 3.0) list(0 3.0)))
dbCreateLabel(s '("device" "drawing") list(0.1 3.0) "BLB1" "centerLeft" "R0" "roman" .14)
schCreateSymbolPin(s dbOpenCellViewByType("basic" "sympin" "symbol" "" "r") "BLB2" "inputOutput" list(-0.25 2.5) "R0" t nil nil "signal")
dbCreateLine(s '("device" "drawing") list(list(-0.25 2.5) list(0 2.5)))
dbCreateLabel(s '("device" "drawing") list(0.1 2.5) "BLB2" "centerLeft" "R0" "roman" .14)
schCreateSymbolPin(s dbOpenCellViewByType("basic" "sympin" "symbol" "" "r") "BLB3" "inputOutput" list(-0.25 2.0) "R0" t nil nil "signal")
dbCreateLine(s '("device" "drawing") list(list(-0.25 2.0) list(0 2.0)))
dbCreateLabel(s '("device" "drawing") list(0.1 2.0) "BLB3" "centerLeft" "R0" "roman" .14)
schCreateSymbolPin(s dbOpenCellViewByType("basic" "sympin" "symbol" "" "r") "BLB4" "inputOutput" list(-0.25 1.5) "R0" t nil nil "signal")
dbCreateLine(s '("device" "drawing") list(list(-0.25 1.5) list(0 1.5)))
dbCreateLabel(s '("device" "drawing") list(0.1 1.5) "BLB4" "centerLeft" "R0" "roman" .14)
schCreateSymbolPin(s dbOpenCellViewByType("basic" "sympin" "symbol" "" "r") "BLB5" "inputOutput" list(-0.25 1.0) "R0" t nil nil "signal")
dbCreateLine(s '("device" "drawing") list(list(-0.25 1.0) list(0 1.0)))
dbCreateLabel(s '("device" "drawing") list(0.1 1.0) "BLB5" "centerLeft" "R0" "roman" .14)
schCreateSymbolPin(s dbOpenCellViewByType("basic" "sympin" "symbol" "" "r") "VDD" "input" list(2 9.25) "R0" t nil nil "power")
dbCreateLine(s '("device" "drawing") list(list(2 9.25) list(2 9.0)))
dbCreateLabel(s '("device" "drawing") list(2 8.8) "VDD" "centerCenter" "R0" "roman" .14)
schCreateSymbolPin(s dbOpenCellViewByType("basic" "sympin" "symbol" "" "r") "GND" "input" list(2 -0.25) "R0" t nil nil "ground")
dbCreateLine(s '("device" "drawing") list(list(2 -0.25) list(2 0)))
dbCreateLabel(s '("device" "drawing") list(2 0.2) "GND" "centerCenter" "R0" "roman" .14)
dbSave(s) dbClose(s)
s=dbOpenCellViewByType("sram_project" "sram_4x6" "symbol" "schematicSymbol" "w")
dbCreateRect(s '("device" "drawing") list(list(0.0 0.0) list(4.0 6.0)))
dbCreateLabel(s '("device" "drawing") list(2.0 3.0) "sram_4x6" "centerCenter" "R0" "roman" .18)
schCreateSymbolPin(s dbOpenCellViewByType("basic" "sympin" "symbol" "" "r") "R1" "input" list(-0.25 5.5) "R0" t nil nil "signal")
dbCreateLine(s '("device" "drawing") list(list(-0.25 5.5) list(0 5.5)))
dbCreateLabel(s '("device" "drawing") list(0.1 5.5) "R1" "centerLeft" "R0" "roman" .14)
schCreateSymbolPin(s dbOpenCellViewByType("basic" "sympin" "symbol" "" "r") "R0" "input" list(-0.25 5.0) "R0" t nil nil "signal")
dbCreateLine(s '("device" "drawing") list(list(-0.25 5.0) list(0 5.0)))
dbCreateLabel(s '("device" "drawing") list(0.1 5.0) "R0" "centerLeft" "R0" "roman" .14)
schCreateSymbolPin(s dbOpenCellViewByType("basic" "sympin" "symbol" "" "r") "C2" "input" list(-0.25 4.5) "R0" t nil nil "signal")
dbCreateLine(s '("device" "drawing") list(list(-0.25 4.5) list(0 4.5)))
dbCreateLabel(s '("device" "drawing") list(0.1 4.5) "C2" "centerLeft" "R0" "roman" .14)
schCreateSymbolPin(s dbOpenCellViewByType("basic" "sympin" "symbol" "" "r") "C1" "input" list(-0.25 4.0) "R0" t nil nil "signal")
dbCreateLine(s '("device" "drawing") list(list(-0.25 4.0) list(0 4.0)))
dbCreateLabel(s '("device" "drawing") list(0.1 4.0) "C1" "centerLeft" "R0" "roman" .14)
schCreateSymbolPin(s dbOpenCellViewByType("basic" "sympin" "symbol" "" "r") "C0" "input" list(-0.25 3.5) "R0" t nil nil "signal")
dbCreateLine(s '("device" "drawing") list(list(-0.25 3.5) list(0 3.5)))
dbCreateLabel(s '("device" "drawing") list(0.1 3.5) "C0" "centerLeft" "R0" "roman" .14)
schCreateSymbolPin(s dbOpenCellViewByType("basic" "sympin" "symbol" "" "r") "CLK1" "input" list(-0.25 3.0) "R0" t nil nil "signal")
dbCreateLine(s '("device" "drawing") list(list(-0.25 3.0) list(0 3.0)))
dbCreateLabel(s '("device" "drawing") list(0.1 3.0) "CLK1" "centerLeft" "R0" "roman" .14)
schCreateSymbolPin(s dbOpenCellViewByType("basic" "sympin" "symbol" "" "r") "CLK2" "input" list(-0.25 2.5) "R0" t nil nil "signal")
dbCreateLine(s '("device" "drawing") list(list(-0.25 2.5) list(0 2.5)))
dbCreateLabel(s '("device" "drawing") list(0.1 2.5) "CLK2" "centerLeft" "R0" "roman" .14)
schCreateSymbolPin(s dbOpenCellViewByType("basic" "sympin" "symbol" "" "r") "WR" "input" list(-0.25 2.0) "R0" t nil nil "signal")
dbCreateLine(s '("device" "drawing") list(list(-0.25 2.0) list(0 2.0)))
dbCreateLabel(s '("device" "drawing") list(0.1 2.0) "WR" "centerLeft" "R0" "roman" .14)
schCreateSymbolPin(s dbOpenCellViewByType("basic" "sympin" "symbol" "" "r") "RD" "input" list(-0.25 1.5) "R0" t nil nil "signal")
dbCreateLine(s '("device" "drawing") list(list(-0.25 1.5) list(0 1.5)))
dbCreateLabel(s '("device" "drawing") list(0.1 1.5) "RD" "centerLeft" "R0" "roman" .14)
schCreateSymbolPin(s dbOpenCellViewByType("basic" "sympin" "symbol" "" "r") "DIN" "input" list(-0.25 1.0) "R0" t nil nil "signal")
dbCreateLine(s '("device" "drawing") list(list(-0.25 1.0) list(0 1.0)))
dbCreateLabel(s '("device" "drawing") list(0.1 1.0) "DIN" "centerLeft" "R0" "roman" .14)
schCreateSymbolPin(s dbOpenCellViewByType("basic" "sympin" "symbol" "" "r") "DOUT" "output" list(4.25 5.5) "R0" t nil nil "signal")
dbCreateLine(s '("device" "drawing") list(list(4.25 5.5) list(4 5.5)))
dbCreateLabel(s '("device" "drawing") list(3.9 5.5) "DOUT" "centerRight" "R0" "roman" .14)
schCreateSymbolPin(s dbOpenCellViewByType("basic" "sympin" "symbol" "" "r") "VDD" "input" list(2 6.25) "R0" t nil nil "power")
dbCreateLine(s '("device" "drawing") list(list(2 6.25) list(2 6.0)))
dbCreateLabel(s '("device" "drawing") list(2 5.8) "VDD" "centerCenter" "R0" "roman" .14)
schCreateSymbolPin(s dbOpenCellViewByType("basic" "sympin" "symbol" "" "r") "GND" "input" list(2 -0.25) "R0" t nil nil "ground")
dbCreateLine(s '("device" "drawing") list(list(2 -0.25) list(2 0)))
dbCreateLabel(s '("device" "drawing") list(2 0.2) "GND" "centerCenter" "R0" "roman" .14)
dbSave(s) dbClose(s)
cv=dbOpenCellViewByType("sram_project" "inv" "schematic" "schematic" "w")
i=schCreateInst(cv dbOpenCellViewByType("gpdk045" "nmos1v" "symbol" "" "r") "NM0" list(4 -3) "R0")
dbReplaceProp(i "w" "string" "360n") dbReplaceProp(i "l" "string" "45n")
stub(cv i "D" "OUT")
stub(cv i "G" "IN")
stub(cv i "S" "GND")
stub(cv i "B" "GND")
i=schCreateInst(cv dbOpenCellViewByType("gpdk045" "pmos1v" "symbol" "" "r") "PM0" list(9 -3) "R0")
dbReplaceProp(i "w" "string" "360n") dbReplaceProp(i "l" "string" "45n")
stub(cv i "D" "OUT")
stub(cv i "G" "IN")
stub(cv i "S" "VDD")
stub(cv i "B" "VDD")
schCreatePin(cv dbOpenCellViewByType("basic" "ipin" "symbol" "" "r") "IN" "input" nil list(-3 2.0) "R0" nil nil "signal")
schCreatePin(cv dbOpenCellViewByType("basic" "opin" "symbol" "" "r") "OUT" "output" nil list(-3 1.5) "R0" nil nil "signal")
schCreatePin(cv dbOpenCellViewByType("basic" "ipin" "symbol" "" "r") "VDD" "input" nil list(-3 1.0) "R0" nil nil "power")
schCreatePin(cv dbOpenCellViewByType("basic" "ipin" "symbol" "" "r") "GND" "input" nil list(-3 0.5) "R0" nil nil "ground")
dbSave(cv) dbClose(cv)
cv=dbOpenCellViewByType("sram_project" "nand3" "schematic" "schematic" "w")
i=schCreateInst(cv dbOpenCellViewByType("gpdk045" "nmos1v" "symbol" "" "r") "NM0" list(4 -3) "R0")
dbReplaceProp(i "w" "string" "1080n") dbReplaceProp(i "l" "string" "45n")
stub(cv i "D" "Y")
stub(cv i "G" "A")
stub(cv i "S" "n1")
stub(cv i "B" "GND")
i=schCreateInst(cv dbOpenCellViewByType("gpdk045" "nmos1v" "symbol" "" "r") "NM1" list(9 -3) "R0")
dbReplaceProp(i "w" "string" "1080n") dbReplaceProp(i "l" "string" "45n")
stub(cv i "D" "n1")
stub(cv i "G" "B")
stub(cv i "S" "n2")
stub(cv i "B" "GND")
i=schCreateInst(cv dbOpenCellViewByType("gpdk045" "nmos1v" "symbol" "" "r") "NM2" list(14 -3) "R0")
dbReplaceProp(i "w" "string" "1080n") dbReplaceProp(i "l" "string" "45n")
stub(cv i "D" "n2")
stub(cv i "G" "E")
stub(cv i "S" "GND")
stub(cv i "B" "GND")
i=schCreateInst(cv dbOpenCellViewByType("gpdk045" "pmos1v" "symbol" "" "r") "PM0" list(19 -3) "R0")
dbReplaceProp(i "w" "string" "360n") dbReplaceProp(i "l" "string" "45n")
stub(cv i "D" "Y")
stub(cv i "G" "A")
stub(cv i "S" "VDD")
stub(cv i "B" "VDD")
i=schCreateInst(cv dbOpenCellViewByType("gpdk045" "pmos1v" "symbol" "" "r") "PM1" list(4 -8) "R0")
dbReplaceProp(i "w" "string" "360n") dbReplaceProp(i "l" "string" "45n")
stub(cv i "D" "Y")
stub(cv i "G" "B")
stub(cv i "S" "VDD")
stub(cv i "B" "VDD")
i=schCreateInst(cv dbOpenCellViewByType("gpdk045" "pmos1v" "symbol" "" "r") "PM2" list(9 -8) "R0")
dbReplaceProp(i "w" "string" "360n") dbReplaceProp(i "l" "string" "45n")
stub(cv i "D" "Y")
stub(cv i "G" "E")
stub(cv i "S" "VDD")
stub(cv i "B" "VDD")
schCreatePin(cv dbOpenCellViewByType("basic" "ipin" "symbol" "" "r") "A" "input" nil list(-3 2.0) "R0" nil nil "signal")
schCreatePin(cv dbOpenCellViewByType("basic" "ipin" "symbol" "" "r") "B" "input" nil list(-3 1.5) "R0" nil nil "signal")
schCreatePin(cv dbOpenCellViewByType("basic" "ipin" "symbol" "" "r") "E" "input" nil list(-3 1.0) "R0" nil nil "signal")
schCreatePin(cv dbOpenCellViewByType("basic" "opin" "symbol" "" "r") "Y" "output" nil list(-3 0.5) "R0" nil nil "signal")
schCreatePin(cv dbOpenCellViewByType("basic" "ipin" "symbol" "" "r") "VDD" "input" nil list(-3 0.0) "R0" nil nil "power")
schCreatePin(cv dbOpenCellViewByType("basic" "ipin" "symbol" "" "r") "GND" "input" nil list(-3 -0.5) "R0" nil nil "ground")
dbSave(cv) dbClose(cv)
cv=dbOpenCellViewByType("sram_project" "and3" "schematic" "schematic" "w")
i=schCreateInst(cv dbOpenCellViewByType("sram_project" "nand3" "symbol" "" "r") "XNAND" list(5 -5.5) "R0")
end=stub(cv i "A" "A")
end=stub(cv i "B" "B")
end=stub(cv i "E" "E")
end=stub(cv i "Y" "nb")
end=stub(cv i "VDD" "VDD")
end=stub(cv i "GND" "GND")
i=schCreateInst(cv dbOpenCellViewByType("sram_project" "inv" "symbol" "" "r") "XBUF" list(15 -5.5) "R0")
end=stub(cv i "IN" "nb")
end=stub(cv i "OUT" "Y")
end=stub(cv i "VDD" "VDD")
end=stub(cv i "GND" "GND")
schCreatePin(cv dbOpenCellViewByType("basic" "ipin" "symbol" "" "r") "A" "input" nil list(-3 2.0) "R0" nil nil "signal")
schCreatePin(cv dbOpenCellViewByType("basic" "ipin" "symbol" "" "r") "B" "input" nil list(-3 1.5) "R0" nil nil "signal")
schCreatePin(cv dbOpenCellViewByType("basic" "ipin" "symbol" "" "r") "E" "input" nil list(-3 1.0) "R0" nil nil "signal")
schCreatePin(cv dbOpenCellViewByType("basic" "opin" "symbol" "" "r") "Y" "output" nil list(-3 0.5) "R0" nil nil "signal")
schCreatePin(cv dbOpenCellViewByType("basic" "ipin" "symbol" "" "r") "VDD" "input" nil list(-3 0.0) "R0" nil nil "power")
schCreatePin(cv dbOpenCellViewByType("basic" "ipin" "symbol" "" "r") "GND" "input" nil list(-3 -0.5) "R0" nil nil "ground")
dbSave(cv) dbClose(cv)
cv=dbOpenCellViewByType("sram_project" "nand2" "schematic" "schematic" "w")
i=schCreateInst(cv dbOpenCellViewByType("gpdk045" "nmos1v" "symbol" "" "r") "N0" list(4 -3) "R0")
dbReplaceProp(i "w" "string" "720n") dbReplaceProp(i "l" "string" "45n")
stub(cv i "D" "Y")
stub(cv i "G" "A")
stub(cv i "S" "n0")
stub(cv i "B" "GND")
i=schCreateInst(cv dbOpenCellViewByType("gpdk045" "nmos1v" "symbol" "" "r") "N1" list(9 -3) "R0")
dbReplaceProp(i "w" "string" "720n") dbReplaceProp(i "l" "string" "45n")
stub(cv i "D" "n0")
stub(cv i "G" "B")
stub(cv i "S" "GND")
stub(cv i "B" "GND")
i=schCreateInst(cv dbOpenCellViewByType("gpdk045" "pmos1v" "symbol" "" "r") "P0" list(14 -3) "R0")
dbReplaceProp(i "w" "string" "360n") dbReplaceProp(i "l" "string" "45n")
stub(cv i "D" "Y")
stub(cv i "G" "A")
stub(cv i "S" "VDD")
stub(cv i "B" "VDD")
i=schCreateInst(cv dbOpenCellViewByType("gpdk045" "pmos1v" "symbol" "" "r") "P1" list(19 -3) "R0")
dbReplaceProp(i "w" "string" "360n") dbReplaceProp(i "l" "string" "45n")
stub(cv i "D" "Y")
stub(cv i "G" "B")
stub(cv i "S" "VDD")
stub(cv i "B" "VDD")
schCreatePin(cv dbOpenCellViewByType("basic" "ipin" "symbol" "" "r") "A" "input" nil list(-3 2.0) "R0" nil nil "signal")
schCreatePin(cv dbOpenCellViewByType("basic" "ipin" "symbol" "" "r") "B" "input" nil list(-3 1.5) "R0" nil nil "signal")
schCreatePin(cv dbOpenCellViewByType("basic" "opin" "symbol" "" "r") "Y" "output" nil list(-3 1.0) "R0" nil nil "signal")
schCreatePin(cv dbOpenCellViewByType("basic" "ipin" "symbol" "" "r") "VDD" "input" nil list(-3 0.5) "R0" nil nil "power")
schCreatePin(cv dbOpenCellViewByType("basic" "ipin" "symbol" "" "r") "GND" "input" nil list(-3 0.0) "R0" nil nil "ground")
dbSave(cv) dbClose(cv)
cv=dbOpenCellViewByType("sram_project" "tg" "schematic" "schematic" "w")
i=schCreateInst(cv dbOpenCellViewByType("gpdk045" "nmos1v" "symbol" "" "r") "N" list(4 -3) "R0")
dbReplaceProp(i "w" "string" "1080n") dbReplaceProp(i "l" "string" "45n")
stub(cv i "D" "B")
stub(cv i "G" "EN")
stub(cv i "S" "A")
stub(cv i "B" "GND")
i=schCreateInst(cv dbOpenCellViewByType("gpdk045" "pmos1v" "symbol" "" "r") "P" list(9 -3) "R0")
dbReplaceProp(i "w" "string" "1080n") dbReplaceProp(i "l" "string" "45n")
stub(cv i "D" "B")
stub(cv i "G" "ENB")
stub(cv i "S" "A")
stub(cv i "B" "VDD")
schCreatePin(cv dbOpenCellViewByType("basic" "iopin" "symbol" "" "r") "A" "inputOutput" nil list(-3 2.0) "R0" nil nil "signal")
schCreatePin(cv dbOpenCellViewByType("basic" "iopin" "symbol" "" "r") "B" "inputOutput" nil list(-3 1.5) "R0" nil nil "signal")
schCreatePin(cv dbOpenCellViewByType("basic" "ipin" "symbol" "" "r") "EN" "input" nil list(-3 1.0) "R0" nil nil "signal")
schCreatePin(cv dbOpenCellViewByType("basic" "ipin" "symbol" "" "r") "ENB" "input" nil list(-3 0.5) "R0" nil nil "signal")
schCreatePin(cv dbOpenCellViewByType("basic" "ipin" "symbol" "" "r") "VDD" "input" nil list(-3 0.0) "R0" nil nil "power")
schCreatePin(cv dbOpenCellViewByType("basic" "ipin" "symbol" "" "r") "GND" "input" nil list(-3 -0.5) "R0" nil nil "ground")
dbSave(cv) dbClose(cv)
cv=dbOpenCellViewByType("sram_project" "precharge_unit" "schematic" "schematic" "w")
i=schCreateInst(cv dbOpenCellViewByType("gpdk045" "pmos1v" "symbol" "" "r") "P0" list(4 -3) "R0")
dbReplaceProp(i "w" "string" "1080n") dbReplaceProp(i "l" "string" "45n")
stub(cv i "D" "BL")
stub(cv i "G" "PCB")
stub(cv i "S" "VDD")
stub(cv i "B" "VDD")
i=schCreateInst(cv dbOpenCellViewByType("gpdk045" "pmos1v" "symbol" "" "r") "P1" list(9 -3) "R0")
dbReplaceProp(i "w" "string" "1080n") dbReplaceProp(i "l" "string" "45n")
stub(cv i "D" "BLB")
stub(cv i "G" "PCB")
stub(cv i "S" "VDD")
stub(cv i "B" "VDD")
i=schCreateInst(cv dbOpenCellViewByType("gpdk045" "pmos1v" "symbol" "" "r") "PEQ" list(14 -3) "R0")
dbReplaceProp(i "w" "string" "1080n") dbReplaceProp(i "l" "string" "45n")
stub(cv i "D" "BL")
stub(cv i "G" "PCB")
stub(cv i "S" "BLB")
stub(cv i "B" "VDD")
schCreatePin(cv dbOpenCellViewByType("basic" "iopin" "symbol" "" "r") "BL" "inputOutput" nil list(-3 2.0) "R0" nil nil "signal")
schCreatePin(cv dbOpenCellViewByType("basic" "iopin" "symbol" "" "r") "BLB" "inputOutput" nil list(-3 1.5) "R0" nil nil "signal")
schCreatePin(cv dbOpenCellViewByType("basic" "ipin" "symbol" "" "r") "PCB" "input" nil list(-3 1.0) "R0" nil nil "signal")
schCreatePin(cv dbOpenCellViewByType("basic" "ipin" "symbol" "" "r") "VDD" "input" nil list(-3 0.5) "R0" nil nil "power")
schCreatePin(cv dbOpenCellViewByType("basic" "ipin" "symbol" "" "r") "GND" "input" nil list(-3 0.0) "R0" nil nil "ground")
schCreateInst(cv dbOpenCellViewByType("basic" "noConn" "symbol" "" "r") "NC_GND" list(-3.0 0.0) "R0")
dbSave(cv) dbClose(cv)
cv=dbOpenCellViewByType("sram_project" "sense_amp" "schematic" "schematic" "w")
i=schCreateInst(cv dbOpenCellViewByType("gpdk045" "pmos1v" "symbol" "" "r") "PM6" list(4 -3) "R0")
dbReplaceProp(i "w" "string" "1440n") dbReplaceProp(i "l" "string" "45n")
stub(cv i "D" "nd")
stub(cv i "G" "nd")
stub(cv i "S" "VDD")
stub(cv i "B" "VDD")
i=schCreateInst(cv dbOpenCellViewByType("gpdk045" "pmos1v" "symbol" "" "r") "PM5" list(9 -3) "R0")
dbReplaceProp(i "w" "string" "1440n") dbReplaceProp(i "l" "string" "45n")
stub(cv i "D" "ns")
stub(cv i "G" "nd")
stub(cv i "S" "VDD")
stub(cv i "B" "VDD")
i=schCreateInst(cv dbOpenCellViewByType("gpdk045" "pmos1v" "symbol" "" "r") "PM7" list(14 -3) "R0")
dbReplaceProp(i "w" "string" "360n") dbReplaceProp(i "l" "string" "45n")
stub(cv i "D" "AMP_OUT")
stub(cv i "G" "ns")
stub(cv i "S" "VDD")
stub(cv i "B" "VDD")
i=schCreateInst(cv dbOpenCellViewByType("gpdk045" "nmos1v" "symbol" "" "r") "NM41" list(19 -3) "R0")
dbReplaceProp(i "w" "string" "240n") dbReplaceProp(i "l" "string" "45n")
stub(cv i "D" "ns")
stub(cv i "G" "BIT")
stub(cv i "S" "tail")
stub(cv i "B" "GND")
i=schCreateInst(cv dbOpenCellViewByType("gpdk045" "nmos1v" "symbol" "" "r") "NM40" list(4 -8) "R0")
dbReplaceProp(i "w" "string" "240n") dbReplaceProp(i "l" "string" "45n")
stub(cv i "D" "nd")
stub(cv i "G" "BIT_bar")
stub(cv i "S" "tail")
stub(cv i "B" "GND")
i=schCreateInst(cv dbOpenCellViewByType("gpdk045" "nmos1v" "symbol" "" "r") "NM39" list(9 -8) "R0")
dbReplaceProp(i "w" "string" "360n") dbReplaceProp(i "l" "string" "45n")
stub(cv i "D" "AMP_OUT")
stub(cv i "G" "ns")
stub(cv i "S" "GND")
stub(cv i "B" "GND")
i=schCreateInst(cv dbOpenCellViewByType("gpdk045" "nmos1v" "symbol" "" "r") "NM38" list(14 -8) "R0")
dbReplaceProp(i "w" "string" "360n") dbReplaceProp(i "l" "string" "45n")
stub(cv i "D" "tail")
stub(cv i "G" "RE")
stub(cv i "S" "GND")
stub(cv i "B" "GND")
schCreatePin(cv dbOpenCellViewByType("basic" "ipin" "symbol" "" "r") "BIT" "input" nil list(-3 2.0) "R0" nil nil "signal")
schCreatePin(cv dbOpenCellViewByType("basic" "ipin" "symbol" "" "r") "BIT_bar" "input" nil list(-3 1.5) "R0" nil nil "signal")
schCreatePin(cv dbOpenCellViewByType("basic" "ipin" "symbol" "" "r") "RE" "input" nil list(-3 1.0) "R0" nil nil "signal")
schCreatePin(cv dbOpenCellViewByType("basic" "ipin" "symbol" "" "r") "VDD" "input" nil list(-3 0.5) "R0" nil nil "power")
schCreatePin(cv dbOpenCellViewByType("basic" "ipin" "symbol" "" "r") "GND" "input" nil list(-3 0.0) "R0" nil nil "ground")
schCreatePin(cv dbOpenCellViewByType("basic" "opin" "symbol" "" "r") "AMP_OUT" "output" nil list(-3 -0.5) "R0" nil nil "signal")
dbSave(cv) dbClose(cv)
cv=dbOpenCellViewByType("sram_project" "read_latch" "schematic" "schematic" "w")
i=schCreateInst(cv dbOpenCellViewByType("sram_project" "tg" "symbol" "" "r") "XINPUT" list(5 -6.0) "R0")
end=stub(cv i "A" "D")
end=stub(cv i "B" "n0")
end=stub(cv i "EN" "EN")
end=stub(cv i "ENB" "ENB")
end=stub(cv i "VDD" "VDD")
end=stub(cv i "GND" "GND")
i=schCreateInst(cv dbOpenCellViewByType("sram_project" "inv" "symbol" "" "r") "XI0" list(15 -6.0) "R0")
end=stub(cv i "IN" "n0")
end=stub(cv i "OUT" "nb")
end=stub(cv i "VDD" "VDD")
end=stub(cv i "GND" "GND")
i=schCreateInst(cv dbOpenCellViewByType("sram_project" "inv" "symbol" "" "r") "XI1" list(25 -6.0) "R0")
end=stub(cv i "IN" "nb")
end=stub(cv i "OUT" "Q")
end=stub(cv i "VDD" "VDD")
end=stub(cv i "GND" "GND")
i=schCreateInst(cv dbOpenCellViewByType("sram_project" "tg" "symbol" "" "r") "XFEEDBACK" list(5 -12.0) "R0")
end=stub(cv i "A" "Q")
end=stub(cv i "B" "n0")
end=stub(cv i "EN" "ENB")
end=stub(cv i "ENB" "EN")
end=stub(cv i "VDD" "VDD")
end=stub(cv i "GND" "GND")
schCreatePin(cv dbOpenCellViewByType("basic" "ipin" "symbol" "" "r") "D" "input" nil list(-3 2.0) "R0" nil nil "signal")
schCreatePin(cv dbOpenCellViewByType("basic" "ipin" "symbol" "" "r") "EN" "input" nil list(-3 1.5) "R0" nil nil "signal")
schCreatePin(cv dbOpenCellViewByType("basic" "ipin" "symbol" "" "r") "ENB" "input" nil list(-3 1.0) "R0" nil nil "signal")
schCreatePin(cv dbOpenCellViewByType("basic" "opin" "symbol" "" "r") "Q" "output" nil list(-3 0.5) "R0" nil nil "signal")
schCreatePin(cv dbOpenCellViewByType("basic" "ipin" "symbol" "" "r") "VDD" "input" nil list(-3 0.0) "R0" nil nil "power")
schCreatePin(cv dbOpenCellViewByType("basic" "ipin" "symbol" "" "r") "GND" "input" nil list(-3 -0.5) "R0" nil nil "ground")
dbSave(cv) dbClose(cv)
cv=dbOpenCellViewByType("sram_project" "row_decoder" "schematic" "schematic" "w")
i=schCreateInst(cv dbOpenCellViewByType("sram_project" "inv" "symbol" "" "r") "XI0" list(5 -5.5) "R0")
end=stub(cv i "IN" "R0")
end=stub(cv i "OUT" "R0B")
end=stub(cv i "VDD" "VDD")
end=stub(cv i "GND" "GND")
i=schCreateInst(cv dbOpenCellViewByType("sram_project" "inv" "symbol" "" "r") "XI1" list(15 -5.5) "R0")
end=stub(cv i "IN" "R1")
end=stub(cv i "OUT" "R1B")
end=stub(cv i "VDD" "VDD")
end=stub(cv i "GND" "GND")
i=schCreateInst(cv dbOpenCellViewByType("sram_project" "and3" "symbol" "" "r") "XR0" list(25 -5.5) "R0")
end=stub(cv i "A" "R1B")
end=stub(cv i "B" "R0B")
end=stub(cv i "E" "EN")
end=stub(cv i "Y" "WL0")
end=stub(cv i "VDD" "VDD")
end=stub(cv i "GND" "GND")
i=schCreateInst(cv dbOpenCellViewByType("sram_project" "and3" "symbol" "" "r") "XR1" list(5 -11.0) "R0")
end=stub(cv i "A" "R1B")
end=stub(cv i "B" "R0")
end=stub(cv i "E" "EN")
end=stub(cv i "Y" "WL1")
end=stub(cv i "VDD" "VDD")
end=stub(cv i "GND" "GND")
i=schCreateInst(cv dbOpenCellViewByType("sram_project" "and3" "symbol" "" "r") "XR2" list(15 -11.0) "R0")
end=stub(cv i "A" "R1")
end=stub(cv i "B" "R0B")
end=stub(cv i "E" "EN")
end=stub(cv i "Y" "WL2")
end=stub(cv i "VDD" "VDD")
end=stub(cv i "GND" "GND")
i=schCreateInst(cv dbOpenCellViewByType("sram_project" "and3" "symbol" "" "r") "XR3" list(25 -11.0) "R0")
end=stub(cv i "A" "R1")
end=stub(cv i "B" "R0")
end=stub(cv i "E" "EN")
end=stub(cv i "Y" "WL3")
end=stub(cv i "VDD" "VDD")
end=stub(cv i "GND" "GND")
schCreatePin(cv dbOpenCellViewByType("basic" "ipin" "symbol" "" "r") "R1" "input" nil list(-3 2.0) "R0" nil nil "signal")
schCreatePin(cv dbOpenCellViewByType("basic" "ipin" "symbol" "" "r") "R0" "input" nil list(-3 1.5) "R0" nil nil "signal")
schCreatePin(cv dbOpenCellViewByType("basic" "ipin" "symbol" "" "r") "EN" "input" nil list(-3 1.0) "R0" nil nil "signal")
schCreatePin(cv dbOpenCellViewByType("basic" "opin" "symbol" "" "r") "WL0" "output" nil list(-3 0.5) "R0" nil nil "signal")
schCreatePin(cv dbOpenCellViewByType("basic" "opin" "symbol" "" "r") "WL1" "output" nil list(-3 0.0) "R0" nil nil "signal")
schCreatePin(cv dbOpenCellViewByType("basic" "opin" "symbol" "" "r") "WL2" "output" nil list(-3 -0.5) "R0" nil nil "signal")
schCreatePin(cv dbOpenCellViewByType("basic" "opin" "symbol" "" "r") "WL3" "output" nil list(-3 -1.0) "R0" nil nil "signal")
schCreatePin(cv dbOpenCellViewByType("basic" "ipin" "symbol" "" "r") "VDD" "input" nil list(-3 -1.5) "R0" nil nil "power")
schCreatePin(cv dbOpenCellViewByType("basic" "ipin" "symbol" "" "r") "GND" "input" nil list(-3 -2.0) "R0" nil nil "ground")
dbSave(cv) dbClose(cv)
cv=dbOpenCellViewByType("sram_project" "column_decoder" "schematic" "schematic" "w")
i=schCreateInst(cv dbOpenCellViewByType("sram_project" "inv" "symbol" "" "r") "XI0" list(5 -5.0) "R0")
end=stub(cv i "IN" "C0")
end=stub(cv i "OUT" "C0B")
end=stub(cv i "VDD" "VDD")
end=stub(cv i "GND" "GND")
i=schCreateInst(cv dbOpenCellViewByType("sram_project" "inv" "symbol" "" "r") "XI1" list(15 -5.0) "R0")
end=stub(cv i "IN" "C1")
end=stub(cv i "OUT" "C1B")
end=stub(cv i "VDD" "VDD")
end=stub(cv i "GND" "GND")
i=schCreateInst(cv dbOpenCellViewByType("sram_project" "inv" "symbol" "" "r") "XI2" list(25 -5.0) "R0")
end=stub(cv i "IN" "C2")
end=stub(cv i "OUT" "C2B")
end=stub(cv i "VDD" "VDD")
end=stub(cv i "GND" "GND")
i=schCreateInst(cv dbOpenCellViewByType("sram_project" "and3" "symbol" "" "r") "XC0" list(5 -10.5) "R0")
end=stub(cv i "A" "C2B")
end=stub(cv i "B" "C1B")
end=stub(cv i "E" "C0B")
end=stub(cv i "Y" "CS0")
end=stub(cv i "VDD" "VDD")
end=stub(cv i "GND" "GND")
i=schCreateInst(cv dbOpenCellViewByType("sram_project" "and3" "symbol" "" "r") "XC1" list(15 -10.5) "R0")
end=stub(cv i "A" "C2B")
end=stub(cv i "B" "C1B")
end=stub(cv i "E" "C0")
end=stub(cv i "Y" "CS1")
end=stub(cv i "VDD" "VDD")
end=stub(cv i "GND" "GND")
i=schCreateInst(cv dbOpenCellViewByType("sram_project" "and3" "symbol" "" "r") "XC2" list(25 -10.5) "R0")
end=stub(cv i "A" "C2B")
end=stub(cv i "B" "C1")
end=stub(cv i "E" "C0B")
end=stub(cv i "Y" "CS2")
end=stub(cv i "VDD" "VDD")
end=stub(cv i "GND" "GND")
i=schCreateInst(cv dbOpenCellViewByType("sram_project" "and3" "symbol" "" "r") "XC3" list(5 -16.0) "R0")
end=stub(cv i "A" "C2B")
end=stub(cv i "B" "C1")
end=stub(cv i "E" "C0")
end=stub(cv i "Y" "CS3")
end=stub(cv i "VDD" "VDD")
end=stub(cv i "GND" "GND")
i=schCreateInst(cv dbOpenCellViewByType("sram_project" "and3" "symbol" "" "r") "XC4" list(15 -16.0) "R0")
end=stub(cv i "A" "C2")
end=stub(cv i "B" "C1B")
end=stub(cv i "E" "C0B")
end=stub(cv i "Y" "CS4")
end=stub(cv i "VDD" "VDD")
end=stub(cv i "GND" "GND")
i=schCreateInst(cv dbOpenCellViewByType("sram_project" "and3" "symbol" "" "r") "XC5" list(25 -16.0) "R0")
end=stub(cv i "A" "C2")
end=stub(cv i "B" "C1B")
end=stub(cv i "E" "C0")
end=stub(cv i "Y" "CS5")
end=stub(cv i "VDD" "VDD")
end=stub(cv i "GND" "GND")
schCreatePin(cv dbOpenCellViewByType("basic" "ipin" "symbol" "" "r") "C2" "input" nil list(-3 2.0) "R0" nil nil "signal")
schCreatePin(cv dbOpenCellViewByType("basic" "ipin" "symbol" "" "r") "C1" "input" nil list(-3 1.5) "R0" nil nil "signal")
schCreatePin(cv dbOpenCellViewByType("basic" "ipin" "symbol" "" "r") "C0" "input" nil list(-3 1.0) "R0" nil nil "signal")
schCreatePin(cv dbOpenCellViewByType("basic" "opin" "symbol" "" "r") "CS0" "output" nil list(-3 0.5) "R0" nil nil "signal")
schCreatePin(cv dbOpenCellViewByType("basic" "opin" "symbol" "" "r") "CS1" "output" nil list(-3 0.0) "R0" nil nil "signal")
schCreatePin(cv dbOpenCellViewByType("basic" "opin" "symbol" "" "r") "CS2" "output" nil list(-3 -0.5) "R0" nil nil "signal")
schCreatePin(cv dbOpenCellViewByType("basic" "opin" "symbol" "" "r") "CS3" "output" nil list(-3 -1.0) "R0" nil nil "signal")
schCreatePin(cv dbOpenCellViewByType("basic" "opin" "symbol" "" "r") "CS4" "output" nil list(-3 -1.5) "R0" nil nil "signal")
schCreatePin(cv dbOpenCellViewByType("basic" "opin" "symbol" "" "r") "CS5" "output" nil list(-3 -2.0) "R0" nil nil "signal")
schCreatePin(cv dbOpenCellViewByType("basic" "ipin" "symbol" "" "r") "VDD" "input" nil list(-3 -2.5) "R0" nil nil "power")
schCreatePin(cv dbOpenCellViewByType("basic" "ipin" "symbol" "" "r") "GND" "input" nil list(-3 -3.0) "R0" nil nil "ground")
dbSave(cv) dbClose(cv)
cv=dbOpenCellViewByType("sram_project" "rw_control" "schematic" "schematic" "w")
i=schCreateInst(cv dbOpenCellViewByType("sram_project" "inv" "symbol" "" "r") "XIRD" list(5 -5.0) "R0")
end=stub(cv i "IN" "RD")
end=stub(cv i "OUT" "NRD")
end=stub(cv i "VDD" "VDD")
end=stub(cv i "GND" "GND")
i=schCreateInst(cv dbOpenCellViewByType("sram_project" "inv" "symbol" "" "r") "XIWR" list(15 -5.0) "R0")
end=stub(cv i "IN" "WR")
end=stub(cv i "OUT" "NWR")
end=stub(cv i "VDD" "VDD")
end=stub(cv i "GND" "GND")
i=schCreateInst(cv dbOpenCellViewByType("sram_project" "inv" "symbol" "" "r") "XIPRE" list(25 -5.0) "R0")
end=stub(cv i "IN" "CLK2")
end=stub(cv i "OUT" "PCB")
end=stub(cv i "VDD" "VDD")
end=stub(cv i "GND" "GND")
i=schCreateInst(cv dbOpenCellViewByType("sram_project" "and3" "symbol" "" "r") "XBAD" list(5 -10.5) "R0")
end=stub(cv i "A" "C2")
end=stub(cv i "B" "C1")
end=stub(cv i "E" "VDD")
end=stub(cv i "Y" "BADCOL")
end=stub(cv i "VDD" "VDD")
end=stub(cv i "GND" "GND")
i=schCreateInst(cv dbOpenCellViewByType("sram_project" "inv" "symbol" "" "r") "XVALID" list(15 -10.5) "R0")
end=stub(cv i "IN" "BADCOL")
end=stub(cv i "OUT" "VALID")
end=stub(cv i "VDD" "VDD")
end=stub(cv i "GND" "GND")
i=schCreateInst(cv dbOpenCellViewByType("sram_project" "and3" "symbol" "" "r") "XWA" list(25 -10.5) "R0")
end=stub(cv i "A" "WR")
end=stub(cv i "B" "NRD")
end=stub(cv i "E" "CLK1")
end=stub(cv i "Y" "WA")
end=stub(cv i "VDD" "VDD")
end=stub(cv i "GND" "GND")
i=schCreateInst(cv dbOpenCellViewByType("sram_project" "and3" "symbol" "" "r") "XRA" list(5 -16.0) "R0")
end=stub(cv i "A" "RD")
end=stub(cv i "B" "NWR")
end=stub(cv i "E" "CLK1")
end=stub(cv i "Y" "RA")
end=stub(cv i "VDD" "VDD")
end=stub(cv i "GND" "GND")
i=schCreateInst(cv dbOpenCellViewByType("sram_project" "and3" "symbol" "" "r") "XWE" list(15 -16.0) "R0")
end=stub(cv i "A" "WA")
end=stub(cv i "B" "VALID")
end=stub(cv i "E" "PCB")
end=stub(cv i "Y" "WEN")
end=stub(cv i "VDD" "VDD")
end=stub(cv i "GND" "GND")
i=schCreateInst(cv dbOpenCellViewByType("sram_project" "and3" "symbol" "" "r") "XRE" list(25 -16.0) "R0")
end=stub(cv i "A" "RA")
end=stub(cv i "B" "VALID")
end=stub(cv i "E" "PCB")
end=stub(cv i "Y" "REN")
end=stub(cv i "VDD" "VDD")
end=stub(cv i "GND" "GND")
i=schCreateInst(cv dbOpenCellViewByType("sram_project" "inv" "symbol" "" "r") "XIWE" list(5 -21.5) "R0")
end=stub(cv i "IN" "WEN")
end=stub(cv i "OUT" "WENB")
end=stub(cv i "VDD" "VDD")
end=stub(cv i "GND" "GND")
i=schCreateInst(cv dbOpenCellViewByType("sram_project" "inv" "symbol" "" "r") "XIRE" list(15 -21.5) "R0")
end=stub(cv i "IN" "REN")
end=stub(cv i "OUT" "RENB")
end=stub(cv i "VDD" "VDD")
end=stub(cv i "GND" "GND")
i=schCreateInst(cv dbOpenCellViewByType("sram_project" "and3" "symbol" "" "r") "XIDLE" list(25 -21.5) "R0")
end=stub(cv i "A" "WENB")
end=stub(cv i "B" "RENB")
end=stub(cv i "E" "VDD")
end=stub(cv i "Y" "IDLE")
end=stub(cv i "VDD" "VDD")
end=stub(cv i "GND" "GND")
i=schCreateInst(cv dbOpenCellViewByType("sram_project" "inv" "symbol" "" "r") "XACTIVE" list(5 -26.5) "R0")
end=stub(cv i "IN" "IDLE")
end=stub(cv i "OUT" "ROWEN")
end=stub(cv i "VDD" "VDD")
end=stub(cv i "GND" "GND")
schCreatePin(cv dbOpenCellViewByType("basic" "ipin" "symbol" "" "r") "CLK1" "input" nil list(-3 2.0) "R0" nil nil "signal")
schCreatePin(cv dbOpenCellViewByType("basic" "ipin" "symbol" "" "r") "CLK2" "input" nil list(-3 1.5) "R0" nil nil "signal")
schCreatePin(cv dbOpenCellViewByType("basic" "ipin" "symbol" "" "r") "WR" "input" nil list(-3 1.0) "R0" nil nil "signal")
schCreatePin(cv dbOpenCellViewByType("basic" "ipin" "symbol" "" "r") "RD" "input" nil list(-3 0.5) "R0" nil nil "signal")
schCreatePin(cv dbOpenCellViewByType("basic" "ipin" "symbol" "" "r") "C2" "input" nil list(-3 0.0) "R0" nil nil "signal")
schCreatePin(cv dbOpenCellViewByType("basic" "ipin" "symbol" "" "r") "C1" "input" nil list(-3 -0.5) "R0" nil nil "signal")
schCreatePin(cv dbOpenCellViewByType("basic" "opin" "symbol" "" "r") "WEN" "output" nil list(-3 -1.0) "R0" nil nil "signal")
schCreatePin(cv dbOpenCellViewByType("basic" "opin" "symbol" "" "r") "WENB" "output" nil list(-3 -1.5) "R0" nil nil "signal")
schCreatePin(cv dbOpenCellViewByType("basic" "opin" "symbol" "" "r") "REN" "output" nil list(-3 -2.0) "R0" nil nil "signal")
schCreatePin(cv dbOpenCellViewByType("basic" "opin" "symbol" "" "r") "RENB" "output" nil list(-3 -2.5) "R0" nil nil "signal")
schCreatePin(cv dbOpenCellViewByType("basic" "opin" "symbol" "" "r") "ROWEN" "output" nil list(-3 -3.0) "R0" nil nil "signal")
schCreatePin(cv dbOpenCellViewByType("basic" "opin" "symbol" "" "r") "PCB" "output" nil list(-3 -3.5) "R0" nil nil "signal")
schCreatePin(cv dbOpenCellViewByType("basic" "ipin" "symbol" "" "r") "VDD" "input" nil list(-3 -4.0) "R0" nil nil "power")
schCreatePin(cv dbOpenCellViewByType("basic" "ipin" "symbol" "" "r") "GND" "input" nil list(-3 -4.5) "R0" nil nil "ground")
dbSave(cv) dbClose(cv)
cv=dbOpenCellViewByType("sram_project" "write_driver" "schematic" "schematic" "w")
i=schCreateInst(cv dbOpenCellViewByType("sram_project" "inv" "symbol" "" "r") "XID" list(5 -6.0) "R0")
end=stub(cv i "IN" "DIN")
end=stub(cv i "OUT" "DINB")
end=stub(cv i "VDD" "VDD")
end=stub(cv i "GND" "GND")
i=schCreateInst(cv dbOpenCellViewByType("sram_project" "tg" "symbol" "" "r") "XW0" list(15 -6.0) "R0")
end=stub(cv i "A" "DIN")
end=stub(cv i "B" "GBL")
end=stub(cv i "EN" "WEN")
end=stub(cv i "ENB" "WENB")
end=stub(cv i "VDD" "VDD")
end=stub(cv i "GND" "GND")
i=schCreateInst(cv dbOpenCellViewByType("sram_project" "tg" "symbol" "" "r") "XW1" list(25 -6.0) "R0")
end=stub(cv i "A" "DINB")
end=stub(cv i "B" "GBLB")
end=stub(cv i "EN" "WEN")
end=stub(cv i "ENB" "WENB")
end=stub(cv i "VDD" "VDD")
end=stub(cv i "GND" "GND")
schCreatePin(cv dbOpenCellViewByType("basic" "ipin" "symbol" "" "r") "DIN" "input" nil list(-3 2.0) "R0" nil nil "signal")
schCreatePin(cv dbOpenCellViewByType("basic" "ipin" "symbol" "" "r") "WEN" "input" nil list(-3 1.5) "R0" nil nil "signal")
schCreatePin(cv dbOpenCellViewByType("basic" "ipin" "symbol" "" "r") "WENB" "input" nil list(-3 1.0) "R0" nil nil "signal")
schCreatePin(cv dbOpenCellViewByType("basic" "iopin" "symbol" "" "r") "GBL" "inputOutput" nil list(-3 0.5) "R0" nil nil "signal")
schCreatePin(cv dbOpenCellViewByType("basic" "iopin" "symbol" "" "r") "GBLB" "inputOutput" nil list(-3 0.0) "R0" nil nil "signal")
schCreatePin(cv dbOpenCellViewByType("basic" "ipin" "symbol" "" "r") "VDD" "input" nil list(-3 -0.5) "R0" nil nil "power")
schCreatePin(cv dbOpenCellViewByType("basic" "ipin" "symbol" "" "r") "GND" "input" nil list(-3 -1.0) "R0" nil nil "ground")
dbSave(cv) dbClose(cv)
cv=dbOpenCellViewByType("sram_project" "column_mux" "schematic" "schematic" "w")
i=schCreateInst(cv dbOpenCellViewByType("sram_project" "inv" "symbol" "" "r") "XI0" list(5 -6.0) "R0")
end=stub(cv i "IN" "CS0")
end=stub(cv i "OUT" "CSB0")
end=stub(cv i "VDD" "VDD")
end=stub(cv i "GND" "GND")
i=schCreateInst(cv dbOpenCellViewByType("sram_project" "tg" "symbol" "" "r") "XM0P" list(15 -6.0) "R0")
end=stub(cv i "A" "BL0")
end=stub(cv i "B" "GBL")
end=stub(cv i "EN" "CS0")
end=stub(cv i "ENB" "CSB0")
end=stub(cv i "VDD" "VDD")
end=stub(cv i "GND" "GND")
i=schCreateInst(cv dbOpenCellViewByType("sram_project" "tg" "symbol" "" "r") "XM0N" list(25 -6.0) "R0")
end=stub(cv i "A" "BLB0")
end=stub(cv i "B" "GBLB")
end=stub(cv i "EN" "CS0")
end=stub(cv i "ENB" "CSB0")
end=stub(cv i "VDD" "VDD")
end=stub(cv i "GND" "GND")
i=schCreateInst(cv dbOpenCellViewByType("sram_project" "inv" "symbol" "" "r") "XI1" list(5 -12.0) "R0")
end=stub(cv i "IN" "CS1")
end=stub(cv i "OUT" "CSB1")
end=stub(cv i "VDD" "VDD")
end=stub(cv i "GND" "GND")
i=schCreateInst(cv dbOpenCellViewByType("sram_project" "tg" "symbol" "" "r") "XM1P" list(15 -12.0) "R0")
end=stub(cv i "A" "BL1")
end=stub(cv i "B" "GBL")
end=stub(cv i "EN" "CS1")
end=stub(cv i "ENB" "CSB1")
end=stub(cv i "VDD" "VDD")
end=stub(cv i "GND" "GND")
i=schCreateInst(cv dbOpenCellViewByType("sram_project" "tg" "symbol" "" "r") "XM1N" list(25 -12.0) "R0")
end=stub(cv i "A" "BLB1")
end=stub(cv i "B" "GBLB")
end=stub(cv i "EN" "CS1")
end=stub(cv i "ENB" "CSB1")
end=stub(cv i "VDD" "VDD")
end=stub(cv i "GND" "GND")
i=schCreateInst(cv dbOpenCellViewByType("sram_project" "inv" "symbol" "" "r") "XI2" list(5 -18.0) "R0")
end=stub(cv i "IN" "CS2")
end=stub(cv i "OUT" "CSB2")
end=stub(cv i "VDD" "VDD")
end=stub(cv i "GND" "GND")
i=schCreateInst(cv dbOpenCellViewByType("sram_project" "tg" "symbol" "" "r") "XM2P" list(15 -18.0) "R0")
end=stub(cv i "A" "BL2")
end=stub(cv i "B" "GBL")
end=stub(cv i "EN" "CS2")
end=stub(cv i "ENB" "CSB2")
end=stub(cv i "VDD" "VDD")
end=stub(cv i "GND" "GND")
i=schCreateInst(cv dbOpenCellViewByType("sram_project" "tg" "symbol" "" "r") "XM2N" list(25 -18.0) "R0")
end=stub(cv i "A" "BLB2")
end=stub(cv i "B" "GBLB")
end=stub(cv i "EN" "CS2")
end=stub(cv i "ENB" "CSB2")
end=stub(cv i "VDD" "VDD")
end=stub(cv i "GND" "GND")
i=schCreateInst(cv dbOpenCellViewByType("sram_project" "inv" "symbol" "" "r") "XI3" list(5 -24.0) "R0")
end=stub(cv i "IN" "CS3")
end=stub(cv i "OUT" "CSB3")
end=stub(cv i "VDD" "VDD")
end=stub(cv i "GND" "GND")
i=schCreateInst(cv dbOpenCellViewByType("sram_project" "tg" "symbol" "" "r") "XM3P" list(15 -24.0) "R0")
end=stub(cv i "A" "BL3")
end=stub(cv i "B" "GBL")
end=stub(cv i "EN" "CS3")
end=stub(cv i "ENB" "CSB3")
end=stub(cv i "VDD" "VDD")
end=stub(cv i "GND" "GND")
i=schCreateInst(cv dbOpenCellViewByType("sram_project" "tg" "symbol" "" "r") "XM3N" list(25 -24.0) "R0")
end=stub(cv i "A" "BLB3")
end=stub(cv i "B" "GBLB")
end=stub(cv i "EN" "CS3")
end=stub(cv i "ENB" "CSB3")
end=stub(cv i "VDD" "VDD")
end=stub(cv i "GND" "GND")
i=schCreateInst(cv dbOpenCellViewByType("sram_project" "inv" "symbol" "" "r") "XI4" list(5 -30.0) "R0")
end=stub(cv i "IN" "CS4")
end=stub(cv i "OUT" "CSB4")
end=stub(cv i "VDD" "VDD")
end=stub(cv i "GND" "GND")
i=schCreateInst(cv dbOpenCellViewByType("sram_project" "tg" "symbol" "" "r") "XM4P" list(15 -30.0) "R0")
end=stub(cv i "A" "BL4")
end=stub(cv i "B" "GBL")
end=stub(cv i "EN" "CS4")
end=stub(cv i "ENB" "CSB4")
end=stub(cv i "VDD" "VDD")
end=stub(cv i "GND" "GND")
i=schCreateInst(cv dbOpenCellViewByType("sram_project" "tg" "symbol" "" "r") "XM4N" list(25 -30.0) "R0")
end=stub(cv i "A" "BLB4")
end=stub(cv i "B" "GBLB")
end=stub(cv i "EN" "CS4")
end=stub(cv i "ENB" "CSB4")
end=stub(cv i "VDD" "VDD")
end=stub(cv i "GND" "GND")
i=schCreateInst(cv dbOpenCellViewByType("sram_project" "inv" "symbol" "" "r") "XI5" list(5 -36.0) "R0")
end=stub(cv i "IN" "CS5")
end=stub(cv i "OUT" "CSB5")
end=stub(cv i "VDD" "VDD")
end=stub(cv i "GND" "GND")
i=schCreateInst(cv dbOpenCellViewByType("sram_project" "tg" "symbol" "" "r") "XM5P" list(15 -36.0) "R0")
end=stub(cv i "A" "BL5")
end=stub(cv i "B" "GBL")
end=stub(cv i "EN" "CS5")
end=stub(cv i "ENB" "CSB5")
end=stub(cv i "VDD" "VDD")
end=stub(cv i "GND" "GND")
i=schCreateInst(cv dbOpenCellViewByType("sram_project" "tg" "symbol" "" "r") "XM5N" list(25 -36.0) "R0")
end=stub(cv i "A" "BLB5")
end=stub(cv i "B" "GBLB")
end=stub(cv i "EN" "CS5")
end=stub(cv i "ENB" "CSB5")
end=stub(cv i "VDD" "VDD")
end=stub(cv i "GND" "GND")
schCreatePin(cv dbOpenCellViewByType("basic" "ipin" "symbol" "" "r") "CS0" "input" nil list(-3 2.0) "R0" nil nil "signal")
schCreatePin(cv dbOpenCellViewByType("basic" "ipin" "symbol" "" "r") "CS1" "input" nil list(-3 1.5) "R0" nil nil "signal")
schCreatePin(cv dbOpenCellViewByType("basic" "ipin" "symbol" "" "r") "CS2" "input" nil list(-3 1.0) "R0" nil nil "signal")
schCreatePin(cv dbOpenCellViewByType("basic" "ipin" "symbol" "" "r") "CS3" "input" nil list(-3 0.5) "R0" nil nil "signal")
schCreatePin(cv dbOpenCellViewByType("basic" "ipin" "symbol" "" "r") "CS4" "input" nil list(-3 0.0) "R0" nil nil "signal")
schCreatePin(cv dbOpenCellViewByType("basic" "ipin" "symbol" "" "r") "CS5" "input" nil list(-3 -0.5) "R0" nil nil "signal")
schCreatePin(cv dbOpenCellViewByType("basic" "iopin" "symbol" "" "r") "BL0" "inputOutput" nil list(-3 -1.0) "R0" nil nil "signal")
schCreatePin(cv dbOpenCellViewByType("basic" "iopin" "symbol" "" "r") "BL1" "inputOutput" nil list(-3 -1.5) "R0" nil nil "signal")
schCreatePin(cv dbOpenCellViewByType("basic" "iopin" "symbol" "" "r") "BL2" "inputOutput" nil list(-3 -2.0) "R0" nil nil "signal")
schCreatePin(cv dbOpenCellViewByType("basic" "iopin" "symbol" "" "r") "BL3" "inputOutput" nil list(-3 -2.5) "R0" nil nil "signal")
schCreatePin(cv dbOpenCellViewByType("basic" "iopin" "symbol" "" "r") "BL4" "inputOutput" nil list(-3 -3.0) "R0" nil nil "signal")
schCreatePin(cv dbOpenCellViewByType("basic" "iopin" "symbol" "" "r") "BL5" "inputOutput" nil list(-3 -3.5) "R0" nil nil "signal")
schCreatePin(cv dbOpenCellViewByType("basic" "iopin" "symbol" "" "r") "BLB0" "inputOutput" nil list(-3 -4.0) "R0" nil nil "signal")
schCreatePin(cv dbOpenCellViewByType("basic" "iopin" "symbol" "" "r") "BLB1" "inputOutput" nil list(-3 -4.5) "R0" nil nil "signal")
schCreatePin(cv dbOpenCellViewByType("basic" "iopin" "symbol" "" "r") "BLB2" "inputOutput" nil list(-3 -5.0) "R0" nil nil "signal")
schCreatePin(cv dbOpenCellViewByType("basic" "iopin" "symbol" "" "r") "BLB3" "inputOutput" nil list(-3 -5.5) "R0" nil nil "signal")
schCreatePin(cv dbOpenCellViewByType("basic" "iopin" "symbol" "" "r") "BLB4" "inputOutput" nil list(-3 -6.0) "R0" nil nil "signal")
schCreatePin(cv dbOpenCellViewByType("basic" "iopin" "symbol" "" "r") "BLB5" "inputOutput" nil list(-3 -6.5) "R0" nil nil "signal")
schCreatePin(cv dbOpenCellViewByType("basic" "iopin" "symbol" "" "r") "GBL" "inputOutput" nil list(-3 -7.0) "R0" nil nil "signal")
schCreatePin(cv dbOpenCellViewByType("basic" "iopin" "symbol" "" "r") "GBLB" "inputOutput" nil list(-3 -7.5) "R0" nil nil "signal")
schCreatePin(cv dbOpenCellViewByType("basic" "ipin" "symbol" "" "r") "VDD" "input" nil list(-3 -8.0) "R0" nil nil "power")
schCreatePin(cv dbOpenCellViewByType("basic" "ipin" "symbol" "" "r") "GND" "input" nil list(-3 -8.5) "R0" nil nil "ground")
dbSave(cv) dbClose(cv)
cv=dbOpenCellViewByType("sram_project" "precharge" "schematic" "schematic" "w")
i=schCreateInst(cv dbOpenCellViewByType("sram_project" "precharge_unit" "symbol" "" "r") "XP0" list(5 -5.5) "R0")
end=stub(cv i "BL" "BL0")
end=stub(cv i "BLB" "BLB0")
end=stub(cv i "PCB" "PCB")
end=stub(cv i "VDD" "VDD")
end=stub(cv i "GND" "GND")
i=schCreateInst(cv dbOpenCellViewByType("sram_project" "precharge_unit" "symbol" "" "r") "XP1" list(15 -5.5) "R0")
end=stub(cv i "BL" "BL1")
end=stub(cv i "BLB" "BLB1")
end=stub(cv i "PCB" "PCB")
end=stub(cv i "VDD" "VDD")
end=stub(cv i "GND" "GND")
i=schCreateInst(cv dbOpenCellViewByType("sram_project" "precharge_unit" "symbol" "" "r") "XP2" list(25 -5.5) "R0")
end=stub(cv i "BL" "BL2")
end=stub(cv i "BLB" "BLB2")
end=stub(cv i "PCB" "PCB")
end=stub(cv i "VDD" "VDD")
end=stub(cv i "GND" "GND")
i=schCreateInst(cv dbOpenCellViewByType("sram_project" "precharge_unit" "symbol" "" "r") "XP3" list(5 -11.0) "R0")
end=stub(cv i "BL" "BL3")
end=stub(cv i "BLB" "BLB3")
end=stub(cv i "PCB" "PCB")
end=stub(cv i "VDD" "VDD")
end=stub(cv i "GND" "GND")
i=schCreateInst(cv dbOpenCellViewByType("sram_project" "precharge_unit" "symbol" "" "r") "XP4" list(15 -11.0) "R0")
end=stub(cv i "BL" "BL4")
end=stub(cv i "BLB" "BLB4")
end=stub(cv i "PCB" "PCB")
end=stub(cv i "VDD" "VDD")
end=stub(cv i "GND" "GND")
i=schCreateInst(cv dbOpenCellViewByType("sram_project" "precharge_unit" "symbol" "" "r") "XP5" list(25 -11.0) "R0")
end=stub(cv i "BL" "BL5")
end=stub(cv i "BLB" "BLB5")
end=stub(cv i "PCB" "PCB")
end=stub(cv i "VDD" "VDD")
end=stub(cv i "GND" "GND")
schCreatePin(cv dbOpenCellViewByType("basic" "iopin" "symbol" "" "r") "BL0" "inputOutput" nil list(-3 2.0) "R0" nil nil "signal")
schCreatePin(cv dbOpenCellViewByType("basic" "iopin" "symbol" "" "r") "BL1" "inputOutput" nil list(-3 1.5) "R0" nil nil "signal")
schCreatePin(cv dbOpenCellViewByType("basic" "iopin" "symbol" "" "r") "BL2" "inputOutput" nil list(-3 1.0) "R0" nil nil "signal")
schCreatePin(cv dbOpenCellViewByType("basic" "iopin" "symbol" "" "r") "BL3" "inputOutput" nil list(-3 0.5) "R0" nil nil "signal")
schCreatePin(cv dbOpenCellViewByType("basic" "iopin" "symbol" "" "r") "BL4" "inputOutput" nil list(-3 0.0) "R0" nil nil "signal")
schCreatePin(cv dbOpenCellViewByType("basic" "iopin" "symbol" "" "r") "BL5" "inputOutput" nil list(-3 -0.5) "R0" nil nil "signal")
schCreatePin(cv dbOpenCellViewByType("basic" "iopin" "symbol" "" "r") "BLB0" "inputOutput" nil list(-3 -1.0) "R0" nil nil "signal")
schCreatePin(cv dbOpenCellViewByType("basic" "iopin" "symbol" "" "r") "BLB1" "inputOutput" nil list(-3 -1.5) "R0" nil nil "signal")
schCreatePin(cv dbOpenCellViewByType("basic" "iopin" "symbol" "" "r") "BLB2" "inputOutput" nil list(-3 -2.0) "R0" nil nil "signal")
schCreatePin(cv dbOpenCellViewByType("basic" "iopin" "symbol" "" "r") "BLB3" "inputOutput" nil list(-3 -2.5) "R0" nil nil "signal")
schCreatePin(cv dbOpenCellViewByType("basic" "iopin" "symbol" "" "r") "BLB4" "inputOutput" nil list(-3 -3.0) "R0" nil nil "signal")
schCreatePin(cv dbOpenCellViewByType("basic" "iopin" "symbol" "" "r") "BLB5" "inputOutput" nil list(-3 -3.5) "R0" nil nil "signal")
schCreatePin(cv dbOpenCellViewByType("basic" "ipin" "symbol" "" "r") "PCB" "input" nil list(-3 -4.0) "R0" nil nil "signal")
schCreatePin(cv dbOpenCellViewByType("basic" "ipin" "symbol" "" "r") "VDD" "input" nil list(-3 -4.5) "R0" nil nil "power")
schCreatePin(cv dbOpenCellViewByType("basic" "ipin" "symbol" "" "r") "GND" "input" nil list(-3 -5.0) "R0" nil nil "ground")
dbSave(cv) dbClose(cv)
cv=dbOpenCellViewByType("sram_project" "bitcell" "schematic" "schematic" "w")
i=schCreateInst(cv dbOpenCellViewByType("gpdk045" "pmos1v" "symbol" "" "r") "PM0" list(4 -3) "R0")
dbReplaceProp(i "w" "string" "120n") dbReplaceProp(i "l" "string" "45n")
stub(cv i "D" "Q_bar")
stub(cv i "G" "Q")
stub(cv i "S" "VDD")
stub(cv i "B" "VDD")
i=schCreateInst(cv dbOpenCellViewByType("gpdk045" "pmos1v" "symbol" "" "r") "PM1" list(9 -3) "R0")
dbReplaceProp(i "w" "string" "120n") dbReplaceProp(i "l" "string" "45n")
stub(cv i "D" "Q")
stub(cv i "G" "Q_bar")
stub(cv i "S" "VDD")
stub(cv i "B" "VDD")
i=schCreateInst(cv dbOpenCellViewByType("gpdk045" "nmos1v" "symbol" "" "r") "NM0" list(14 -3) "R0")
dbReplaceProp(i "w" "string" "360n") dbReplaceProp(i "l" "string" "45n")
stub(cv i "D" "Q_bar")
stub(cv i "G" "Q")
stub(cv i "S" "GND")
stub(cv i "B" "GND")
i=schCreateInst(cv dbOpenCellViewByType("gpdk045" "nmos1v" "symbol" "" "r") "NM1" list(19 -3) "R0")
dbReplaceProp(i "w" "string" "360n") dbReplaceProp(i "l" "string" "45n")
stub(cv i "D" "Q")
stub(cv i "G" "Q_bar")
stub(cv i "S" "GND")
stub(cv i "B" "GND")
i=schCreateInst(cv dbOpenCellViewByType("gpdk045" "nmos1v" "symbol" "" "r") "NM2" list(4 -8) "R0")
dbReplaceProp(i "w" "string" "240n") dbReplaceProp(i "l" "string" "45n")
stub(cv i "D" "Q_bar")
stub(cv i "G" "WL")
stub(cv i "S" "BL_bar")
stub(cv i "B" "GND")
i=schCreateInst(cv dbOpenCellViewByType("gpdk045" "nmos1v" "symbol" "" "r") "NM3" list(9 -8) "R0")
dbReplaceProp(i "w" "string" "240n") dbReplaceProp(i "l" "string" "45n")
stub(cv i "D" "BL")
stub(cv i "G" "WL")
stub(cv i "S" "Q")
stub(cv i "B" "GND")
schCreatePin(cv dbOpenCellViewByType("basic" "iopin" "symbol" "" "r") "BL" "inputOutput" nil list(-3 2.0) "R0" nil nil "signal")
schCreatePin(cv dbOpenCellViewByType("basic" "iopin" "symbol" "" "r") "BL_bar" "inputOutput" nil list(-3 1.5) "R0" nil nil "signal")
schCreatePin(cv dbOpenCellViewByType("basic" "ipin" "symbol" "" "r") "WL" "input" nil list(-3 1.0) "R0" nil nil "signal")
schCreatePin(cv dbOpenCellViewByType("basic" "iopin" "symbol" "" "r") "Q" "inputOutput" nil list(-3 0.5) "R0" nil nil "signal")
schCreatePin(cv dbOpenCellViewByType("basic" "iopin" "symbol" "" "r") "Q_bar" "inputOutput" nil list(-3 0.0) "R0" nil nil "signal")
schCreatePin(cv dbOpenCellViewByType("basic" "ipin" "symbol" "" "r") "VDD" "input" nil list(-3 -0.5) "R0" nil nil "power")
schCreatePin(cv dbOpenCellViewByType("basic" "ipin" "symbol" "" "r") "GND" "input" nil list(-3 -1.0) "R0" nil nil "ground")
dbSave(cv) dbClose(cv)
cv=dbOpenCellViewByType("sram_project" "bit_array" "schematic" "schematic" "w")
i=schCreateInst(cv dbOpenCellViewByType("sram_project" "bitcell" "symbol" "" "r") "XB0_0" list(5 -4) "R0")
end=stub(cv i "BL" "BL0")
end=stub(cv i "BL_bar" "BLB0")
end=stub(cv i "WL" "WL0")
end=stub(cv i "Q" "Q0_0")
schCreateInst(cv dbOpenCellViewByType("basic" "noConn" "symbol" "" "r") "NC_B0_0_Q" end "R0")
end=stub(cv i "Q_bar" "QB0_0")
schCreateInst(cv dbOpenCellViewByType("basic" "noConn" "symbol" "" "r") "NC_B0_0_Q_bar" end "R0")
end=stub(cv i "VDD" "VDD")
end=stub(cv i "GND" "GND")
i=schCreateInst(cv dbOpenCellViewByType("sram_project" "bitcell" "symbol" "" "r") "XB0_1" list(13 -4) "R0")
end=stub(cv i "BL" "BL1")
end=stub(cv i "BL_bar" "BLB1")
end=stub(cv i "WL" "WL0")
end=stub(cv i "Q" "Q0_1")
schCreateInst(cv dbOpenCellViewByType("basic" "noConn" "symbol" "" "r") "NC_B0_1_Q" end "R0")
end=stub(cv i "Q_bar" "QB0_1")
schCreateInst(cv dbOpenCellViewByType("basic" "noConn" "symbol" "" "r") "NC_B0_1_Q_bar" end "R0")
end=stub(cv i "VDD" "VDD")
end=stub(cv i "GND" "GND")
i=schCreateInst(cv dbOpenCellViewByType("sram_project" "bitcell" "symbol" "" "r") "XB0_2" list(21 -4) "R0")
end=stub(cv i "BL" "BL2")
end=stub(cv i "BL_bar" "BLB2")
end=stub(cv i "WL" "WL0")
end=stub(cv i "Q" "Q0_2")
schCreateInst(cv dbOpenCellViewByType("basic" "noConn" "symbol" "" "r") "NC_B0_2_Q" end "R0")
end=stub(cv i "Q_bar" "QB0_2")
schCreateInst(cv dbOpenCellViewByType("basic" "noConn" "symbol" "" "r") "NC_B0_2_Q_bar" end "R0")
end=stub(cv i "VDD" "VDD")
end=stub(cv i "GND" "GND")
i=schCreateInst(cv dbOpenCellViewByType("sram_project" "bitcell" "symbol" "" "r") "XB0_3" list(29 -4) "R0")
end=stub(cv i "BL" "BL3")
end=stub(cv i "BL_bar" "BLB3")
end=stub(cv i "WL" "WL0")
end=stub(cv i "Q" "Q0_3")
schCreateInst(cv dbOpenCellViewByType("basic" "noConn" "symbol" "" "r") "NC_B0_3_Q" end "R0")
end=stub(cv i "Q_bar" "QB0_3")
schCreateInst(cv dbOpenCellViewByType("basic" "noConn" "symbol" "" "r") "NC_B0_3_Q_bar" end "R0")
end=stub(cv i "VDD" "VDD")
end=stub(cv i "GND" "GND")
i=schCreateInst(cv dbOpenCellViewByType("sram_project" "bitcell" "symbol" "" "r") "XB0_4" list(37 -4) "R0")
end=stub(cv i "BL" "BL4")
end=stub(cv i "BL_bar" "BLB4")
end=stub(cv i "WL" "WL0")
end=stub(cv i "Q" "Q0_4")
schCreateInst(cv dbOpenCellViewByType("basic" "noConn" "symbol" "" "r") "NC_B0_4_Q" end "R0")
end=stub(cv i "Q_bar" "QB0_4")
schCreateInst(cv dbOpenCellViewByType("basic" "noConn" "symbol" "" "r") "NC_B0_4_Q_bar" end "R0")
end=stub(cv i "VDD" "VDD")
end=stub(cv i "GND" "GND")
i=schCreateInst(cv dbOpenCellViewByType("sram_project" "bitcell" "symbol" "" "r") "XB0_5" list(45 -4) "R0")
end=stub(cv i "BL" "BL5")
end=stub(cv i "BL_bar" "BLB5")
end=stub(cv i "WL" "WL0")
end=stub(cv i "Q" "Q0_5")
schCreateInst(cv dbOpenCellViewByType("basic" "noConn" "symbol" "" "r") "NC_B0_5_Q" end "R0")
end=stub(cv i "Q_bar" "QB0_5")
schCreateInst(cv dbOpenCellViewByType("basic" "noConn" "symbol" "" "r") "NC_B0_5_Q_bar" end "R0")
end=stub(cv i "VDD" "VDD")
end=stub(cv i "GND" "GND")
i=schCreateInst(cv dbOpenCellViewByType("sram_project" "bitcell" "symbol" "" "r") "XB1_0" list(5 -12) "R0")
end=stub(cv i "BL" "BL0")
end=stub(cv i "BL_bar" "BLB0")
end=stub(cv i "WL" "WL1")
end=stub(cv i "Q" "Q1_0")
schCreateInst(cv dbOpenCellViewByType("basic" "noConn" "symbol" "" "r") "NC_B1_0_Q" end "R0")
end=stub(cv i "Q_bar" "QB1_0")
schCreateInst(cv dbOpenCellViewByType("basic" "noConn" "symbol" "" "r") "NC_B1_0_Q_bar" end "R0")
end=stub(cv i "VDD" "VDD")
end=stub(cv i "GND" "GND")
i=schCreateInst(cv dbOpenCellViewByType("sram_project" "bitcell" "symbol" "" "r") "XB1_1" list(13 -12) "R0")
end=stub(cv i "BL" "BL1")
end=stub(cv i "BL_bar" "BLB1")
end=stub(cv i "WL" "WL1")
end=stub(cv i "Q" "Q1_1")
schCreateInst(cv dbOpenCellViewByType("basic" "noConn" "symbol" "" "r") "NC_B1_1_Q" end "R0")
end=stub(cv i "Q_bar" "QB1_1")
schCreateInst(cv dbOpenCellViewByType("basic" "noConn" "symbol" "" "r") "NC_B1_1_Q_bar" end "R0")
end=stub(cv i "VDD" "VDD")
end=stub(cv i "GND" "GND")
i=schCreateInst(cv dbOpenCellViewByType("sram_project" "bitcell" "symbol" "" "r") "XB1_2" list(21 -12) "R0")
end=stub(cv i "BL" "BL2")
end=stub(cv i "BL_bar" "BLB2")
end=stub(cv i "WL" "WL1")
end=stub(cv i "Q" "Q1_2")
schCreateInst(cv dbOpenCellViewByType("basic" "noConn" "symbol" "" "r") "NC_B1_2_Q" end "R0")
end=stub(cv i "Q_bar" "QB1_2")
schCreateInst(cv dbOpenCellViewByType("basic" "noConn" "symbol" "" "r") "NC_B1_2_Q_bar" end "R0")
end=stub(cv i "VDD" "VDD")
end=stub(cv i "GND" "GND")
i=schCreateInst(cv dbOpenCellViewByType("sram_project" "bitcell" "symbol" "" "r") "XB1_3" list(29 -12) "R0")
end=stub(cv i "BL" "BL3")
end=stub(cv i "BL_bar" "BLB3")
end=stub(cv i "WL" "WL1")
end=stub(cv i "Q" "Q1_3")
schCreateInst(cv dbOpenCellViewByType("basic" "noConn" "symbol" "" "r") "NC_B1_3_Q" end "R0")
end=stub(cv i "Q_bar" "QB1_3")
schCreateInst(cv dbOpenCellViewByType("basic" "noConn" "symbol" "" "r") "NC_B1_3_Q_bar" end "R0")
end=stub(cv i "VDD" "VDD")
end=stub(cv i "GND" "GND")
i=schCreateInst(cv dbOpenCellViewByType("sram_project" "bitcell" "symbol" "" "r") "XB1_4" list(37 -12) "R0")
end=stub(cv i "BL" "BL4")
end=stub(cv i "BL_bar" "BLB4")
end=stub(cv i "WL" "WL1")
end=stub(cv i "Q" "Q1_4")
schCreateInst(cv dbOpenCellViewByType("basic" "noConn" "symbol" "" "r") "NC_B1_4_Q" end "R0")
end=stub(cv i "Q_bar" "QB1_4")
schCreateInst(cv dbOpenCellViewByType("basic" "noConn" "symbol" "" "r") "NC_B1_4_Q_bar" end "R0")
end=stub(cv i "VDD" "VDD")
end=stub(cv i "GND" "GND")
i=schCreateInst(cv dbOpenCellViewByType("sram_project" "bitcell" "symbol" "" "r") "XB1_5" list(45 -12) "R0")
end=stub(cv i "BL" "BL5")
end=stub(cv i "BL_bar" "BLB5")
end=stub(cv i "WL" "WL1")
end=stub(cv i "Q" "Q1_5")
schCreateInst(cv dbOpenCellViewByType("basic" "noConn" "symbol" "" "r") "NC_B1_5_Q" end "R0")
end=stub(cv i "Q_bar" "QB1_5")
schCreateInst(cv dbOpenCellViewByType("basic" "noConn" "symbol" "" "r") "NC_B1_5_Q_bar" end "R0")
end=stub(cv i "VDD" "VDD")
end=stub(cv i "GND" "GND")
i=schCreateInst(cv dbOpenCellViewByType("sram_project" "bitcell" "symbol" "" "r") "XB2_0" list(5 -20) "R0")
end=stub(cv i "BL" "BL0")
end=stub(cv i "BL_bar" "BLB0")
end=stub(cv i "WL" "WL2")
end=stub(cv i "Q" "Q2_0")
schCreateInst(cv dbOpenCellViewByType("basic" "noConn" "symbol" "" "r") "NC_B2_0_Q" end "R0")
end=stub(cv i "Q_bar" "QB2_0")
schCreateInst(cv dbOpenCellViewByType("basic" "noConn" "symbol" "" "r") "NC_B2_0_Q_bar" end "R0")
end=stub(cv i "VDD" "VDD")
end=stub(cv i "GND" "GND")
i=schCreateInst(cv dbOpenCellViewByType("sram_project" "bitcell" "symbol" "" "r") "XB2_1" list(13 -20) "R0")
end=stub(cv i "BL" "BL1")
end=stub(cv i "BL_bar" "BLB1")
end=stub(cv i "WL" "WL2")
end=stub(cv i "Q" "Q2_1")
schCreateInst(cv dbOpenCellViewByType("basic" "noConn" "symbol" "" "r") "NC_B2_1_Q" end "R0")
end=stub(cv i "Q_bar" "QB2_1")
schCreateInst(cv dbOpenCellViewByType("basic" "noConn" "symbol" "" "r") "NC_B2_1_Q_bar" end "R0")
end=stub(cv i "VDD" "VDD")
end=stub(cv i "GND" "GND")
i=schCreateInst(cv dbOpenCellViewByType("sram_project" "bitcell" "symbol" "" "r") "XB2_2" list(21 -20) "R0")
end=stub(cv i "BL" "BL2")
end=stub(cv i "BL_bar" "BLB2")
end=stub(cv i "WL" "WL2")
end=stub(cv i "Q" "Q2_2")
schCreateInst(cv dbOpenCellViewByType("basic" "noConn" "symbol" "" "r") "NC_B2_2_Q" end "R0")
end=stub(cv i "Q_bar" "QB2_2")
schCreateInst(cv dbOpenCellViewByType("basic" "noConn" "symbol" "" "r") "NC_B2_2_Q_bar" end "R0")
end=stub(cv i "VDD" "VDD")
end=stub(cv i "GND" "GND")
i=schCreateInst(cv dbOpenCellViewByType("sram_project" "bitcell" "symbol" "" "r") "XB2_3" list(29 -20) "R0")
end=stub(cv i "BL" "BL3")
end=stub(cv i "BL_bar" "BLB3")
end=stub(cv i "WL" "WL2")
end=stub(cv i "Q" "Q2_3")
schCreateInst(cv dbOpenCellViewByType("basic" "noConn" "symbol" "" "r") "NC_B2_3_Q" end "R0")
end=stub(cv i "Q_bar" "QB2_3")
schCreateInst(cv dbOpenCellViewByType("basic" "noConn" "symbol" "" "r") "NC_B2_3_Q_bar" end "R0")
end=stub(cv i "VDD" "VDD")
end=stub(cv i "GND" "GND")
i=schCreateInst(cv dbOpenCellViewByType("sram_project" "bitcell" "symbol" "" "r") "XB2_4" list(37 -20) "R0")
end=stub(cv i "BL" "BL4")
end=stub(cv i "BL_bar" "BLB4")
end=stub(cv i "WL" "WL2")
end=stub(cv i "Q" "Q2_4")
schCreateInst(cv dbOpenCellViewByType("basic" "noConn" "symbol" "" "r") "NC_B2_4_Q" end "R0")
end=stub(cv i "Q_bar" "QB2_4")
schCreateInst(cv dbOpenCellViewByType("basic" "noConn" "symbol" "" "r") "NC_B2_4_Q_bar" end "R0")
end=stub(cv i "VDD" "VDD")
end=stub(cv i "GND" "GND")
i=schCreateInst(cv dbOpenCellViewByType("sram_project" "bitcell" "symbol" "" "r") "XB2_5" list(45 -20) "R0")
end=stub(cv i "BL" "BL5")
end=stub(cv i "BL_bar" "BLB5")
end=stub(cv i "WL" "WL2")
end=stub(cv i "Q" "Q2_5")
schCreateInst(cv dbOpenCellViewByType("basic" "noConn" "symbol" "" "r") "NC_B2_5_Q" end "R0")
end=stub(cv i "Q_bar" "QB2_5")
schCreateInst(cv dbOpenCellViewByType("basic" "noConn" "symbol" "" "r") "NC_B2_5_Q_bar" end "R0")
end=stub(cv i "VDD" "VDD")
end=stub(cv i "GND" "GND")
i=schCreateInst(cv dbOpenCellViewByType("sram_project" "bitcell" "symbol" "" "r") "XB3_0" list(5 -28) "R0")
end=stub(cv i "BL" "BL0")
end=stub(cv i "BL_bar" "BLB0")
end=stub(cv i "WL" "WL3")
end=stub(cv i "Q" "Q3_0")
schCreateInst(cv dbOpenCellViewByType("basic" "noConn" "symbol" "" "r") "NC_B3_0_Q" end "R0")
end=stub(cv i "Q_bar" "QB3_0")
schCreateInst(cv dbOpenCellViewByType("basic" "noConn" "symbol" "" "r") "NC_B3_0_Q_bar" end "R0")
end=stub(cv i "VDD" "VDD")
end=stub(cv i "GND" "GND")
i=schCreateInst(cv dbOpenCellViewByType("sram_project" "bitcell" "symbol" "" "r") "XB3_1" list(13 -28) "R0")
end=stub(cv i "BL" "BL1")
end=stub(cv i "BL_bar" "BLB1")
end=stub(cv i "WL" "WL3")
end=stub(cv i "Q" "Q3_1")
schCreateInst(cv dbOpenCellViewByType("basic" "noConn" "symbol" "" "r") "NC_B3_1_Q" end "R0")
end=stub(cv i "Q_bar" "QB3_1")
schCreateInst(cv dbOpenCellViewByType("basic" "noConn" "symbol" "" "r") "NC_B3_1_Q_bar" end "R0")
end=stub(cv i "VDD" "VDD")
end=stub(cv i "GND" "GND")
i=schCreateInst(cv dbOpenCellViewByType("sram_project" "bitcell" "symbol" "" "r") "XB3_2" list(21 -28) "R0")
end=stub(cv i "BL" "BL2")
end=stub(cv i "BL_bar" "BLB2")
end=stub(cv i "WL" "WL3")
end=stub(cv i "Q" "Q3_2")
schCreateInst(cv dbOpenCellViewByType("basic" "noConn" "symbol" "" "r") "NC_B3_2_Q" end "R0")
end=stub(cv i "Q_bar" "QB3_2")
schCreateInst(cv dbOpenCellViewByType("basic" "noConn" "symbol" "" "r") "NC_B3_2_Q_bar" end "R0")
end=stub(cv i "VDD" "VDD")
end=stub(cv i "GND" "GND")
i=schCreateInst(cv dbOpenCellViewByType("sram_project" "bitcell" "symbol" "" "r") "XB3_3" list(29 -28) "R0")
end=stub(cv i "BL" "BL3")
end=stub(cv i "BL_bar" "BLB3")
end=stub(cv i "WL" "WL3")
end=stub(cv i "Q" "Q3_3")
schCreateInst(cv dbOpenCellViewByType("basic" "noConn" "symbol" "" "r") "NC_B3_3_Q" end "R0")
end=stub(cv i "Q_bar" "QB3_3")
schCreateInst(cv dbOpenCellViewByType("basic" "noConn" "symbol" "" "r") "NC_B3_3_Q_bar" end "R0")
end=stub(cv i "VDD" "VDD")
end=stub(cv i "GND" "GND")
i=schCreateInst(cv dbOpenCellViewByType("sram_project" "bitcell" "symbol" "" "r") "XB3_4" list(37 -28) "R0")
end=stub(cv i "BL" "BL4")
end=stub(cv i "BL_bar" "BLB4")
end=stub(cv i "WL" "WL3")
end=stub(cv i "Q" "Q3_4")
schCreateInst(cv dbOpenCellViewByType("basic" "noConn" "symbol" "" "r") "NC_B3_4_Q" end "R0")
end=stub(cv i "Q_bar" "QB3_4")
schCreateInst(cv dbOpenCellViewByType("basic" "noConn" "symbol" "" "r") "NC_B3_4_Q_bar" end "R0")
end=stub(cv i "VDD" "VDD")
end=stub(cv i "GND" "GND")
i=schCreateInst(cv dbOpenCellViewByType("sram_project" "bitcell" "symbol" "" "r") "XB3_5" list(45 -28) "R0")
end=stub(cv i "BL" "BL5")
end=stub(cv i "BL_bar" "BLB5")
end=stub(cv i "WL" "WL3")
end=stub(cv i "Q" "Q3_5")
schCreateInst(cv dbOpenCellViewByType("basic" "noConn" "symbol" "" "r") "NC_B3_5_Q" end "R0")
end=stub(cv i "Q_bar" "QB3_5")
schCreateInst(cv dbOpenCellViewByType("basic" "noConn" "symbol" "" "r") "NC_B3_5_Q_bar" end "R0")
end=stub(cv i "VDD" "VDD")
end=stub(cv i "GND" "GND")
schCreatePin(cv dbOpenCellViewByType("basic" "ipin" "symbol" "" "r") "WL0" "input" nil list(-3 2.0) "R0" nil nil "signal")
schCreatePin(cv dbOpenCellViewByType("basic" "ipin" "symbol" "" "r") "WL1" "input" nil list(-3 1.5) "R0" nil nil "signal")
schCreatePin(cv dbOpenCellViewByType("basic" "ipin" "symbol" "" "r") "WL2" "input" nil list(-3 1.0) "R0" nil nil "signal")
schCreatePin(cv dbOpenCellViewByType("basic" "ipin" "symbol" "" "r") "WL3" "input" nil list(-3 0.5) "R0" nil nil "signal")
schCreatePin(cv dbOpenCellViewByType("basic" "iopin" "symbol" "" "r") "BL0" "inputOutput" nil list(-3 0.0) "R0" nil nil "signal")
schCreatePin(cv dbOpenCellViewByType("basic" "iopin" "symbol" "" "r") "BL1" "inputOutput" nil list(-3 -0.5) "R0" nil nil "signal")
schCreatePin(cv dbOpenCellViewByType("basic" "iopin" "symbol" "" "r") "BL2" "inputOutput" nil list(-3 -1.0) "R0" nil nil "signal")
schCreatePin(cv dbOpenCellViewByType("basic" "iopin" "symbol" "" "r") "BL3" "inputOutput" nil list(-3 -1.5) "R0" nil nil "signal")
schCreatePin(cv dbOpenCellViewByType("basic" "iopin" "symbol" "" "r") "BL4" "inputOutput" nil list(-3 -2.0) "R0" nil nil "signal")
schCreatePin(cv dbOpenCellViewByType("basic" "iopin" "symbol" "" "r") "BL5" "inputOutput" nil list(-3 -2.5) "R0" nil nil "signal")
schCreatePin(cv dbOpenCellViewByType("basic" "iopin" "symbol" "" "r") "BLB0" "inputOutput" nil list(-3 -3.0) "R0" nil nil "signal")
schCreatePin(cv dbOpenCellViewByType("basic" "iopin" "symbol" "" "r") "BLB1" "inputOutput" nil list(-3 -3.5) "R0" nil nil "signal")
schCreatePin(cv dbOpenCellViewByType("basic" "iopin" "symbol" "" "r") "BLB2" "inputOutput" nil list(-3 -4.0) "R0" nil nil "signal")
schCreatePin(cv dbOpenCellViewByType("basic" "iopin" "symbol" "" "r") "BLB3" "inputOutput" nil list(-3 -4.5) "R0" nil nil "signal")
schCreatePin(cv dbOpenCellViewByType("basic" "iopin" "symbol" "" "r") "BLB4" "inputOutput" nil list(-3 -5.0) "R0" nil nil "signal")
schCreatePin(cv dbOpenCellViewByType("basic" "iopin" "symbol" "" "r") "BLB5" "inputOutput" nil list(-3 -5.5) "R0" nil nil "signal")
schCreatePin(cv dbOpenCellViewByType("basic" "ipin" "symbol" "" "r") "VDD" "input" nil list(-3 -6.0) "R0" nil nil "power")
schCreatePin(cv dbOpenCellViewByType("basic" "ipin" "symbol" "" "r") "GND" "input" nil list(-3 -6.5) "R0" nil nil "ground")
dbSave(cv) dbClose(cv)
cv=dbOpenCellViewByType("sram_project" "sram_4x6" "schematic" "schematic" "w")
i=schCreateInst(cv dbOpenCellViewByType("sram_project" "rw_control" "symbol" "" "r") "XCTRL" list(5 -7.0) "R0")
end=stub(cv i "CLK1" "CLK1")
end=stub(cv i "CLK2" "CLK2")
end=stub(cv i "WR" "WR")
end=stub(cv i "RD" "RD")
end=stub(cv i "C2" "C2")
end=stub(cv i "C1" "C1")
end=stub(cv i "WEN" "WEN")
end=stub(cv i "WENB" "WENB")
end=stub(cv i "REN" "REN")
end=stub(cv i "RENB" "RENB")
end=stub(cv i "ROWEN" "ROWEN")
end=stub(cv i "PCB" "PCB")
end=stub(cv i "VDD" "VDD")
end=stub(cv i "GND" "GND")
i=schCreateInst(cv dbOpenCellViewByType("sram_project" "row_decoder" "symbol" "" "r") "XROW" list(15 -7.0) "R0")
end=stub(cv i "R1" "R1")
end=stub(cv i "R0" "R0")
end=stub(cv i "EN" "ROWEN")
end=stub(cv i "WL0" "WL0")
end=stub(cv i "WL1" "WL1")
end=stub(cv i "WL2" "WL2")
end=stub(cv i "WL3" "WL3")
end=stub(cv i "VDD" "VDD")
end=stub(cv i "GND" "GND")
i=schCreateInst(cv dbOpenCellViewByType("sram_project" "column_decoder" "symbol" "" "r") "XCOL" list(25 -7.0) "R0")
end=stub(cv i "C2" "C2")
end=stub(cv i "C1" "C1")
end=stub(cv i "C0" "C0")
end=stub(cv i "CS0" "CS0")
end=stub(cv i "CS1" "CS1")
end=stub(cv i "CS2" "CS2")
end=stub(cv i "CS3" "CS3")
end=stub(cv i "CS4" "CS4")
end=stub(cv i "CS5" "CS5")
end=stub(cv i "VDD" "VDD")
end=stub(cv i "GND" "GND")
i=schCreateInst(cv dbOpenCellViewByType("sram_project" "precharge" "symbol" "" "r") "XPRE" list(5 -21.0) "R0")
end=stub(cv i "BL0" "BL0")
end=stub(cv i "BL1" "BL1")
end=stub(cv i "BL2" "BL2")
end=stub(cv i "BL3" "BL3")
end=stub(cv i "BL4" "BL4")
end=stub(cv i "BL5" "BL5")
end=stub(cv i "BLB0" "BLB0")
end=stub(cv i "BLB1" "BLB1")
end=stub(cv i "BLB2" "BLB2")
end=stub(cv i "BLB3" "BLB3")
end=stub(cv i "BLB4" "BLB4")
end=stub(cv i "BLB5" "BLB5")
end=stub(cv i "PCB" "PCB")
end=stub(cv i "VDD" "VDD")
end=stub(cv i "GND" "GND")
i=schCreateInst(cv dbOpenCellViewByType("sram_project" "column_mux" "symbol" "" "r") "XMUX" list(15 -21.0) "R0")
end=stub(cv i "CS0" "CS0")
end=stub(cv i "CS1" "CS1")
end=stub(cv i "CS2" "CS2")
end=stub(cv i "CS3" "CS3")
end=stub(cv i "CS4" "CS4")
end=stub(cv i "CS5" "CS5")
end=stub(cv i "BL0" "BL0")
end=stub(cv i "BL1" "BL1")
end=stub(cv i "BL2" "BL2")
end=stub(cv i "BL3" "BL3")
end=stub(cv i "BL4" "BL4")
end=stub(cv i "BL5" "BL5")
end=stub(cv i "BLB0" "BLB0")
end=stub(cv i "BLB1" "BLB1")
end=stub(cv i "BLB2" "BLB2")
end=stub(cv i "BLB3" "BLB3")
end=stub(cv i "BLB4" "BLB4")
end=stub(cv i "BLB5" "BLB5")
end=stub(cv i "GBL" "GBL")
end=stub(cv i "GBLB" "GBLB")
end=stub(cv i "VDD" "VDD")
end=stub(cv i "GND" "GND")
i=schCreateInst(cv dbOpenCellViewByType("sram_project" "write_driver" "symbol" "" "r") "XWRITE" list(25 -21.0) "R0")
end=stub(cv i "DIN" "DIN")
end=stub(cv i "WEN" "WEN")
end=stub(cv i "WENB" "WENB")
end=stub(cv i "GBL" "GBL")
end=stub(cv i "GBLB" "GBLB")
end=stub(cv i "VDD" "VDD")
end=stub(cv i "GND" "GND")
i=schCreateInst(cv dbOpenCellViewByType("sram_project" "bit_array" "symbol" "" "r") "XMEM" list(5 -33.0) "R0")
end=stub(cv i "WL0" "WL0")
end=stub(cv i "WL1" "WL1")
end=stub(cv i "WL2" "WL2")
end=stub(cv i "WL3" "WL3")
end=stub(cv i "BL0" "BL0")
end=stub(cv i "BL1" "BL1")
end=stub(cv i "BL2" "BL2")
end=stub(cv i "BL3" "BL3")
end=stub(cv i "BL4" "BL4")
end=stub(cv i "BL5" "BL5")
end=stub(cv i "BLB0" "BLB0")
end=stub(cv i "BLB1" "BLB1")
end=stub(cv i "BLB2" "BLB2")
end=stub(cv i "BLB3" "BLB3")
end=stub(cv i "BLB4" "BLB4")
end=stub(cv i "BLB5" "BLB5")
end=stub(cv i "VDD" "VDD")
end=stub(cv i "GND" "GND")
i=schCreateInst(cv dbOpenCellViewByType("sram_project" "sense_amp" "symbol" "" "r") "XSENSE" list(15 -33.0) "R0")
end=stub(cv i "BIT" "GBL")
end=stub(cv i "BIT_bar" "GBLB")
end=stub(cv i "RE" "REN")
end=stub(cv i "VDD" "VDD")
end=stub(cv i "GND" "GND")
end=stub(cv i "AMP_OUT" "SENSE")
i=schCreateInst(cv dbOpenCellViewByType("sram_project" "read_latch" "symbol" "" "r") "XLATCH" list(25 -33.0) "R0")
end=stub(cv i "D" "SENSE")
end=stub(cv i "EN" "REN")
end=stub(cv i "ENB" "RENB")
end=stub(cv i "Q" "DOUT")
end=stub(cv i "VDD" "VDD")
end=stub(cv i "GND" "GND")
schCreatePin(cv dbOpenCellViewByType("basic" "ipin" "symbol" "" "r") "R1" "input" nil list(-3 2.0) "R0" nil nil "signal")
schCreatePin(cv dbOpenCellViewByType("basic" "ipin" "symbol" "" "r") "R0" "input" nil list(-3 1.5) "R0" nil nil "signal")
schCreatePin(cv dbOpenCellViewByType("basic" "ipin" "symbol" "" "r") "C2" "input" nil list(-3 1.0) "R0" nil nil "signal")
schCreatePin(cv dbOpenCellViewByType("basic" "ipin" "symbol" "" "r") "C1" "input" nil list(-3 0.5) "R0" nil nil "signal")
schCreatePin(cv dbOpenCellViewByType("basic" "ipin" "symbol" "" "r") "C0" "input" nil list(-3 0.0) "R0" nil nil "signal")
schCreatePin(cv dbOpenCellViewByType("basic" "ipin" "symbol" "" "r") "CLK1" "input" nil list(-3 -0.5) "R0" nil nil "signal")
schCreatePin(cv dbOpenCellViewByType("basic" "ipin" "symbol" "" "r") "CLK2" "input" nil list(-3 -1.0) "R0" nil nil "signal")
schCreatePin(cv dbOpenCellViewByType("basic" "ipin" "symbol" "" "r") "WR" "input" nil list(-3 -1.5) "R0" nil nil "signal")
schCreatePin(cv dbOpenCellViewByType("basic" "ipin" "symbol" "" "r") "RD" "input" nil list(-3 -2.0) "R0" nil nil "signal")
schCreatePin(cv dbOpenCellViewByType("basic" "ipin" "symbol" "" "r") "DIN" "input" nil list(-3 -2.5) "R0" nil nil "signal")
schCreatePin(cv dbOpenCellViewByType("basic" "opin" "symbol" "" "r") "DOUT" "output" nil list(-3 -3.0) "R0" nil nil "signal")
schCreatePin(cv dbOpenCellViewByType("basic" "ipin" "symbol" "" "r") "VDD" "input" nil list(-3 -3.5) "R0" nil nil "power")
schCreatePin(cv dbOpenCellViewByType("basic" "ipin" "symbol" "" "r") "GND" "input" nil list(-3 -4.0) "R0" nil nil "ground")
dbSave(cv) dbClose(cv)
cv=dbOpenCellViewByType("sram_project" "inv" "schematic" "" "a") printf("CHECK inv %L\n" schCheck(cv)) dbSave(cv) dbClose(cv)
cv=dbOpenCellViewByType("sram_project" "nand3" "schematic" "" "a") printf("CHECK nand3 %L\n" schCheck(cv)) dbSave(cv) dbClose(cv)
cv=dbOpenCellViewByType("sram_project" "and3" "schematic" "" "a") printf("CHECK and3 %L\n" schCheck(cv)) dbSave(cv) dbClose(cv)
cv=dbOpenCellViewByType("sram_project" "nand2" "schematic" "" "a") printf("CHECK nand2 %L\n" schCheck(cv)) dbSave(cv) dbClose(cv)
cv=dbOpenCellViewByType("sram_project" "tg" "schematic" "" "a") printf("CHECK tg %L\n" schCheck(cv)) dbSave(cv) dbClose(cv)
cv=dbOpenCellViewByType("sram_project" "precharge_unit" "schematic" "" "a") printf("CHECK precharge_unit %L\n" schCheck(cv)) dbSave(cv) dbClose(cv)
cv=dbOpenCellViewByType("sram_project" "sense_amp" "schematic" "" "a") printf("CHECK sense_amp %L\n" schCheck(cv)) dbSave(cv) dbClose(cv)
cv=dbOpenCellViewByType("sram_project" "read_latch" "schematic" "" "a") printf("CHECK read_latch %L\n" schCheck(cv)) dbSave(cv) dbClose(cv)
cv=dbOpenCellViewByType("sram_project" "row_decoder" "schematic" "" "a") printf("CHECK row_decoder %L\n" schCheck(cv)) dbSave(cv) dbClose(cv)
cv=dbOpenCellViewByType("sram_project" "column_decoder" "schematic" "" "a") printf("CHECK column_decoder %L\n" schCheck(cv)) dbSave(cv) dbClose(cv)
cv=dbOpenCellViewByType("sram_project" "rw_control" "schematic" "" "a") printf("CHECK rw_control %L\n" schCheck(cv)) dbSave(cv) dbClose(cv)
cv=dbOpenCellViewByType("sram_project" "write_driver" "schematic" "" "a") printf("CHECK write_driver %L\n" schCheck(cv)) dbSave(cv) dbClose(cv)
cv=dbOpenCellViewByType("sram_project" "column_mux" "schematic" "" "a") printf("CHECK column_mux %L\n" schCheck(cv)) dbSave(cv) dbClose(cv)
cv=dbOpenCellViewByType("sram_project" "precharge" "schematic" "" "a") printf("CHECK precharge %L\n" schCheck(cv)) dbSave(cv) dbClose(cv)
cv=dbOpenCellViewByType("sram_project" "bitcell" "schematic" "" "a") printf("CHECK bitcell %L\n" schCheck(cv)) dbSave(cv) dbClose(cv)
cv=dbOpenCellViewByType("sram_project" "bit_array" "schematic" "" "a") printf("CHECK bit_array %L\n" schCheck(cv)) dbSave(cv) dbClose(cv)
cv=dbOpenCellViewByType("sram_project" "sram_4x6" "schematic" "" "a") printf("CHECK sram_4x6 %L\n" schCheck(cv)) dbSave(cv) dbClose(cv)
exit()
