f=outfile("netlists/native.cdl")
cv=dbOpenCellViewByType("sram_project" "inv" "schematic" "" "r")
fprintf(f ".SUBCKT inv IN OUT VDD GND\n")
i=dbFindAnyInstByName(cv "NM0")
fprintf(f "MNM0")
foreach(pn '("D" "G" "S" "B") ti=car(setof(xx i~>instTerms xx~>name==pn)) fprintf(f " %s" ti~>net~>name))
fprintf(f " g45n1svt W=%s L=%s\n" cdfGetInstCDF(i)~>w~>value cdfGetInstCDF(i)~>l~>value)
i=dbFindAnyInstByName(cv "PM0")
fprintf(f "MPM0")
foreach(pn '("D" "G" "S" "B") ti=car(setof(xx i~>instTerms xx~>name==pn)) fprintf(f " %s" ti~>net~>name))
fprintf(f " g45p1svt W=%s L=%s\n" cdfGetInstCDF(i)~>w~>value cdfGetInstCDF(i)~>l~>value)
fprintf(f ".ENDS inv\n")
dbClose(cv)
cv=dbOpenCellViewByType("sram_project" "nand3" "schematic" "" "r")
fprintf(f ".SUBCKT nand3 A B E Y VDD GND\n")
i=dbFindAnyInstByName(cv "NM0")
fprintf(f "MNM0")
foreach(pn '("D" "G" "S" "B") ti=car(setof(xx i~>instTerms xx~>name==pn)) fprintf(f " %s" ti~>net~>name))
fprintf(f " g45n1svt W=%s L=%s\n" cdfGetInstCDF(i)~>w~>value cdfGetInstCDF(i)~>l~>value)
i=dbFindAnyInstByName(cv "NM1")
fprintf(f "MNM1")
foreach(pn '("D" "G" "S" "B") ti=car(setof(xx i~>instTerms xx~>name==pn)) fprintf(f " %s" ti~>net~>name))
fprintf(f " g45n1svt W=%s L=%s\n" cdfGetInstCDF(i)~>w~>value cdfGetInstCDF(i)~>l~>value)
i=dbFindAnyInstByName(cv "NM2")
fprintf(f "MNM2")
foreach(pn '("D" "G" "S" "B") ti=car(setof(xx i~>instTerms xx~>name==pn)) fprintf(f " %s" ti~>net~>name))
fprintf(f " g45n1svt W=%s L=%s\n" cdfGetInstCDF(i)~>w~>value cdfGetInstCDF(i)~>l~>value)
i=dbFindAnyInstByName(cv "PM0")
fprintf(f "MPM0")
foreach(pn '("D" "G" "S" "B") ti=car(setof(xx i~>instTerms xx~>name==pn)) fprintf(f " %s" ti~>net~>name))
fprintf(f " g45p1svt W=%s L=%s\n" cdfGetInstCDF(i)~>w~>value cdfGetInstCDF(i)~>l~>value)
i=dbFindAnyInstByName(cv "PM1")
fprintf(f "MPM1")
foreach(pn '("D" "G" "S" "B") ti=car(setof(xx i~>instTerms xx~>name==pn)) fprintf(f " %s" ti~>net~>name))
fprintf(f " g45p1svt W=%s L=%s\n" cdfGetInstCDF(i)~>w~>value cdfGetInstCDF(i)~>l~>value)
i=dbFindAnyInstByName(cv "PM2")
fprintf(f "MPM2")
foreach(pn '("D" "G" "S" "B") ti=car(setof(xx i~>instTerms xx~>name==pn)) fprintf(f " %s" ti~>net~>name))
fprintf(f " g45p1svt W=%s L=%s\n" cdfGetInstCDF(i)~>w~>value cdfGetInstCDF(i)~>l~>value)
fprintf(f ".ENDS nand3\n")
dbClose(cv)
cv=dbOpenCellViewByType("sram_project" "and3" "schematic" "" "r")
fprintf(f ".SUBCKT and3 A B E Y VDD GND\n")
i=dbFindAnyInstByName(cv "XNAND")
fprintf(f "XNAND")
foreach(pn '("A" "B" "E" "Y" "VDD" "GND") ti=car(setof(xx i~>instTerms xx~>name==pn)) fprintf(f " %s" ti~>net~>name))
fprintf(f " nand3\n")
i=dbFindAnyInstByName(cv "XBUF")
fprintf(f "XBUF")
foreach(pn '("IN" "OUT" "VDD" "GND") ti=car(setof(xx i~>instTerms xx~>name==pn)) fprintf(f " %s" ti~>net~>name))
fprintf(f " inv\n")
fprintf(f ".ENDS and3\n")
dbClose(cv)
cv=dbOpenCellViewByType("sram_project" "nand2" "schematic" "" "r")
fprintf(f ".SUBCKT nand2 A B Y VDD GND\n")
i=dbFindAnyInstByName(cv "N0")
fprintf(f "MN0")
foreach(pn '("D" "G" "S" "B") ti=car(setof(xx i~>instTerms xx~>name==pn)) fprintf(f " %s" ti~>net~>name))
fprintf(f " g45n1svt W=%s L=%s\n" cdfGetInstCDF(i)~>w~>value cdfGetInstCDF(i)~>l~>value)
i=dbFindAnyInstByName(cv "N1")
fprintf(f "MN1")
foreach(pn '("D" "G" "S" "B") ti=car(setof(xx i~>instTerms xx~>name==pn)) fprintf(f " %s" ti~>net~>name))
fprintf(f " g45n1svt W=%s L=%s\n" cdfGetInstCDF(i)~>w~>value cdfGetInstCDF(i)~>l~>value)
i=dbFindAnyInstByName(cv "P0")
fprintf(f "MP0")
foreach(pn '("D" "G" "S" "B") ti=car(setof(xx i~>instTerms xx~>name==pn)) fprintf(f " %s" ti~>net~>name))
fprintf(f " g45p1svt W=%s L=%s\n" cdfGetInstCDF(i)~>w~>value cdfGetInstCDF(i)~>l~>value)
i=dbFindAnyInstByName(cv "P1")
fprintf(f "MP1")
foreach(pn '("D" "G" "S" "B") ti=car(setof(xx i~>instTerms xx~>name==pn)) fprintf(f " %s" ti~>net~>name))
fprintf(f " g45p1svt W=%s L=%s\n" cdfGetInstCDF(i)~>w~>value cdfGetInstCDF(i)~>l~>value)
fprintf(f ".ENDS nand2\n")
dbClose(cv)
cv=dbOpenCellViewByType("sram_project" "tg" "schematic" "" "r")
fprintf(f ".SUBCKT tg A B EN ENB VDD GND\n")
i=dbFindAnyInstByName(cv "N")
fprintf(f "MN")
foreach(pn '("D" "G" "S" "B") ti=car(setof(xx i~>instTerms xx~>name==pn)) fprintf(f " %s" ti~>net~>name))
fprintf(f " g45n1svt W=%s L=%s\n" cdfGetInstCDF(i)~>w~>value cdfGetInstCDF(i)~>l~>value)
i=dbFindAnyInstByName(cv "P")
fprintf(f "MP")
foreach(pn '("D" "G" "S" "B") ti=car(setof(xx i~>instTerms xx~>name==pn)) fprintf(f " %s" ti~>net~>name))
fprintf(f " g45p1svt W=%s L=%s\n" cdfGetInstCDF(i)~>w~>value cdfGetInstCDF(i)~>l~>value)
fprintf(f ".ENDS tg\n")
dbClose(cv)
cv=dbOpenCellViewByType("sram_project" "precharge_unit" "schematic" "" "r")
fprintf(f ".SUBCKT precharge_unit BL BLB PCB VDD GND\n")
i=dbFindAnyInstByName(cv "P0")
fprintf(f "MP0")
foreach(pn '("D" "G" "S" "B") ti=car(setof(xx i~>instTerms xx~>name==pn)) fprintf(f " %s" ti~>net~>name))
fprintf(f " g45p1svt W=%s L=%s\n" cdfGetInstCDF(i)~>w~>value cdfGetInstCDF(i)~>l~>value)
i=dbFindAnyInstByName(cv "P1")
fprintf(f "MP1")
foreach(pn '("D" "G" "S" "B") ti=car(setof(xx i~>instTerms xx~>name==pn)) fprintf(f " %s" ti~>net~>name))
fprintf(f " g45p1svt W=%s L=%s\n" cdfGetInstCDF(i)~>w~>value cdfGetInstCDF(i)~>l~>value)
i=dbFindAnyInstByName(cv "PEQ")
fprintf(f "MPEQ")
foreach(pn '("D" "G" "S" "B") ti=car(setof(xx i~>instTerms xx~>name==pn)) fprintf(f " %s" ti~>net~>name))
fprintf(f " g45p1svt W=%s L=%s\n" cdfGetInstCDF(i)~>w~>value cdfGetInstCDF(i)~>l~>value)
fprintf(f ".ENDS precharge_unit\n")
dbClose(cv)
cv=dbOpenCellViewByType("sram_project" "sense_amp" "schematic" "" "r")
fprintf(f ".SUBCKT sense_amp BIT BIT_bar RE VDD GND AMP_OUT\n")
i=dbFindAnyInstByName(cv "PM6")
fprintf(f "MPM6")
foreach(pn '("D" "G" "S" "B") ti=car(setof(xx i~>instTerms xx~>name==pn)) fprintf(f " %s" ti~>net~>name))
fprintf(f " g45p1svt W=%s L=%s\n" cdfGetInstCDF(i)~>w~>value cdfGetInstCDF(i)~>l~>value)
i=dbFindAnyInstByName(cv "PM5")
fprintf(f "MPM5")
foreach(pn '("D" "G" "S" "B") ti=car(setof(xx i~>instTerms xx~>name==pn)) fprintf(f " %s" ti~>net~>name))
fprintf(f " g45p1svt W=%s L=%s\n" cdfGetInstCDF(i)~>w~>value cdfGetInstCDF(i)~>l~>value)
i=dbFindAnyInstByName(cv "PM7")
fprintf(f "MPM7")
foreach(pn '("D" "G" "S" "B") ti=car(setof(xx i~>instTerms xx~>name==pn)) fprintf(f " %s" ti~>net~>name))
fprintf(f " g45p1svt W=%s L=%s\n" cdfGetInstCDF(i)~>w~>value cdfGetInstCDF(i)~>l~>value)
i=dbFindAnyInstByName(cv "NM41")
fprintf(f "MNM41")
foreach(pn '("D" "G" "S" "B") ti=car(setof(xx i~>instTerms xx~>name==pn)) fprintf(f " %s" ti~>net~>name))
fprintf(f " g45n1svt W=%s L=%s\n" cdfGetInstCDF(i)~>w~>value cdfGetInstCDF(i)~>l~>value)
i=dbFindAnyInstByName(cv "NM40")
fprintf(f "MNM40")
foreach(pn '("D" "G" "S" "B") ti=car(setof(xx i~>instTerms xx~>name==pn)) fprintf(f " %s" ti~>net~>name))
fprintf(f " g45n1svt W=%s L=%s\n" cdfGetInstCDF(i)~>w~>value cdfGetInstCDF(i)~>l~>value)
i=dbFindAnyInstByName(cv "NM39")
fprintf(f "MNM39")
foreach(pn '("D" "G" "S" "B") ti=car(setof(xx i~>instTerms xx~>name==pn)) fprintf(f " %s" ti~>net~>name))
fprintf(f " g45n1svt W=%s L=%s\n" cdfGetInstCDF(i)~>w~>value cdfGetInstCDF(i)~>l~>value)
i=dbFindAnyInstByName(cv "NM38")
fprintf(f "MNM38")
foreach(pn '("D" "G" "S" "B") ti=car(setof(xx i~>instTerms xx~>name==pn)) fprintf(f " %s" ti~>net~>name))
fprintf(f " g45n1svt W=%s L=%s\n" cdfGetInstCDF(i)~>w~>value cdfGetInstCDF(i)~>l~>value)
fprintf(f ".ENDS sense_amp\n")
dbClose(cv)
cv=dbOpenCellViewByType("sram_project" "read_latch" "schematic" "" "r")
fprintf(f ".SUBCKT read_latch D EN ENB Q VDD GND\n")
i=dbFindAnyInstByName(cv "XINPUT")
fprintf(f "XINPUT")
foreach(pn '("A" "B" "EN" "ENB" "VDD" "GND") ti=car(setof(xx i~>instTerms xx~>name==pn)) fprintf(f " %s" ti~>net~>name))
fprintf(f " tg\n")
i=dbFindAnyInstByName(cv "XI0")
fprintf(f "XI0")
foreach(pn '("IN" "OUT" "VDD" "GND") ti=car(setof(xx i~>instTerms xx~>name==pn)) fprintf(f " %s" ti~>net~>name))
fprintf(f " inv\n")
i=dbFindAnyInstByName(cv "XI1")
fprintf(f "XI1")
foreach(pn '("IN" "OUT" "VDD" "GND") ti=car(setof(xx i~>instTerms xx~>name==pn)) fprintf(f " %s" ti~>net~>name))
fprintf(f " inv\n")
i=dbFindAnyInstByName(cv "XFEEDBACK")
fprintf(f "XFEEDBACK")
foreach(pn '("A" "B" "EN" "ENB" "VDD" "GND") ti=car(setof(xx i~>instTerms xx~>name==pn)) fprintf(f " %s" ti~>net~>name))
fprintf(f " tg\n")
fprintf(f ".ENDS read_latch\n")
dbClose(cv)
cv=dbOpenCellViewByType("sram_project" "row_decoder" "schematic" "" "r")
fprintf(f ".SUBCKT row_decoder R1 R0 EN WL0 WL1 WL2 WL3 VDD GND\n")
i=dbFindAnyInstByName(cv "XI0")
fprintf(f "XI0")
foreach(pn '("IN" "OUT" "VDD" "GND") ti=car(setof(xx i~>instTerms xx~>name==pn)) fprintf(f " %s" ti~>net~>name))
fprintf(f " inv\n")
i=dbFindAnyInstByName(cv "XI1")
fprintf(f "XI1")
foreach(pn '("IN" "OUT" "VDD" "GND") ti=car(setof(xx i~>instTerms xx~>name==pn)) fprintf(f " %s" ti~>net~>name))
fprintf(f " inv\n")
i=dbFindAnyInstByName(cv "XR0")
fprintf(f "XR0")
foreach(pn '("A" "B" "E" "Y" "VDD" "GND") ti=car(setof(xx i~>instTerms xx~>name==pn)) fprintf(f " %s" ti~>net~>name))
fprintf(f " and3\n")
i=dbFindAnyInstByName(cv "XR1")
fprintf(f "XR1")
foreach(pn '("A" "B" "E" "Y" "VDD" "GND") ti=car(setof(xx i~>instTerms xx~>name==pn)) fprintf(f " %s" ti~>net~>name))
fprintf(f " and3\n")
i=dbFindAnyInstByName(cv "XR2")
fprintf(f "XR2")
foreach(pn '("A" "B" "E" "Y" "VDD" "GND") ti=car(setof(xx i~>instTerms xx~>name==pn)) fprintf(f " %s" ti~>net~>name))
fprintf(f " and3\n")
i=dbFindAnyInstByName(cv "XR3")
fprintf(f "XR3")
foreach(pn '("A" "B" "E" "Y" "VDD" "GND") ti=car(setof(xx i~>instTerms xx~>name==pn)) fprintf(f " %s" ti~>net~>name))
fprintf(f " and3\n")
fprintf(f ".ENDS row_decoder\n")
dbClose(cv)
cv=dbOpenCellViewByType("sram_project" "column_decoder" "schematic" "" "r")
fprintf(f ".SUBCKT column_decoder C2 C1 C0 CS0 CS1 CS2 CS3 CS4 CS5 VDD GND\n")
i=dbFindAnyInstByName(cv "XI0")
fprintf(f "XI0")
foreach(pn '("IN" "OUT" "VDD" "GND") ti=car(setof(xx i~>instTerms xx~>name==pn)) fprintf(f " %s" ti~>net~>name))
fprintf(f " inv\n")
i=dbFindAnyInstByName(cv "XI1")
fprintf(f "XI1")
foreach(pn '("IN" "OUT" "VDD" "GND") ti=car(setof(xx i~>instTerms xx~>name==pn)) fprintf(f " %s" ti~>net~>name))
fprintf(f " inv\n")
i=dbFindAnyInstByName(cv "XI2")
fprintf(f "XI2")
foreach(pn '("IN" "OUT" "VDD" "GND") ti=car(setof(xx i~>instTerms xx~>name==pn)) fprintf(f " %s" ti~>net~>name))
fprintf(f " inv\n")
i=dbFindAnyInstByName(cv "XC0")
fprintf(f "XC0")
foreach(pn '("A" "B" "E" "Y" "VDD" "GND") ti=car(setof(xx i~>instTerms xx~>name==pn)) fprintf(f " %s" ti~>net~>name))
fprintf(f " and3\n")
i=dbFindAnyInstByName(cv "XC1")
fprintf(f "XC1")
foreach(pn '("A" "B" "E" "Y" "VDD" "GND") ti=car(setof(xx i~>instTerms xx~>name==pn)) fprintf(f " %s" ti~>net~>name))
fprintf(f " and3\n")
i=dbFindAnyInstByName(cv "XC2")
fprintf(f "XC2")
foreach(pn '("A" "B" "E" "Y" "VDD" "GND") ti=car(setof(xx i~>instTerms xx~>name==pn)) fprintf(f " %s" ti~>net~>name))
fprintf(f " and3\n")
i=dbFindAnyInstByName(cv "XC3")
fprintf(f "XC3")
foreach(pn '("A" "B" "E" "Y" "VDD" "GND") ti=car(setof(xx i~>instTerms xx~>name==pn)) fprintf(f " %s" ti~>net~>name))
fprintf(f " and3\n")
i=dbFindAnyInstByName(cv "XC4")
fprintf(f "XC4")
foreach(pn '("A" "B" "E" "Y" "VDD" "GND") ti=car(setof(xx i~>instTerms xx~>name==pn)) fprintf(f " %s" ti~>net~>name))
fprintf(f " and3\n")
i=dbFindAnyInstByName(cv "XC5")
fprintf(f "XC5")
foreach(pn '("A" "B" "E" "Y" "VDD" "GND") ti=car(setof(xx i~>instTerms xx~>name==pn)) fprintf(f " %s" ti~>net~>name))
fprintf(f " and3\n")
fprintf(f ".ENDS column_decoder\n")
dbClose(cv)
cv=dbOpenCellViewByType("sram_project" "rw_control" "schematic" "" "r")
fprintf(f ".SUBCKT rw_control CLK1 CLK2 WR RD C2 C1 WEN WENB REN RENB ROWEN PCB VDD GND\n")
i=dbFindAnyInstByName(cv "XIRD")
fprintf(f "XIRD")
foreach(pn '("IN" "OUT" "VDD" "GND") ti=car(setof(xx i~>instTerms xx~>name==pn)) fprintf(f " %s" ti~>net~>name))
fprintf(f " inv\n")
i=dbFindAnyInstByName(cv "XIWR")
fprintf(f "XIWR")
foreach(pn '("IN" "OUT" "VDD" "GND") ti=car(setof(xx i~>instTerms xx~>name==pn)) fprintf(f " %s" ti~>net~>name))
fprintf(f " inv\n")
i=dbFindAnyInstByName(cv "XIPRE")
fprintf(f "XIPRE")
foreach(pn '("IN" "OUT" "VDD" "GND") ti=car(setof(xx i~>instTerms xx~>name==pn)) fprintf(f " %s" ti~>net~>name))
fprintf(f " inv\n")
i=dbFindAnyInstByName(cv "XBAD")
fprintf(f "XBAD")
foreach(pn '("A" "B" "E" "Y" "VDD" "GND") ti=car(setof(xx i~>instTerms xx~>name==pn)) fprintf(f " %s" ti~>net~>name))
fprintf(f " and3\n")
i=dbFindAnyInstByName(cv "XVALID")
fprintf(f "XVALID")
foreach(pn '("IN" "OUT" "VDD" "GND") ti=car(setof(xx i~>instTerms xx~>name==pn)) fprintf(f " %s" ti~>net~>name))
fprintf(f " inv\n")
i=dbFindAnyInstByName(cv "XWA")
fprintf(f "XWA")
foreach(pn '("A" "B" "E" "Y" "VDD" "GND") ti=car(setof(xx i~>instTerms xx~>name==pn)) fprintf(f " %s" ti~>net~>name))
fprintf(f " and3\n")
i=dbFindAnyInstByName(cv "XRA")
fprintf(f "XRA")
foreach(pn '("A" "B" "E" "Y" "VDD" "GND") ti=car(setof(xx i~>instTerms xx~>name==pn)) fprintf(f " %s" ti~>net~>name))
fprintf(f " and3\n")
i=dbFindAnyInstByName(cv "XWE")
fprintf(f "XWE")
foreach(pn '("A" "B" "E" "Y" "VDD" "GND") ti=car(setof(xx i~>instTerms xx~>name==pn)) fprintf(f " %s" ti~>net~>name))
fprintf(f " and3\n")
i=dbFindAnyInstByName(cv "XRE")
fprintf(f "XRE")
foreach(pn '("A" "B" "E" "Y" "VDD" "GND") ti=car(setof(xx i~>instTerms xx~>name==pn)) fprintf(f " %s" ti~>net~>name))
fprintf(f " and3\n")
i=dbFindAnyInstByName(cv "XIWE")
fprintf(f "XIWE")
foreach(pn '("IN" "OUT" "VDD" "GND") ti=car(setof(xx i~>instTerms xx~>name==pn)) fprintf(f " %s" ti~>net~>name))
fprintf(f " inv\n")
i=dbFindAnyInstByName(cv "XIRE")
fprintf(f "XIRE")
foreach(pn '("IN" "OUT" "VDD" "GND") ti=car(setof(xx i~>instTerms xx~>name==pn)) fprintf(f " %s" ti~>net~>name))
fprintf(f " inv\n")
i=dbFindAnyInstByName(cv "XIDLE")
fprintf(f "XIDLE")
foreach(pn '("A" "B" "E" "Y" "VDD" "GND") ti=car(setof(xx i~>instTerms xx~>name==pn)) fprintf(f " %s" ti~>net~>name))
fprintf(f " and3\n")
i=dbFindAnyInstByName(cv "XACTIVE")
fprintf(f "XACTIVE")
foreach(pn '("IN" "OUT" "VDD" "GND") ti=car(setof(xx i~>instTerms xx~>name==pn)) fprintf(f " %s" ti~>net~>name))
fprintf(f " inv\n")
fprintf(f ".ENDS rw_control\n")
dbClose(cv)
cv=dbOpenCellViewByType("sram_project" "write_driver" "schematic" "" "r")
fprintf(f ".SUBCKT write_driver DIN WEN WENB GBL GBLB VDD GND\n")
i=dbFindAnyInstByName(cv "XID")
fprintf(f "XID")
foreach(pn '("IN" "OUT" "VDD" "GND") ti=car(setof(xx i~>instTerms xx~>name==pn)) fprintf(f " %s" ti~>net~>name))
fprintf(f " inv\n")
i=dbFindAnyInstByName(cv "XW0")
fprintf(f "XW0")
foreach(pn '("A" "B" "EN" "ENB" "VDD" "GND") ti=car(setof(xx i~>instTerms xx~>name==pn)) fprintf(f " %s" ti~>net~>name))
fprintf(f " tg\n")
i=dbFindAnyInstByName(cv "XW1")
fprintf(f "XW1")
foreach(pn '("A" "B" "EN" "ENB" "VDD" "GND") ti=car(setof(xx i~>instTerms xx~>name==pn)) fprintf(f " %s" ti~>net~>name))
fprintf(f " tg\n")
fprintf(f ".ENDS write_driver\n")
dbClose(cv)
cv=dbOpenCellViewByType("sram_project" "column_mux" "schematic" "" "r")
fprintf(f ".SUBCKT column_mux CS0 CS1 CS2 CS3 CS4 CS5 BL0 BL1 BL2 BL3 BL4 BL5 BLB0 BLB1 BLB2 BLB3 BLB4 BLB5 GBL GBLB VDD GND\n")
i=dbFindAnyInstByName(cv "XI0")
fprintf(f "XI0")
foreach(pn '("IN" "OUT" "VDD" "GND") ti=car(setof(xx i~>instTerms xx~>name==pn)) fprintf(f " %s" ti~>net~>name))
fprintf(f " inv\n")
i=dbFindAnyInstByName(cv "XM0P")
fprintf(f "XM0P")
foreach(pn '("A" "B" "EN" "ENB" "VDD" "GND") ti=car(setof(xx i~>instTerms xx~>name==pn)) fprintf(f " %s" ti~>net~>name))
fprintf(f " tg\n")
i=dbFindAnyInstByName(cv "XM0N")
fprintf(f "XM0N")
foreach(pn '("A" "B" "EN" "ENB" "VDD" "GND") ti=car(setof(xx i~>instTerms xx~>name==pn)) fprintf(f " %s" ti~>net~>name))
fprintf(f " tg\n")
i=dbFindAnyInstByName(cv "XI1")
fprintf(f "XI1")
foreach(pn '("IN" "OUT" "VDD" "GND") ti=car(setof(xx i~>instTerms xx~>name==pn)) fprintf(f " %s" ti~>net~>name))
fprintf(f " inv\n")
i=dbFindAnyInstByName(cv "XM1P")
fprintf(f "XM1P")
foreach(pn '("A" "B" "EN" "ENB" "VDD" "GND") ti=car(setof(xx i~>instTerms xx~>name==pn)) fprintf(f " %s" ti~>net~>name))
fprintf(f " tg\n")
i=dbFindAnyInstByName(cv "XM1N")
fprintf(f "XM1N")
foreach(pn '("A" "B" "EN" "ENB" "VDD" "GND") ti=car(setof(xx i~>instTerms xx~>name==pn)) fprintf(f " %s" ti~>net~>name))
fprintf(f " tg\n")
i=dbFindAnyInstByName(cv "XI2")
fprintf(f "XI2")
foreach(pn '("IN" "OUT" "VDD" "GND") ti=car(setof(xx i~>instTerms xx~>name==pn)) fprintf(f " %s" ti~>net~>name))
fprintf(f " inv\n")
i=dbFindAnyInstByName(cv "XM2P")
fprintf(f "XM2P")
foreach(pn '("A" "B" "EN" "ENB" "VDD" "GND") ti=car(setof(xx i~>instTerms xx~>name==pn)) fprintf(f " %s" ti~>net~>name))
fprintf(f " tg\n")
i=dbFindAnyInstByName(cv "XM2N")
fprintf(f "XM2N")
foreach(pn '("A" "B" "EN" "ENB" "VDD" "GND") ti=car(setof(xx i~>instTerms xx~>name==pn)) fprintf(f " %s" ti~>net~>name))
fprintf(f " tg\n")
i=dbFindAnyInstByName(cv "XI3")
fprintf(f "XI3")
foreach(pn '("IN" "OUT" "VDD" "GND") ti=car(setof(xx i~>instTerms xx~>name==pn)) fprintf(f " %s" ti~>net~>name))
fprintf(f " inv\n")
i=dbFindAnyInstByName(cv "XM3P")
fprintf(f "XM3P")
foreach(pn '("A" "B" "EN" "ENB" "VDD" "GND") ti=car(setof(xx i~>instTerms xx~>name==pn)) fprintf(f " %s" ti~>net~>name))
fprintf(f " tg\n")
i=dbFindAnyInstByName(cv "XM3N")
fprintf(f "XM3N")
foreach(pn '("A" "B" "EN" "ENB" "VDD" "GND") ti=car(setof(xx i~>instTerms xx~>name==pn)) fprintf(f " %s" ti~>net~>name))
fprintf(f " tg\n")
i=dbFindAnyInstByName(cv "XI4")
fprintf(f "XI4")
foreach(pn '("IN" "OUT" "VDD" "GND") ti=car(setof(xx i~>instTerms xx~>name==pn)) fprintf(f " %s" ti~>net~>name))
fprintf(f " inv\n")
i=dbFindAnyInstByName(cv "XM4P")
fprintf(f "XM4P")
foreach(pn '("A" "B" "EN" "ENB" "VDD" "GND") ti=car(setof(xx i~>instTerms xx~>name==pn)) fprintf(f " %s" ti~>net~>name))
fprintf(f " tg\n")
i=dbFindAnyInstByName(cv "XM4N")
fprintf(f "XM4N")
foreach(pn '("A" "B" "EN" "ENB" "VDD" "GND") ti=car(setof(xx i~>instTerms xx~>name==pn)) fprintf(f " %s" ti~>net~>name))
fprintf(f " tg\n")
i=dbFindAnyInstByName(cv "XI5")
fprintf(f "XI5")
foreach(pn '("IN" "OUT" "VDD" "GND") ti=car(setof(xx i~>instTerms xx~>name==pn)) fprintf(f " %s" ti~>net~>name))
fprintf(f " inv\n")
i=dbFindAnyInstByName(cv "XM5P")
fprintf(f "XM5P")
foreach(pn '("A" "B" "EN" "ENB" "VDD" "GND") ti=car(setof(xx i~>instTerms xx~>name==pn)) fprintf(f " %s" ti~>net~>name))
fprintf(f " tg\n")
i=dbFindAnyInstByName(cv "XM5N")
fprintf(f "XM5N")
foreach(pn '("A" "B" "EN" "ENB" "VDD" "GND") ti=car(setof(xx i~>instTerms xx~>name==pn)) fprintf(f " %s" ti~>net~>name))
fprintf(f " tg\n")
fprintf(f ".ENDS column_mux\n")
dbClose(cv)
cv=dbOpenCellViewByType("sram_project" "precharge" "schematic" "" "r")
fprintf(f ".SUBCKT precharge BL0 BL1 BL2 BL3 BL4 BL5 BLB0 BLB1 BLB2 BLB3 BLB4 BLB5 PCB VDD GND\n")
i=dbFindAnyInstByName(cv "XP0")
fprintf(f "XP0")
foreach(pn '("BL" "BLB" "PCB" "VDD" "GND") ti=car(setof(xx i~>instTerms xx~>name==pn)) fprintf(f " %s" ti~>net~>name))
fprintf(f " precharge_unit\n")
i=dbFindAnyInstByName(cv "XP1")
fprintf(f "XP1")
foreach(pn '("BL" "BLB" "PCB" "VDD" "GND") ti=car(setof(xx i~>instTerms xx~>name==pn)) fprintf(f " %s" ti~>net~>name))
fprintf(f " precharge_unit\n")
i=dbFindAnyInstByName(cv "XP2")
fprintf(f "XP2")
foreach(pn '("BL" "BLB" "PCB" "VDD" "GND") ti=car(setof(xx i~>instTerms xx~>name==pn)) fprintf(f " %s" ti~>net~>name))
fprintf(f " precharge_unit\n")
i=dbFindAnyInstByName(cv "XP3")
fprintf(f "XP3")
foreach(pn '("BL" "BLB" "PCB" "VDD" "GND") ti=car(setof(xx i~>instTerms xx~>name==pn)) fprintf(f " %s" ti~>net~>name))
fprintf(f " precharge_unit\n")
i=dbFindAnyInstByName(cv "XP4")
fprintf(f "XP4")
foreach(pn '("BL" "BLB" "PCB" "VDD" "GND") ti=car(setof(xx i~>instTerms xx~>name==pn)) fprintf(f " %s" ti~>net~>name))
fprintf(f " precharge_unit\n")
i=dbFindAnyInstByName(cv "XP5")
fprintf(f "XP5")
foreach(pn '("BL" "BLB" "PCB" "VDD" "GND") ti=car(setof(xx i~>instTerms xx~>name==pn)) fprintf(f " %s" ti~>net~>name))
fprintf(f " precharge_unit\n")
fprintf(f ".ENDS precharge\n")
dbClose(cv)
cv=dbOpenCellViewByType("sram_project" "bitcell" "schematic" "" "r")
fprintf(f ".SUBCKT bitcell BL BL_bar WL Q Q_bar VDD GND\n")
i=dbFindAnyInstByName(cv "PM0")
fprintf(f "MPM0")
foreach(pn '("D" "G" "S" "B") ti=car(setof(xx i~>instTerms xx~>name==pn)) fprintf(f " %s" ti~>net~>name))
fprintf(f " g45p1svt W=%s L=%s\n" cdfGetInstCDF(i)~>w~>value cdfGetInstCDF(i)~>l~>value)
i=dbFindAnyInstByName(cv "PM1")
fprintf(f "MPM1")
foreach(pn '("D" "G" "S" "B") ti=car(setof(xx i~>instTerms xx~>name==pn)) fprintf(f " %s" ti~>net~>name))
fprintf(f " g45p1svt W=%s L=%s\n" cdfGetInstCDF(i)~>w~>value cdfGetInstCDF(i)~>l~>value)
i=dbFindAnyInstByName(cv "NM0")
fprintf(f "MNM0")
foreach(pn '("D" "G" "S" "B") ti=car(setof(xx i~>instTerms xx~>name==pn)) fprintf(f " %s" ti~>net~>name))
fprintf(f " g45n1svt W=%s L=%s\n" cdfGetInstCDF(i)~>w~>value cdfGetInstCDF(i)~>l~>value)
i=dbFindAnyInstByName(cv "NM1")
fprintf(f "MNM1")
foreach(pn '("D" "G" "S" "B") ti=car(setof(xx i~>instTerms xx~>name==pn)) fprintf(f " %s" ti~>net~>name))
fprintf(f " g45n1svt W=%s L=%s\n" cdfGetInstCDF(i)~>w~>value cdfGetInstCDF(i)~>l~>value)
i=dbFindAnyInstByName(cv "NM2")
fprintf(f "MNM2")
foreach(pn '("D" "G" "S" "B") ti=car(setof(xx i~>instTerms xx~>name==pn)) fprintf(f " %s" ti~>net~>name))
fprintf(f " g45n1svt W=%s L=%s\n" cdfGetInstCDF(i)~>w~>value cdfGetInstCDF(i)~>l~>value)
i=dbFindAnyInstByName(cv "NM3")
fprintf(f "MNM3")
foreach(pn '("D" "G" "S" "B") ti=car(setof(xx i~>instTerms xx~>name==pn)) fprintf(f " %s" ti~>net~>name))
fprintf(f " g45n1svt W=%s L=%s\n" cdfGetInstCDF(i)~>w~>value cdfGetInstCDF(i)~>l~>value)
fprintf(f ".ENDS bitcell\n")
dbClose(cv)
cv=dbOpenCellViewByType("sram_project" "bit_array" "schematic" "" "r")
fprintf(f ".SUBCKT bit_array WL0 WL1 WL2 WL3 BL0 BL1 BL2 BL3 BL4 BL5 BLB0 BLB1 BLB2 BLB3 BLB4 BLB5 VDD GND\n")
i=dbFindAnyInstByName(cv "XB0_0")
fprintf(f "XB0_0")
foreach(pn '("BL" "BL_bar" "WL" "Q" "Q_bar" "VDD" "GND") ti=car(setof(xx i~>instTerms xx~>name==pn)) fprintf(f " %s" ti~>net~>name))
fprintf(f " bitcell\n")
i=dbFindAnyInstByName(cv "XB0_1")
fprintf(f "XB0_1")
foreach(pn '("BL" "BL_bar" "WL" "Q" "Q_bar" "VDD" "GND") ti=car(setof(xx i~>instTerms xx~>name==pn)) fprintf(f " %s" ti~>net~>name))
fprintf(f " bitcell\n")
i=dbFindAnyInstByName(cv "XB0_2")
fprintf(f "XB0_2")
foreach(pn '("BL" "BL_bar" "WL" "Q" "Q_bar" "VDD" "GND") ti=car(setof(xx i~>instTerms xx~>name==pn)) fprintf(f " %s" ti~>net~>name))
fprintf(f " bitcell\n")
i=dbFindAnyInstByName(cv "XB0_3")
fprintf(f "XB0_3")
foreach(pn '("BL" "BL_bar" "WL" "Q" "Q_bar" "VDD" "GND") ti=car(setof(xx i~>instTerms xx~>name==pn)) fprintf(f " %s" ti~>net~>name))
fprintf(f " bitcell\n")
i=dbFindAnyInstByName(cv "XB0_4")
fprintf(f "XB0_4")
foreach(pn '("BL" "BL_bar" "WL" "Q" "Q_bar" "VDD" "GND") ti=car(setof(xx i~>instTerms xx~>name==pn)) fprintf(f " %s" ti~>net~>name))
fprintf(f " bitcell\n")
i=dbFindAnyInstByName(cv "XB0_5")
fprintf(f "XB0_5")
foreach(pn '("BL" "BL_bar" "WL" "Q" "Q_bar" "VDD" "GND") ti=car(setof(xx i~>instTerms xx~>name==pn)) fprintf(f " %s" ti~>net~>name))
fprintf(f " bitcell\n")
i=dbFindAnyInstByName(cv "XB1_0")
fprintf(f "XB1_0")
foreach(pn '("BL" "BL_bar" "WL" "Q" "Q_bar" "VDD" "GND") ti=car(setof(xx i~>instTerms xx~>name==pn)) fprintf(f " %s" ti~>net~>name))
fprintf(f " bitcell\n")
i=dbFindAnyInstByName(cv "XB1_1")
fprintf(f "XB1_1")
foreach(pn '("BL" "BL_bar" "WL" "Q" "Q_bar" "VDD" "GND") ti=car(setof(xx i~>instTerms xx~>name==pn)) fprintf(f " %s" ti~>net~>name))
fprintf(f " bitcell\n")
i=dbFindAnyInstByName(cv "XB1_2")
fprintf(f "XB1_2")
foreach(pn '("BL" "BL_bar" "WL" "Q" "Q_bar" "VDD" "GND") ti=car(setof(xx i~>instTerms xx~>name==pn)) fprintf(f " %s" ti~>net~>name))
fprintf(f " bitcell\n")
i=dbFindAnyInstByName(cv "XB1_3")
fprintf(f "XB1_3")
foreach(pn '("BL" "BL_bar" "WL" "Q" "Q_bar" "VDD" "GND") ti=car(setof(xx i~>instTerms xx~>name==pn)) fprintf(f " %s" ti~>net~>name))
fprintf(f " bitcell\n")
i=dbFindAnyInstByName(cv "XB1_4")
fprintf(f "XB1_4")
foreach(pn '("BL" "BL_bar" "WL" "Q" "Q_bar" "VDD" "GND") ti=car(setof(xx i~>instTerms xx~>name==pn)) fprintf(f " %s" ti~>net~>name))
fprintf(f " bitcell\n")
i=dbFindAnyInstByName(cv "XB1_5")
fprintf(f "XB1_5")
foreach(pn '("BL" "BL_bar" "WL" "Q" "Q_bar" "VDD" "GND") ti=car(setof(xx i~>instTerms xx~>name==pn)) fprintf(f " %s" ti~>net~>name))
fprintf(f " bitcell\n")
i=dbFindAnyInstByName(cv "XB2_0")
fprintf(f "XB2_0")
foreach(pn '("BL" "BL_bar" "WL" "Q" "Q_bar" "VDD" "GND") ti=car(setof(xx i~>instTerms xx~>name==pn)) fprintf(f " %s" ti~>net~>name))
fprintf(f " bitcell\n")
i=dbFindAnyInstByName(cv "XB2_1")
fprintf(f "XB2_1")
foreach(pn '("BL" "BL_bar" "WL" "Q" "Q_bar" "VDD" "GND") ti=car(setof(xx i~>instTerms xx~>name==pn)) fprintf(f " %s" ti~>net~>name))
fprintf(f " bitcell\n")
i=dbFindAnyInstByName(cv "XB2_2")
fprintf(f "XB2_2")
foreach(pn '("BL" "BL_bar" "WL" "Q" "Q_bar" "VDD" "GND") ti=car(setof(xx i~>instTerms xx~>name==pn)) fprintf(f " %s" ti~>net~>name))
fprintf(f " bitcell\n")
i=dbFindAnyInstByName(cv "XB2_3")
fprintf(f "XB2_3")
foreach(pn '("BL" "BL_bar" "WL" "Q" "Q_bar" "VDD" "GND") ti=car(setof(xx i~>instTerms xx~>name==pn)) fprintf(f " %s" ti~>net~>name))
fprintf(f " bitcell\n")
i=dbFindAnyInstByName(cv "XB2_4")
fprintf(f "XB2_4")
foreach(pn '("BL" "BL_bar" "WL" "Q" "Q_bar" "VDD" "GND") ti=car(setof(xx i~>instTerms xx~>name==pn)) fprintf(f " %s" ti~>net~>name))
fprintf(f " bitcell\n")
i=dbFindAnyInstByName(cv "XB2_5")
fprintf(f "XB2_5")
foreach(pn '("BL" "BL_bar" "WL" "Q" "Q_bar" "VDD" "GND") ti=car(setof(xx i~>instTerms xx~>name==pn)) fprintf(f " %s" ti~>net~>name))
fprintf(f " bitcell\n")
i=dbFindAnyInstByName(cv "XB3_0")
fprintf(f "XB3_0")
foreach(pn '("BL" "BL_bar" "WL" "Q" "Q_bar" "VDD" "GND") ti=car(setof(xx i~>instTerms xx~>name==pn)) fprintf(f " %s" ti~>net~>name))
fprintf(f " bitcell\n")
i=dbFindAnyInstByName(cv "XB3_1")
fprintf(f "XB3_1")
foreach(pn '("BL" "BL_bar" "WL" "Q" "Q_bar" "VDD" "GND") ti=car(setof(xx i~>instTerms xx~>name==pn)) fprintf(f " %s" ti~>net~>name))
fprintf(f " bitcell\n")
i=dbFindAnyInstByName(cv "XB3_2")
fprintf(f "XB3_2")
foreach(pn '("BL" "BL_bar" "WL" "Q" "Q_bar" "VDD" "GND") ti=car(setof(xx i~>instTerms xx~>name==pn)) fprintf(f " %s" ti~>net~>name))
fprintf(f " bitcell\n")
i=dbFindAnyInstByName(cv "XB3_3")
fprintf(f "XB3_3")
foreach(pn '("BL" "BL_bar" "WL" "Q" "Q_bar" "VDD" "GND") ti=car(setof(xx i~>instTerms xx~>name==pn)) fprintf(f " %s" ti~>net~>name))
fprintf(f " bitcell\n")
i=dbFindAnyInstByName(cv "XB3_4")
fprintf(f "XB3_4")
foreach(pn '("BL" "BL_bar" "WL" "Q" "Q_bar" "VDD" "GND") ti=car(setof(xx i~>instTerms xx~>name==pn)) fprintf(f " %s" ti~>net~>name))
fprintf(f " bitcell\n")
i=dbFindAnyInstByName(cv "XB3_5")
fprintf(f "XB3_5")
foreach(pn '("BL" "BL_bar" "WL" "Q" "Q_bar" "VDD" "GND") ti=car(setof(xx i~>instTerms xx~>name==pn)) fprintf(f " %s" ti~>net~>name))
fprintf(f " bitcell\n")
fprintf(f ".ENDS bit_array\n")
dbClose(cv)
cv=dbOpenCellViewByType("sram_project" "sram_4x6" "schematic" "" "r")
fprintf(f ".SUBCKT sram_4x6 R1 R0 C2 C1 C0 CLK1 CLK2 WR RD DIN DOUT VDD GND\n")
i=dbFindAnyInstByName(cv "XCTRL")
fprintf(f "XCTRL")
foreach(pn '("CLK1" "CLK2" "WR" "RD" "C2" "C1" "WEN" "WENB" "REN" "RENB" "ROWEN" "PCB" "VDD" "GND") ti=car(setof(xx i~>instTerms xx~>name==pn)) fprintf(f " %s" ti~>net~>name))
fprintf(f " rw_control\n")
i=dbFindAnyInstByName(cv "XROW")
fprintf(f "XROW")
foreach(pn '("R1" "R0" "EN" "WL0" "WL1" "WL2" "WL3" "VDD" "GND") ti=car(setof(xx i~>instTerms xx~>name==pn)) fprintf(f " %s" ti~>net~>name))
fprintf(f " row_decoder\n")
i=dbFindAnyInstByName(cv "XCOL")
fprintf(f "XCOL")
foreach(pn '("C2" "C1" "C0" "CS0" "CS1" "CS2" "CS3" "CS4" "CS5" "VDD" "GND") ti=car(setof(xx i~>instTerms xx~>name==pn)) fprintf(f " %s" ti~>net~>name))
fprintf(f " column_decoder\n")
i=dbFindAnyInstByName(cv "XPRE")
fprintf(f "XPRE")
foreach(pn '("BL0" "BL1" "BL2" "BL3" "BL4" "BL5" "BLB0" "BLB1" "BLB2" "BLB3" "BLB4" "BLB5" "PCB" "VDD" "GND") ti=car(setof(xx i~>instTerms xx~>name==pn)) fprintf(f " %s" ti~>net~>name))
fprintf(f " precharge\n")
i=dbFindAnyInstByName(cv "XMUX")
fprintf(f "XMUX")
foreach(pn '("CS0" "CS1" "CS2" "CS3" "CS4" "CS5" "BL0" "BL1" "BL2" "BL3" "BL4" "BL5" "BLB0" "BLB1" "BLB2" "BLB3" "BLB4" "BLB5" "GBL" "GBLB" "VDD" "GND") ti=car(setof(xx i~>instTerms xx~>name==pn)) fprintf(f " %s" ti~>net~>name))
fprintf(f " column_mux\n")
i=dbFindAnyInstByName(cv "XWRITE")
fprintf(f "XWRITE")
foreach(pn '("DIN" "WEN" "WENB" "GBL" "GBLB" "VDD" "GND") ti=car(setof(xx i~>instTerms xx~>name==pn)) fprintf(f " %s" ti~>net~>name))
fprintf(f " write_driver\n")
i=dbFindAnyInstByName(cv "XMEM")
fprintf(f "XMEM")
foreach(pn '("WL0" "WL1" "WL2" "WL3" "BL0" "BL1" "BL2" "BL3" "BL4" "BL5" "BLB0" "BLB1" "BLB2" "BLB3" "BLB4" "BLB5" "VDD" "GND") ti=car(setof(xx i~>instTerms xx~>name==pn)) fprintf(f " %s" ti~>net~>name))
fprintf(f " bit_array\n")
i=dbFindAnyInstByName(cv "XSENSE")
fprintf(f "XSENSE")
foreach(pn '("BIT" "BIT_bar" "RE" "VDD" "GND" "AMP_OUT") ti=car(setof(xx i~>instTerms xx~>name==pn)) fprintf(f " %s" ti~>net~>name))
fprintf(f " sense_amp\n")
i=dbFindAnyInstByName(cv "XLATCH")
fprintf(f "XLATCH")
foreach(pn '("D" "EN" "ENB" "Q" "VDD" "GND") ti=car(setof(xx i~>instTerms xx~>name==pn)) fprintf(f " %s" ti~>net~>name))
fprintf(f " read_latch\n")
fprintf(f ".ENDS sram_4x6\n")
dbClose(cv)
close(f)
exit()
