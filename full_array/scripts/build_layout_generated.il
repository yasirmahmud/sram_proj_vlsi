procedure(rect(cv layer x1 y1 x2 y2) dbCreateRect(cv list(layer "drawing") list(list(x1 y1) list(x2 y2))))
procedure(dev(cv name kind x y w l)
 dbCreateParamInst(cv dbOpenCellViewByType("gpdk045" kind "layout" "" "r") name list(x y) "R0" 1 list(list("fw" "float" w*1e-9) list("l" "float" l*1e-9))))
procedure(port(cv name layer x y)
 let((net fig)
 net=dbCreateNet(cv name) dbCreateTerm(net name "inputOutput")
 fig=dbCreateRect(cv list(layer "pin") list(list(x-.065 y-.065) list(x+.065 y+.065))) dbCreatePin(net fig name)
 dbCreateLabel(cv list(layer "label") list(x y) name "centerCenter" "R0" "roman" .06)))
cv=dbOpenCellViewByType("sram_project" "inv" "layout" "maskLayout" "w")
rect(cv "Metal3" 0.18 0.03 0.32 3.6)
rect(cv "Metal3" 0.5 0.03 0.64 3.6)
rect(cv "Metal3" 0.82 0.03 0.96 3.6)
rect(cv "Metal3" 1.14 0.03 1.28 3.6)
dev(cv "NM0" "nmos1v" 1.68 0.77 360 45)
rect(cv "Metal1" 1.56 0.31 1.64 0.99)
rect(cv "Via1" 1.565 0.315 1.635 0.385)
rect(cv "Metal1" 1.56 0.285 1.64 0.415)
rect(cv "Metal2" 1.535 0.31 1.665 0.39)
rect(cv "Metal2" 1.17 0.31 1.64 0.39)
rect(cv "Via2" 1.175 0.315 1.245 0.385)
rect(cv "Metal2" 1.145 0.31 1.275 0.39)
rect(cv "Metal3" 1.17 0.285 1.25 0.415)
rect(cv "Metal1" 1.765 0.47 1.845 0.99)
rect(cv "Via1" 1.77 0.475 1.84 0.545)
rect(cv "Metal1" 1.765 0.445 1.845 0.575)
rect(cv "Metal2" 1.74 0.47 1.87 0.55)
rect(cv "Metal2" 0.53 0.47 1.845 0.55)
rect(cv "Via2" 0.535 0.475 0.605 0.545)
rect(cv "Metal2" 0.505 0.47 0.635 0.55)
rect(cv "Metal3" 0.53 0.445 0.61 0.575)
rect(cv "Poly" 1.68 1.18 1.725 1.46)
rect(cv "Poly" 1.63 1.26 1.77 1.46)
rect(cv "Cont" 1.67 1.33 1.73 1.39)
rect(cv "Metal1" 1.63 1.285 1.77 1.435)
rect(cv "Metal1" 1.63 1.29 1.77 1.43)
rect(cv "Via1" 1.665 1.325 1.735 1.395)
rect(cv "Metal1" 1.63 1.285 1.77 1.435)
rect(cv "Metal2" 1.635 1.32 1.765 1.4)
rect(cv "Metal2" 0.21 1.32 1.74 1.4)
rect(cv "Via2" 0.215 1.325 0.285 1.395)
rect(cv "Metal2" 0.185 1.32 0.315 1.4)
rect(cv "Metal3" 0.21 1.295 0.29 1.425)
dev(cv "PM0" "pmos1v" 2.03 2.14 360 45)
rect(cv "Metal1" 1.91 2.28 1.99 2.79)
rect(cv "Via1" 1.915 2.715 1.985 2.785)
rect(cv "Metal1" 1.91 2.685 1.99 2.815)
rect(cv "Metal2" 1.885 2.71 2.015 2.79)
rect(cv "Metal2" 0.85 2.71 1.99 2.79)
rect(cv "Via2" 0.855 2.715 0.925 2.785)
rect(cv "Metal2" 0.825 2.71 0.955 2.79)
rect(cv "Metal3" 0.85 2.685 0.93 2.815)
rect(cv "Metal1" 2.115 2.28 2.195 2.95)
rect(cv "Via1" 2.12 2.875 2.19 2.945)
rect(cv "Metal1" 2.115 2.845 2.195 2.975)
rect(cv "Metal2" 2.09 2.87 2.22 2.95)
rect(cv "Metal2" 0.53 2.87 2.195 2.95)
rect(cv "Via2" 0.535 2.875 0.605 2.945)
rect(cv "Metal2" 0.505 2.87 0.635 2.95)
rect(cv "Metal3" 0.53 2.845 0.61 2.975)
rect(cv "Poly" 2.03 1.81 2.075 2.09)
rect(cv "Poly" 1.98 1.81 2.12 2.01)
rect(cv "Cont" 2.02 1.88 2.08 1.94)
rect(cv "Metal1" 1.98 1.835 2.12 1.985)
rect(cv "Metal1" 1.98 1.77 2.12 1.98)
rect(cv "Via1" 2.015 1.805 2.085 1.875)
rect(cv "Metal1" 1.98 1.765 2.12 1.915)
rect(cv "Metal2" 1.985 1.8 2.115 1.88)
rect(cv "Metal2" 0.21 1.8 2.09 1.88)
rect(cv "Via2" 0.215 1.805 0.285 1.875)
rect(cv "Metal2" 0.185 1.8 0.315 1.88)
rect(cv "Metal3" 0.21 1.775 0.29 1.905)
rect(cv "Nwell" 1.43 1.94 3.15 2.7)
rect(cv "Oxide" 2.83 2.21 3.03 2.41)
rect(cv "Nimp" 2.77 2.15 3.09 2.47)
rect(cv "Cont" 2.9 2.28 2.96 2.34)
rect(cv "Metal1" 2.89 2.245 2.97 2.375)
rect(cv "Metal1" 2.89 2.27 2.97 3.35)
rect(cv "Via1" 2.895 3.275 2.965 3.345)
rect(cv "Metal1" 2.89 3.245 2.97 3.375)
rect(cv "Metal2" 2.865 3.27 2.995 3.35)
rect(cv "Metal2" 0.85 3.27 2.97 3.35)
rect(cv "Via2" 0.855 3.275 0.925 3.345)
rect(cv "Metal2" 0.825 3.27 0.955 3.35)
rect(cv "Metal3" 0.85 3.245 0.93 3.375)
rect(cv "Oxide" 2.83 0.84 3.03 1.04)
rect(cv "Pimp" 2.77 0.78 3.09 1.1)
rect(cv "Cont" 2.9 0.91 2.96 0.97)
rect(cv "Metal1" 2.89 0.875 2.97 1.005)
rect(cv "Metal1" 2.89 0.08 2.97 0.98)
rect(cv "Via1" 2.895 0.085 2.965 0.155)
rect(cv "Metal1" 2.89 0.055 2.97 0.185)
rect(cv "Metal2" 2.865 0.08 2.995 0.16)
rect(cv "Metal2" 1.17 0.08 2.97 0.16)
rect(cv "Via2" 1.175 0.085 1.245 0.155)
rect(cv "Metal2" 1.145 0.08 1.275 0.16)
rect(cv "Metal3" 1.17 0.055 1.25 0.185)
port(cv "IN" "Metal3" 0.25 3.53)
port(cv "OUT" "Metal3" 0.57 3.53)
port(cv "VDD" "Metal3" 0.89 3.53)
port(cv "GND" "Metal3" 1.21 3.53)
rect(cv "prBoundary" 0.0 0.0 3.23 3.61)
dbSave(cv) printf("LAYOUT inv %L\n" cv~>bBox) dbClose(cv)
cv=dbOpenCellViewByType("sram_project" "nand3" "layout" "maskLayout" "w")
rect(cv "Metal3" 0.18 0.03 0.32 6.24)
rect(cv "Metal3" 0.5 0.03 0.64 6.24)
rect(cv "Metal3" 0.82 0.03 0.96 6.24)
rect(cv "Metal3" 1.14 0.03 1.28 6.24)
rect(cv "Metal3" 1.46 0.03 1.6 6.24)
rect(cv "Metal3" 1.78 0.03 1.92 6.24)
rect(cv "Metal3" 2.1 0.03 2.24 6.24)
rect(cv "Metal3" 2.42 0.03 2.56 6.24)
dev(cv "NM0" "nmos1v" 2.96 1.41 1080 45)
rect(cv "Metal1" 2.84 0.31 2.92 1.99)
rect(cv "Via1" 2.845 0.315 2.915 0.385)
rect(cv "Metal1" 2.84 0.285 2.92 0.415)
rect(cv "Metal2" 2.815 0.31 2.945 0.39)
rect(cv "Metal2" 2.13 0.31 2.92 0.39)
rect(cv "Via2" 2.135 0.315 2.205 0.385)
rect(cv "Metal2" 2.105 0.31 2.235 0.39)
rect(cv "Metal3" 2.13 0.285 2.21 0.415)
rect(cv "Metal1" 3.045 0.47 3.125 1.99)
rect(cv "Via1" 3.05 0.475 3.12 0.545)
rect(cv "Metal1" 3.045 0.445 3.125 0.575)
rect(cv "Metal2" 3.02 0.47 3.15 0.55)
rect(cv "Metal2" 1.17 0.47 3.125 0.55)
rect(cv "Via2" 1.175 0.475 1.245 0.545)
rect(cv "Metal2" 1.145 0.47 1.275 0.55)
rect(cv "Metal3" 1.17 0.445 1.25 0.575)
rect(cv "Poly" 2.96 2.54 3.005 2.82)
rect(cv "Poly" 2.91 2.62 3.05 2.82)
rect(cv "Cont" 2.95 2.69 3.01 2.75)
rect(cv "Metal1" 2.91 2.645 3.05 2.795)
rect(cv "Metal1" 2.91 2.65 3.05 2.79)
rect(cv "Via1" 2.945 2.685 3.015 2.755)
rect(cv "Metal1" 2.91 2.645 3.05 2.795)
rect(cv "Metal2" 2.915 2.68 3.045 2.76)
rect(cv "Metal2" 0.21 2.68 3.02 2.76)
rect(cv "Via2" 0.215 2.685 0.285 2.755)
rect(cv "Metal2" 0.185 2.68 0.315 2.76)
rect(cv "Metal3" 0.21 2.655 0.29 2.785)
dev(cv "NM1" "nmos1v" 3.66 1.41 1080 45)
rect(cv "Metal1" 3.54 0.63 3.62 1.99)
rect(cv "Via1" 3.545 0.635 3.615 0.705)
rect(cv "Metal1" 3.54 0.605 3.62 0.735)
rect(cv "Metal2" 3.515 0.63 3.645 0.71)
rect(cv "Metal2" 2.45 0.63 3.62 0.71)
rect(cv "Via2" 2.455 0.635 2.525 0.705)
rect(cv "Metal2" 2.425 0.63 2.555 0.71)
rect(cv "Metal3" 2.45 0.605 2.53 0.735)
rect(cv "Metal1" 3.745 0.79 3.825 1.99)
rect(cv "Via1" 3.75 0.795 3.82 0.865)
rect(cv "Metal1" 3.745 0.765 3.825 0.895)
rect(cv "Metal2" 3.72 0.79 3.85 0.87)
rect(cv "Metal2" 2.13 0.79 3.825 0.87)
rect(cv "Via2" 2.135 0.795 2.205 0.865)
rect(cv "Metal2" 2.105 0.79 2.235 0.87)
rect(cv "Metal3" 2.13 0.765 2.21 0.895)
rect(cv "Poly" 3.66 2.54 3.705 2.82)
rect(cv "Poly" 3.61 2.62 3.75 2.82)
rect(cv "Cont" 3.65 2.69 3.71 2.75)
rect(cv "Metal1" 3.61 2.645 3.75 2.795)
rect(cv "Metal1" 3.61 2.65 3.75 2.95)
rect(cv "Via1" 3.645 2.845 3.715 2.915)
rect(cv "Metal1" 3.61 2.805 3.75 2.955)
rect(cv "Metal2" 3.615 2.84 3.745 2.92)
rect(cv "Metal2" 0.53 2.84 3.72 2.92)
rect(cv "Via2" 0.535 2.845 0.605 2.915)
rect(cv "Metal2" 0.505 2.84 0.635 2.92)
rect(cv "Metal3" 0.53 2.815 0.61 2.945)
dev(cv "NM2" "nmos1v" 4.36 1.41 1080 45)
rect(cv "Metal1" 4.24 0.95 4.32 1.99)
rect(cv "Via1" 4.245 0.955 4.315 1.025)
rect(cv "Metal1" 4.24 0.925 4.32 1.055)
rect(cv "Metal2" 4.215 0.95 4.345 1.03)
rect(cv "Metal2" 1.81 0.95 4.32 1.03)
rect(cv "Via2" 1.815 0.955 1.885 1.025)
rect(cv "Metal2" 1.785 0.95 1.915 1.03)
rect(cv "Metal3" 1.81 0.925 1.89 1.055)
rect(cv "Metal1" 4.445 1.11 4.525 1.99)
rect(cv "Via1" 4.45 1.115 4.52 1.185)
rect(cv "Metal1" 4.445 1.085 4.525 1.215)
rect(cv "Metal2" 4.42 1.11 4.55 1.19)
rect(cv "Metal2" 2.45 1.11 4.525 1.19)
rect(cv "Via2" 2.455 1.115 2.525 1.185)
rect(cv "Metal2" 2.425 1.11 2.555 1.19)
rect(cv "Metal3" 2.45 1.085 2.53 1.215)
rect(cv "Poly" 4.36 2.54 4.405 2.82)
rect(cv "Poly" 4.31 2.62 4.45 2.82)
rect(cv "Cont" 4.35 2.69 4.41 2.75)
rect(cv "Metal1" 4.31 2.645 4.45 2.795)
rect(cv "Metal1" 4.31 2.65 4.45 3.11)
rect(cv "Via1" 4.345 3.005 4.415 3.075)
rect(cv "Metal1" 4.31 2.965 4.45 3.115)
rect(cv "Metal2" 4.315 3 4.445 3.08)
rect(cv "Metal2" 0.85 3 4.42 3.08)
rect(cv "Via2" 0.855 3.005 0.925 3.075)
rect(cv "Metal2" 0.825 3 0.955 3.08)
rect(cv "Metal3" 0.85 2.975 0.93 3.105)
dev(cv "PM0" "pmos1v" 3.31 4.14 360 45)
rect(cv "Metal1" 3.19 4.28 3.27 4.79)
rect(cv "Via1" 3.195 4.715 3.265 4.785)
rect(cv "Metal1" 3.19 4.685 3.27 4.815)
rect(cv "Metal2" 3.165 4.71 3.295 4.79)
rect(cv "Metal2" 1.49 4.71 3.27 4.79)
rect(cv "Via2" 1.495 4.715 1.565 4.785)
rect(cv "Metal2" 1.465 4.71 1.595 4.79)
rect(cv "Metal3" 1.49 4.685 1.57 4.815)
rect(cv "Metal1" 3.395 4.28 3.475 4.95)
rect(cv "Via1" 3.4 4.875 3.47 4.945)
rect(cv "Metal1" 3.395 4.845 3.475 4.975)
rect(cv "Metal2" 3.37 4.87 3.5 4.95)
rect(cv "Metal2" 1.17 4.87 3.475 4.95)
rect(cv "Via2" 1.175 4.875 1.245 4.945)
rect(cv "Metal2" 1.145 4.87 1.275 4.95)
rect(cv "Metal3" 1.17 4.845 1.25 4.975)
rect(cv "Poly" 3.31 3.81 3.355 4.09)
rect(cv "Poly" 3.26 3.81 3.4 4.01)
rect(cv "Cont" 3.3 3.88 3.36 3.94)
rect(cv "Metal1" 3.26 3.835 3.4 3.985)
rect(cv "Metal1" 3.26 3.45 3.4 3.98)
rect(cv "Via1" 3.295 3.485 3.365 3.555)
rect(cv "Metal1" 3.26 3.445 3.4 3.595)
rect(cv "Metal2" 3.265 3.48 3.395 3.56)
rect(cv "Metal2" 0.21 3.48 3.37 3.56)
rect(cv "Via2" 0.215 3.485 0.285 3.555)
rect(cv "Metal2" 0.185 3.48 0.315 3.56)
rect(cv "Metal3" 0.21 3.455 0.29 3.585)
dev(cv "PM1" "pmos1v" 4.01 4.14 360 45)
rect(cv "Metal1" 3.89 4.28 3.97 5.11)
rect(cv "Via1" 3.895 5.035 3.965 5.105)
rect(cv "Metal1" 3.89 5.005 3.97 5.135)
rect(cv "Metal2" 3.865 5.03 3.995 5.11)
rect(cv "Metal2" 1.49 5.03 3.97 5.11)
rect(cv "Via2" 1.495 5.035 1.565 5.105)
rect(cv "Metal2" 1.465 5.03 1.595 5.11)
rect(cv "Metal3" 1.49 5.005 1.57 5.135)
rect(cv "Metal1" 4.095 4.28 4.175 5.27)
rect(cv "Via1" 4.1 5.195 4.17 5.265)
rect(cv "Metal1" 4.095 5.165 4.175 5.295)
rect(cv "Metal2" 4.07 5.19 4.2 5.27)
rect(cv "Metal2" 1.17 5.19 4.175 5.27)
rect(cv "Via2" 1.175 5.195 1.245 5.265)
rect(cv "Metal2" 1.145 5.19 1.275 5.27)
rect(cv "Metal3" 1.17 5.165 1.25 5.295)
rect(cv "Poly" 4.01 3.81 4.055 4.09)
rect(cv "Poly" 3.96 3.81 4.1 4.01)
rect(cv "Cont" 4 3.88 4.06 3.94)
rect(cv "Metal1" 3.96 3.835 4.1 3.985)
rect(cv "Metal1" 3.96 3.61 4.1 3.98)
rect(cv "Via1" 3.995 3.645 4.065 3.715)
rect(cv "Metal1" 3.96 3.605 4.1 3.755)
rect(cv "Metal2" 3.965 3.64 4.095 3.72)
rect(cv "Metal2" 0.53 3.64 4.07 3.72)
rect(cv "Via2" 0.535 3.645 0.605 3.715)
rect(cv "Metal2" 0.505 3.64 0.635 3.72)
rect(cv "Metal3" 0.53 3.615 0.61 3.745)
dev(cv "PM2" "pmos1v" 4.71 4.14 360 45)
rect(cv "Metal1" 4.59 4.28 4.67 5.43)
rect(cv "Via1" 4.595 5.355 4.665 5.425)
rect(cv "Metal1" 4.59 5.325 4.67 5.455)
rect(cv "Metal2" 4.565 5.35 4.695 5.43)
rect(cv "Metal2" 1.49 5.35 4.67 5.43)
rect(cv "Via2" 1.495 5.355 1.565 5.425)
rect(cv "Metal2" 1.465 5.35 1.595 5.43)
rect(cv "Metal3" 1.49 5.325 1.57 5.455)
rect(cv "Metal1" 4.795 4.28 4.875 5.59)
rect(cv "Via1" 4.8 5.515 4.87 5.585)
rect(cv "Metal1" 4.795 5.485 4.875 5.615)
rect(cv "Metal2" 4.77 5.51 4.9 5.59)
rect(cv "Metal2" 1.17 5.51 4.875 5.59)
rect(cv "Via2" 1.175 5.515 1.245 5.585)
rect(cv "Metal2" 1.145 5.51 1.275 5.59)
rect(cv "Metal3" 1.17 5.485 1.25 5.615)
rect(cv "Poly" 4.71 3.81 4.755 4.09)
rect(cv "Poly" 4.66 3.81 4.8 4.01)
rect(cv "Cont" 4.7 3.88 4.76 3.94)
rect(cv "Metal1" 4.66 3.835 4.8 3.985)
rect(cv "Metal1" 4.66 3.77 4.8 3.98)
rect(cv "Via1" 4.695 3.805 4.765 3.875)
rect(cv "Metal1" 4.66 3.765 4.8 3.915)
rect(cv "Metal2" 4.665 3.8 4.795 3.88)
rect(cv "Metal2" 0.85 3.8 4.77 3.88)
rect(cv "Via2" 0.855 3.805 0.925 3.875)
rect(cv "Metal2" 0.825 3.8 0.955 3.88)
rect(cv "Metal3" 0.85 3.775 0.93 3.905)
rect(cv "Nwell" 2.71 3.94 5.83 4.7)
rect(cv "Oxide" 5.51 4.21 5.71 4.41)
rect(cv "Nimp" 5.45 4.15 5.77 4.47)
rect(cv "Cont" 5.58 4.28 5.64 4.34)
rect(cv "Metal1" 5.57 4.245 5.65 4.375)
rect(cv "Metal1" 5.57 4.27 5.65 5.99)
rect(cv "Via1" 5.575 5.915 5.645 5.985)
rect(cv "Metal1" 5.57 5.885 5.65 6.015)
rect(cv "Metal2" 5.545 5.91 5.675 5.99)
rect(cv "Metal2" 1.49 5.91 5.65 5.99)
rect(cv "Via2" 1.495 5.915 1.565 5.985)
rect(cv "Metal2" 1.465 5.91 1.595 5.99)
rect(cv "Metal3" 1.49 5.885 1.57 6.015)
rect(cv "Oxide" 5.51 1.48 5.71 1.68)
rect(cv "Pimp" 5.45 1.42 5.77 1.74)
rect(cv "Cont" 5.58 1.55 5.64 1.61)
rect(cv "Metal1" 5.57 1.515 5.65 1.645)
rect(cv "Metal1" 5.57 0.08 5.65 1.62)
rect(cv "Via1" 5.575 0.085 5.645 0.155)
rect(cv "Metal1" 5.57 0.055 5.65 0.185)
rect(cv "Metal2" 5.545 0.08 5.675 0.16)
rect(cv "Metal2" 1.81 0.08 5.65 0.16)
rect(cv "Via2" 1.815 0.085 1.885 0.155)
rect(cv "Metal2" 1.785 0.08 1.915 0.16)
rect(cv "Metal3" 1.81 0.055 1.89 0.185)
port(cv "A" "Metal3" 0.25 6.17)
port(cv "B" "Metal3" 0.57 6.17)
port(cv "E" "Metal3" 0.89 6.17)
port(cv "Y" "Metal3" 1.21 6.17)
port(cv "VDD" "Metal3" 1.53 6.17)
port(cv "GND" "Metal3" 1.85 6.17)
rect(cv "prBoundary" 0.0 0.0 5.91 6.25)
dbSave(cv) printf("LAYOUT nand3 %L\n" cv~>bBox) dbClose(cv)
cv=dbOpenCellViewByType("sram_project" "nand2" "layout" "maskLayout" "w")
rect(cv "Metal3" 0.18 0.03 0.32 4.92)
rect(cv "Metal3" 0.5 0.03 0.64 4.92)
rect(cv "Metal3" 0.82 0.03 0.96 4.92)
rect(cv "Metal3" 1.14 0.03 1.28 4.92)
rect(cv "Metal3" 1.46 0.03 1.6 4.92)
rect(cv "Metal3" 1.78 0.03 1.92 4.92)
dev(cv "N0" "nmos1v" 2.32 1.09 720 45)
rect(cv "Metal1" 2.2 0.31 2.28 1.49)
rect(cv "Via1" 2.205 0.315 2.275 0.385)
rect(cv "Metal1" 2.2 0.285 2.28 0.415)
rect(cv "Metal2" 2.175 0.31 2.305 0.39)
rect(cv "Metal2" 1.81 0.31 2.28 0.39)
rect(cv "Via2" 1.815 0.315 1.885 0.385)
rect(cv "Metal2" 1.785 0.31 1.915 0.39)
rect(cv "Metal3" 1.81 0.285 1.89 0.415)
rect(cv "Metal1" 2.405 0.47 2.485 1.49)
rect(cv "Via1" 2.41 0.475 2.48 0.545)
rect(cv "Metal1" 2.405 0.445 2.485 0.575)
rect(cv "Metal2" 2.38 0.47 2.51 0.55)
rect(cv "Metal2" 0.85 0.47 2.485 0.55)
rect(cv "Via2" 0.855 0.475 0.925 0.545)
rect(cv "Metal2" 0.825 0.47 0.955 0.55)
rect(cv "Metal3" 0.85 0.445 0.93 0.575)
rect(cv "Poly" 2.32 1.86 2.365 2.14)
rect(cv "Poly" 2.27 1.94 2.41 2.14)
rect(cv "Cont" 2.31 2.01 2.37 2.07)
rect(cv "Metal1" 2.27 1.965 2.41 2.115)
rect(cv "Metal1" 2.27 1.97 2.41 2.11)
rect(cv "Via1" 2.305 2.005 2.375 2.075)
rect(cv "Metal1" 2.27 1.965 2.41 2.115)
rect(cv "Metal2" 2.275 2 2.405 2.08)
rect(cv "Metal2" 0.21 2 2.38 2.08)
rect(cv "Via2" 0.215 2.005 0.285 2.075)
rect(cv "Metal2" 0.185 2 0.315 2.08)
rect(cv "Metal3" 0.21 1.975 0.29 2.105)
dev(cv "N1" "nmos1v" 3.02 1.09 720 45)
rect(cv "Metal1" 2.9 0.63 2.98 1.49)
rect(cv "Via1" 2.905 0.635 2.975 0.705)
rect(cv "Metal1" 2.9 0.605 2.98 0.735)
rect(cv "Metal2" 2.875 0.63 3.005 0.71)
rect(cv "Metal2" 1.49 0.63 2.98 0.71)
rect(cv "Via2" 1.495 0.635 1.565 0.705)
rect(cv "Metal2" 1.465 0.63 1.595 0.71)
rect(cv "Metal3" 1.49 0.605 1.57 0.735)
rect(cv "Metal1" 3.105 0.79 3.185 1.49)
rect(cv "Via1" 3.11 0.795 3.18 0.865)
rect(cv "Metal1" 3.105 0.765 3.185 0.895)
rect(cv "Metal2" 3.08 0.79 3.21 0.87)
rect(cv "Metal2" 1.81 0.79 3.185 0.87)
rect(cv "Via2" 1.815 0.795 1.885 0.865)
rect(cv "Metal2" 1.785 0.79 1.915 0.87)
rect(cv "Metal3" 1.81 0.765 1.89 0.895)
rect(cv "Poly" 3.02 1.86 3.065 2.14)
rect(cv "Poly" 2.97 1.94 3.11 2.14)
rect(cv "Cont" 3.01 2.01 3.07 2.07)
rect(cv "Metal1" 2.97 1.965 3.11 2.115)
rect(cv "Metal1" 2.97 1.97 3.11 2.27)
rect(cv "Via1" 3.005 2.165 3.075 2.235)
rect(cv "Metal1" 2.97 2.125 3.11 2.275)
rect(cv "Metal2" 2.975 2.16 3.105 2.24)
rect(cv "Metal2" 0.53 2.16 3.08 2.24)
rect(cv "Via2" 0.535 2.165 0.605 2.235)
rect(cv "Metal2" 0.505 2.16 0.635 2.24)
rect(cv "Metal3" 0.53 2.135 0.61 2.265)
dev(cv "P0" "pmos1v" 2.67 3.14 360 45)
rect(cv "Metal1" 2.55 3.28 2.63 3.79)
rect(cv "Via1" 2.555 3.715 2.625 3.785)
rect(cv "Metal1" 2.55 3.685 2.63 3.815)
rect(cv "Metal2" 2.525 3.71 2.655 3.79)
rect(cv "Metal2" 1.17 3.71 2.63 3.79)
rect(cv "Via2" 1.175 3.715 1.245 3.785)
rect(cv "Metal2" 1.145 3.71 1.275 3.79)
rect(cv "Metal3" 1.17 3.685 1.25 3.815)
rect(cv "Metal1" 2.755 3.28 2.835 3.95)
rect(cv "Via1" 2.76 3.875 2.83 3.945)
rect(cv "Metal1" 2.755 3.845 2.835 3.975)
rect(cv "Metal2" 2.73 3.87 2.86 3.95)
rect(cv "Metal2" 0.85 3.87 2.835 3.95)
rect(cv "Via2" 0.855 3.875 0.925 3.945)
rect(cv "Metal2" 0.825 3.87 0.955 3.95)
rect(cv "Metal3" 0.85 3.845 0.93 3.975)
rect(cv "Poly" 2.67 2.81 2.715 3.09)
rect(cv "Poly" 2.62 2.81 2.76 3.01)
rect(cv "Cont" 2.66 2.88 2.72 2.94)
rect(cv "Metal1" 2.62 2.835 2.76 2.985)
rect(cv "Metal1" 2.62 2.61 2.76 2.98)
rect(cv "Via1" 2.655 2.645 2.725 2.715)
rect(cv "Metal1" 2.62 2.605 2.76 2.755)
rect(cv "Metal2" 2.625 2.64 2.755 2.72)
rect(cv "Metal2" 0.21 2.64 2.73 2.72)
rect(cv "Via2" 0.215 2.645 0.285 2.715)
rect(cv "Metal2" 0.185 2.64 0.315 2.72)
rect(cv "Metal3" 0.21 2.615 0.29 2.745)
dev(cv "P1" "pmos1v" 3.37 3.14 360 45)
rect(cv "Metal1" 3.25 3.28 3.33 4.11)
rect(cv "Via1" 3.255 4.035 3.325 4.105)
rect(cv "Metal1" 3.25 4.005 3.33 4.135)
rect(cv "Metal2" 3.225 4.03 3.355 4.11)
rect(cv "Metal2" 1.17 4.03 3.33 4.11)
rect(cv "Via2" 1.175 4.035 1.245 4.105)
rect(cv "Metal2" 1.145 4.03 1.275 4.11)
rect(cv "Metal3" 1.17 4.005 1.25 4.135)
rect(cv "Metal1" 3.455 3.28 3.535 4.27)
rect(cv "Via1" 3.46 4.195 3.53 4.265)
rect(cv "Metal1" 3.455 4.165 3.535 4.295)
rect(cv "Metal2" 3.43 4.19 3.56 4.27)
rect(cv "Metal2" 0.85 4.19 3.535 4.27)
rect(cv "Via2" 0.855 4.195 0.925 4.265)
rect(cv "Metal2" 0.825 4.19 0.955 4.27)
rect(cv "Metal3" 0.85 4.165 0.93 4.295)
rect(cv "Poly" 3.37 2.81 3.415 3.09)
rect(cv "Poly" 3.32 2.81 3.46 3.01)
rect(cv "Cont" 3.36 2.88 3.42 2.94)
rect(cv "Metal1" 3.32 2.835 3.46 2.985)
rect(cv "Metal1" 3.32 2.77 3.46 2.98)
rect(cv "Via1" 3.355 2.805 3.425 2.875)
rect(cv "Metal1" 3.32 2.765 3.46 2.915)
rect(cv "Metal2" 3.325 2.8 3.455 2.88)
rect(cv "Metal2" 0.53 2.8 3.43 2.88)
rect(cv "Via2" 0.535 2.805 0.605 2.875)
rect(cv "Metal2" 0.505 2.8 0.635 2.88)
rect(cv "Metal3" 0.53 2.775 0.61 2.905)
rect(cv "Nwell" 2.07 2.94 4.49 3.7)
rect(cv "Oxide" 4.17 3.21 4.37 3.41)
rect(cv "Nimp" 4.11 3.15 4.43 3.47)
rect(cv "Cont" 4.24 3.28 4.3 3.34)
rect(cv "Metal1" 4.23 3.245 4.31 3.375)
rect(cv "Metal1" 4.23 3.27 4.31 4.67)
rect(cv "Via1" 4.235 4.595 4.305 4.665)
rect(cv "Metal1" 4.23 4.565 4.31 4.695)
rect(cv "Metal2" 4.205 4.59 4.335 4.67)
rect(cv "Metal2" 1.17 4.59 4.31 4.67)
rect(cv "Via2" 1.175 4.595 1.245 4.665)
rect(cv "Metal2" 1.145 4.59 1.275 4.67)
rect(cv "Metal3" 1.17 4.565 1.25 4.695)
rect(cv "Oxide" 4.17 1.16 4.37 1.36)
rect(cv "Pimp" 4.11 1.1 4.43 1.42)
rect(cv "Cont" 4.24 1.23 4.3 1.29)
rect(cv "Metal1" 4.23 1.195 4.31 1.325)
rect(cv "Metal1" 4.23 0.08 4.31 1.3)
rect(cv "Via1" 4.235 0.085 4.305 0.155)
rect(cv "Metal1" 4.23 0.055 4.31 0.185)
rect(cv "Metal2" 4.205 0.08 4.335 0.16)
rect(cv "Metal2" 1.49 0.08 4.31 0.16)
rect(cv "Via2" 1.495 0.085 1.565 0.155)
rect(cv "Metal2" 1.465 0.08 1.595 0.16)
rect(cv "Metal3" 1.49 0.055 1.57 0.185)
port(cv "A" "Metal3" 0.25 4.85)
port(cv "B" "Metal3" 0.57 4.85)
port(cv "Y" "Metal3" 0.89 4.85)
port(cv "VDD" "Metal3" 1.21 4.85)
port(cv "GND" "Metal3" 1.53 4.85)
rect(cv "prBoundary" 0.0 0.0 4.57 4.93)
dbSave(cv) printf("LAYOUT nand2 %L\n" cv~>bBox) dbClose(cv)
cv=dbOpenCellViewByType("sram_project" "and3" "layout" "maskLayout" "w")
rect(cv "Metal3" 0.18 0.03 0.32 7.2)
rect(cv "Metal3" 0.5 0.03 0.64 7.2)
rect(cv "Metal3" 0.82 0.03 0.96 7.2)
rect(cv "Metal3" 1.14 0.03 1.28 7.2)
rect(cv "Metal3" 1.46 0.03 1.6 7.2)
rect(cv "Metal3" 1.78 0.03 1.92 7.2)
rect(cv "Metal3" 2.1 0.03 2.24 7.2)
rect(cv "Metal3" 2.42 0.03 2.56 7.2)
rect(cv "Metal3" 2.74 0.03 2.88 7.2)
dev(cv "NAND_NM0" "nmos1v" 3.28 1.73 1080 45)
rect(cv "Metal1" 3.16 0.31 3.24 2.31)
rect(cv "Via1" 3.165 0.315 3.235 0.385)
rect(cv "Metal1" 3.16 0.285 3.24 0.415)
rect(cv "Metal2" 3.135 0.31 3.265 0.39)
rect(cv "Metal2" 2.45 0.31 3.24 0.39)
rect(cv "Via2" 2.455 0.315 2.525 0.385)
rect(cv "Metal2" 2.425 0.31 2.555 0.39)
rect(cv "Metal3" 2.45 0.285 2.53 0.415)
rect(cv "Metal1" 3.365 0.47 3.445 2.31)
rect(cv "Via1" 3.37 0.475 3.44 0.545)
rect(cv "Metal1" 3.365 0.445 3.445 0.575)
rect(cv "Metal2" 3.34 0.47 3.47 0.55)
rect(cv "Metal2" 2.13 0.47 3.445 0.55)
rect(cv "Via2" 2.135 0.475 2.205 0.545)
rect(cv "Metal2" 2.105 0.47 2.235 0.55)
rect(cv "Metal3" 2.13 0.445 2.21 0.575)
rect(cv "Poly" 3.28 2.86 3.325 3.14)
rect(cv "Poly" 3.23 2.94 3.37 3.14)
rect(cv "Cont" 3.27 3.01 3.33 3.07)
rect(cv "Metal1" 3.23 2.965 3.37 3.115)
rect(cv "Metal1" 3.23 2.97 3.37 3.11)
rect(cv "Via1" 3.265 3.005 3.335 3.075)
rect(cv "Metal1" 3.23 2.965 3.37 3.115)
rect(cv "Metal2" 3.235 3 3.365 3.08)
rect(cv "Metal2" 0.21 3 3.34 3.08)
rect(cv "Via2" 0.215 3.005 0.285 3.075)
rect(cv "Metal2" 0.185 3 0.315 3.08)
rect(cv "Metal3" 0.21 2.975 0.29 3.105)
dev(cv "NAND_NM1" "nmos1v" 3.98 1.73 1080 45)
rect(cv "Metal1" 3.86 0.63 3.94 2.31)
rect(cv "Via1" 3.865 0.635 3.935 0.705)
rect(cv "Metal1" 3.86 0.605 3.94 0.735)
rect(cv "Metal2" 3.835 0.63 3.965 0.71)
rect(cv "Metal2" 2.77 0.63 3.94 0.71)
rect(cv "Via2" 2.775 0.635 2.845 0.705)
rect(cv "Metal2" 2.745 0.63 2.875 0.71)
rect(cv "Metal3" 2.77 0.605 2.85 0.735)
rect(cv "Metal1" 4.065 0.79 4.145 2.31)
rect(cv "Via1" 4.07 0.795 4.14 0.865)
rect(cv "Metal1" 4.065 0.765 4.145 0.895)
rect(cv "Metal2" 4.04 0.79 4.17 0.87)
rect(cv "Metal2" 2.45 0.79 4.145 0.87)
rect(cv "Via2" 2.455 0.795 2.525 0.865)
rect(cv "Metal2" 2.425 0.79 2.555 0.87)
rect(cv "Metal3" 2.45 0.765 2.53 0.895)
rect(cv "Poly" 3.98 2.86 4.025 3.14)
rect(cv "Poly" 3.93 2.94 4.07 3.14)
rect(cv "Cont" 3.97 3.01 4.03 3.07)
rect(cv "Metal1" 3.93 2.965 4.07 3.115)
rect(cv "Metal1" 3.93 2.97 4.07 3.27)
rect(cv "Via1" 3.965 3.165 4.035 3.235)
rect(cv "Metal1" 3.93 3.125 4.07 3.275)
rect(cv "Metal2" 3.935 3.16 4.065 3.24)
rect(cv "Metal2" 0.53 3.16 4.04 3.24)
rect(cv "Via2" 0.535 3.165 0.605 3.235)
rect(cv "Metal2" 0.505 3.16 0.635 3.24)
rect(cv "Metal3" 0.53 3.135 0.61 3.265)
dev(cv "NAND_NM2" "nmos1v" 4.68 1.73 1080 45)
rect(cv "Metal1" 4.56 0.95 4.64 2.31)
rect(cv "Via1" 4.565 0.955 4.635 1.025)
rect(cv "Metal1" 4.56 0.925 4.64 1.055)
rect(cv "Metal2" 4.535 0.95 4.665 1.03)
rect(cv "Metal2" 1.81 0.95 4.64 1.03)
rect(cv "Via2" 1.815 0.955 1.885 1.025)
rect(cv "Metal2" 1.785 0.95 1.915 1.03)
rect(cv "Metal3" 1.81 0.925 1.89 1.055)
rect(cv "Metal1" 4.765 1.11 4.845 2.31)
rect(cv "Via1" 4.77 1.115 4.84 1.185)
rect(cv "Metal1" 4.765 1.085 4.845 1.215)
rect(cv "Metal2" 4.74 1.11 4.87 1.19)
rect(cv "Metal2" 2.77 1.11 4.845 1.19)
rect(cv "Via2" 2.775 1.115 2.845 1.185)
rect(cv "Metal2" 2.745 1.11 2.875 1.19)
rect(cv "Metal3" 2.77 1.085 2.85 1.215)
rect(cv "Poly" 4.68 2.86 4.725 3.14)
rect(cv "Poly" 4.63 2.94 4.77 3.14)
rect(cv "Cont" 4.67 3.01 4.73 3.07)
rect(cv "Metal1" 4.63 2.965 4.77 3.115)
rect(cv "Metal1" 4.63 2.97 4.77 3.43)
rect(cv "Via1" 4.665 3.325 4.735 3.395)
rect(cv "Metal1" 4.63 3.285 4.77 3.435)
rect(cv "Metal2" 4.635 3.32 4.765 3.4)
rect(cv "Metal2" 0.85 3.32 4.74 3.4)
rect(cv "Via2" 0.855 3.325 0.925 3.395)
rect(cv "Metal2" 0.825 3.32 0.955 3.4)
rect(cv "Metal3" 0.85 3.295 0.93 3.425)
dev(cv "BUF_NM0" "nmos1v" 5.38 1.73 360 45)
rect(cv "Metal1" 5.26 1.27 5.34 1.95)
rect(cv "Via1" 5.265 1.275 5.335 1.345)
rect(cv "Metal1" 5.26 1.245 5.34 1.375)
rect(cv "Metal2" 5.235 1.27 5.365 1.35)
rect(cv "Metal2" 1.81 1.27 5.34 1.35)
rect(cv "Via2" 1.815 1.275 1.885 1.345)
rect(cv "Metal2" 1.785 1.27 1.915 1.35)
rect(cv "Metal3" 1.81 1.245 1.89 1.375)
rect(cv "Metal1" 5.465 1.43 5.545 1.95)
rect(cv "Via1" 5.47 1.435 5.54 1.505)
rect(cv "Metal1" 5.465 1.405 5.545 1.535)
rect(cv "Metal2" 5.44 1.43 5.57 1.51)
rect(cv "Metal2" 1.17 1.43 5.545 1.51)
rect(cv "Via2" 1.175 1.435 1.245 1.505)
rect(cv "Metal2" 1.145 1.43 1.275 1.51)
rect(cv "Metal3" 1.17 1.405 1.25 1.535)
rect(cv "Poly" 5.38 2.14 5.425 3.14)
rect(cv "Poly" 5.33 2.94 5.47 3.14)
rect(cv "Cont" 5.37 3.01 5.43 3.07)
rect(cv "Metal1" 5.33 2.965 5.47 3.115)
rect(cv "Metal1" 5.33 2.97 5.47 3.59)
rect(cv "Via1" 5.365 3.485 5.435 3.555)
rect(cv "Metal1" 5.33 3.445 5.47 3.595)
rect(cv "Metal2" 5.335 3.48 5.465 3.56)
rect(cv "Metal2" 2.13 3.48 5.44 3.56)
rect(cv "Via2" 2.135 3.485 2.205 3.555)
rect(cv "Metal2" 2.105 3.48 2.235 3.56)
rect(cv "Metal3" 2.13 3.455 2.21 3.585)
dev(cv "NAND_PM0" "pmos1v" 3.63 4.78 360 45)
rect(cv "Metal1" 3.51 4.92 3.59 5.43)
rect(cv "Via1" 3.515 5.355 3.585 5.425)
rect(cv "Metal1" 3.51 5.325 3.59 5.455)
rect(cv "Metal2" 3.485 5.35 3.615 5.43)
rect(cv "Metal2" 1.49 5.35 3.59 5.43)
rect(cv "Via2" 1.495 5.355 1.565 5.425)
rect(cv "Metal2" 1.465 5.35 1.595 5.43)
rect(cv "Metal3" 1.49 5.325 1.57 5.455)
rect(cv "Metal1" 3.715 4.92 3.795 5.59)
rect(cv "Via1" 3.72 5.515 3.79 5.585)
rect(cv "Metal1" 3.715 5.485 3.795 5.615)
rect(cv "Metal2" 3.69 5.51 3.82 5.59)
rect(cv "Metal2" 2.13 5.51 3.795 5.59)
rect(cv "Via2" 2.135 5.515 2.205 5.585)
rect(cv "Metal2" 2.105 5.51 2.235 5.59)
rect(cv "Metal3" 2.13 5.485 2.21 5.615)
rect(cv "Poly" 3.63 4.45 3.675 4.73)
rect(cv "Poly" 3.58 4.45 3.72 4.65)
rect(cv "Cont" 3.62 4.52 3.68 4.58)
rect(cv "Metal1" 3.58 4.475 3.72 4.625)
rect(cv "Metal1" 3.58 3.93 3.72 4.62)
rect(cv "Via1" 3.615 3.965 3.685 4.035)
rect(cv "Metal1" 3.58 3.925 3.72 4.075)
rect(cv "Metal2" 3.585 3.96 3.715 4.04)
rect(cv "Metal2" 0.21 3.96 3.69 4.04)
rect(cv "Via2" 0.215 3.965 0.285 4.035)
rect(cv "Metal2" 0.185 3.96 0.315 4.04)
rect(cv "Metal3" 0.21 3.935 0.29 4.065)
dev(cv "NAND_PM1" "pmos1v" 4.33 4.78 360 45)
rect(cv "Metal1" 4.21 4.92 4.29 5.75)
rect(cv "Via1" 4.215 5.675 4.285 5.745)
rect(cv "Metal1" 4.21 5.645 4.29 5.775)
rect(cv "Metal2" 4.185 5.67 4.315 5.75)
rect(cv "Metal2" 1.49 5.67 4.29 5.75)
rect(cv "Via2" 1.495 5.675 1.565 5.745)
rect(cv "Metal2" 1.465 5.67 1.595 5.75)
rect(cv "Metal3" 1.49 5.645 1.57 5.775)
rect(cv "Metal1" 4.415 4.92 4.495 5.91)
rect(cv "Via1" 4.42 5.835 4.49 5.905)
rect(cv "Metal1" 4.415 5.805 4.495 5.935)
rect(cv "Metal2" 4.39 5.83 4.52 5.91)
rect(cv "Metal2" 2.13 5.83 4.495 5.91)
rect(cv "Via2" 2.135 5.835 2.205 5.905)
rect(cv "Metal2" 2.105 5.83 2.235 5.91)
rect(cv "Metal3" 2.13 5.805 2.21 5.935)
rect(cv "Poly" 4.33 4.45 4.375 4.73)
rect(cv "Poly" 4.28 4.45 4.42 4.65)
rect(cv "Cont" 4.32 4.52 4.38 4.58)
rect(cv "Metal1" 4.28 4.475 4.42 4.625)
rect(cv "Metal1" 4.28 4.09 4.42 4.62)
rect(cv "Via1" 4.315 4.125 4.385 4.195)
rect(cv "Metal1" 4.28 4.085 4.42 4.235)
rect(cv "Metal2" 4.285 4.12 4.415 4.2)
rect(cv "Metal2" 0.53 4.12 4.39 4.2)
rect(cv "Via2" 0.535 4.125 0.605 4.195)
rect(cv "Metal2" 0.505 4.12 0.635 4.2)
rect(cv "Metal3" 0.53 4.095 0.61 4.225)
dev(cv "NAND_PM2" "pmos1v" 5.03 4.78 360 45)
rect(cv "Metal1" 4.91 4.92 4.99 6.07)
rect(cv "Via1" 4.915 5.995 4.985 6.065)
rect(cv "Metal1" 4.91 5.965 4.99 6.095)
rect(cv "Metal2" 4.885 5.99 5.015 6.07)
rect(cv "Metal2" 1.49 5.99 4.99 6.07)
rect(cv "Via2" 1.495 5.995 1.565 6.065)
rect(cv "Metal2" 1.465 5.99 1.595 6.07)
rect(cv "Metal3" 1.49 5.965 1.57 6.095)
rect(cv "Metal1" 5.115 4.92 5.195 6.23)
rect(cv "Via1" 5.12 6.155 5.19 6.225)
rect(cv "Metal1" 5.115 6.125 5.195 6.255)
rect(cv "Metal2" 5.09 6.15 5.22 6.23)
rect(cv "Metal2" 2.13 6.15 5.195 6.23)
rect(cv "Via2" 2.135 6.155 2.205 6.225)
rect(cv "Metal2" 2.105 6.15 2.235 6.23)
rect(cv "Metal3" 2.13 6.125 2.21 6.255)
rect(cv "Poly" 5.03 4.45 5.075 4.73)
rect(cv "Poly" 4.98 4.45 5.12 4.65)
rect(cv "Cont" 5.02 4.52 5.08 4.58)
rect(cv "Metal1" 4.98 4.475 5.12 4.625)
rect(cv "Metal1" 4.98 4.25 5.12 4.62)
rect(cv "Via1" 5.015 4.285 5.085 4.355)
rect(cv "Metal1" 4.98 4.245 5.12 4.395)
rect(cv "Metal2" 4.985 4.28 5.115 4.36)
rect(cv "Metal2" 0.85 4.28 5.09 4.36)
rect(cv "Via2" 0.855 4.285 0.925 4.355)
rect(cv "Metal2" 0.825 4.28 0.955 4.36)
rect(cv "Metal3" 0.85 4.255 0.93 4.385)
dev(cv "BUF_PM0" "pmos1v" 5.73 4.78 360 45)
rect(cv "Metal1" 5.61 4.92 5.69 6.39)
rect(cv "Via1" 5.615 6.315 5.685 6.385)
rect(cv "Metal1" 5.61 6.285 5.69 6.415)
rect(cv "Metal2" 5.585 6.31 5.715 6.39)
rect(cv "Metal2" 1.49 6.31 5.69 6.39)
rect(cv "Via2" 1.495 6.315 1.565 6.385)
rect(cv "Metal2" 1.465 6.31 1.595 6.39)
rect(cv "Metal3" 1.49 6.285 1.57 6.415)
rect(cv "Metal1" 5.815 4.92 5.895 6.55)
rect(cv "Via1" 5.82 6.475 5.89 6.545)
rect(cv "Metal1" 5.815 6.445 5.895 6.575)
rect(cv "Metal2" 5.79 6.47 5.92 6.55)
rect(cv "Metal2" 1.17 6.47 5.895 6.55)
rect(cv "Via2" 1.175 6.475 1.245 6.545)
rect(cv "Metal2" 1.145 6.47 1.275 6.55)
rect(cv "Metal3" 1.17 6.445 1.25 6.575)
rect(cv "Poly" 5.73 4.45 5.775 4.73)
rect(cv "Poly" 5.68 4.45 5.82 4.65)
rect(cv "Cont" 5.72 4.52 5.78 4.58)
rect(cv "Metal1" 5.68 4.475 5.82 4.625)
rect(cv "Metal1" 5.68 4.41 5.82 4.62)
rect(cv "Via1" 5.715 4.445 5.785 4.515)
rect(cv "Metal1" 5.68 4.405 5.82 4.555)
rect(cv "Metal2" 5.685 4.44 5.815 4.52)
rect(cv "Metal2" 2.13 4.44 5.79 4.52)
rect(cv "Via2" 2.135 4.445 2.205 4.515)
rect(cv "Metal2" 2.105 4.44 2.235 4.52)
rect(cv "Metal3" 2.13 4.415 2.21 4.545)
rect(cv "Nwell" 3.03 4.58 6.85 5.34)
rect(cv "Oxide" 6.53 4.85 6.73 5.05)
rect(cv "Nimp" 6.47 4.79 6.79 5.11)
rect(cv "Cont" 6.6 4.92 6.66 4.98)
rect(cv "Metal1" 6.59 4.885 6.67 5.015)
rect(cv "Metal1" 6.59 4.91 6.67 6.95)
rect(cv "Via1" 6.595 6.875 6.665 6.945)
rect(cv "Metal1" 6.59 6.845 6.67 6.975)
rect(cv "Metal2" 6.565 6.87 6.695 6.95)
rect(cv "Metal2" 1.49 6.87 6.67 6.95)
rect(cv "Via2" 1.495 6.875 1.565 6.945)
rect(cv "Metal2" 1.465 6.87 1.595 6.95)
rect(cv "Metal3" 1.49 6.845 1.57 6.975)
rect(cv "Oxide" 6.53 1.8 6.73 2)
rect(cv "Pimp" 6.47 1.74 6.79 2.06)
rect(cv "Cont" 6.6 1.87 6.66 1.93)
rect(cv "Metal1" 6.59 1.835 6.67 1.965)
rect(cv "Metal1" 6.59 0.08 6.67 1.94)
rect(cv "Via1" 6.595 0.085 6.665 0.155)
rect(cv "Metal1" 6.59 0.055 6.67 0.185)
rect(cv "Metal2" 6.565 0.08 6.695 0.16)
rect(cv "Metal2" 1.81 0.08 6.67 0.16)
rect(cv "Via2" 1.815 0.085 1.885 0.155)
rect(cv "Metal2" 1.785 0.08 1.915 0.16)
rect(cv "Metal3" 1.81 0.055 1.89 0.185)
port(cv "A" "Metal3" 0.25 7.13)
port(cv "B" "Metal3" 0.57 7.13)
port(cv "E" "Metal3" 0.89 7.13)
port(cv "Y" "Metal3" 1.21 7.13)
port(cv "VDD" "Metal3" 1.53 7.13)
port(cv "GND" "Metal3" 1.85 7.13)
rect(cv "prBoundary" 0.0 0.0 6.93 7.21)
dbSave(cv) printf("LAYOUT and3 %L\n" cv~>bBox) dbClose(cv)
cv=dbOpenCellViewByType("sram_project" "tg" "layout" "maskLayout" "w")
rect(cv "Metal3" 0.18 0.03 0.32 5.04)
rect(cv "Metal3" 0.5 0.03 0.64 5.04)
rect(cv "Metal3" 0.82 0.03 0.96 5.04)
rect(cv "Metal3" 1.14 0.03 1.28 5.04)
rect(cv "Metal3" 1.46 0.03 1.6 5.04)
rect(cv "Metal3" 1.78 0.03 1.92 5.04)
dev(cv "N" "nmos1v" 2.32 0.77 1080 45)
rect(cv "Metal1" 2.2 0.31 2.28 1.35)
rect(cv "Via1" 2.205 0.315 2.275 0.385)
rect(cv "Metal1" 2.2 0.285 2.28 0.415)
rect(cv "Metal2" 2.175 0.31 2.305 0.39)
rect(cv "Metal2" 0.21 0.31 2.28 0.39)
rect(cv "Via2" 0.215 0.315 0.285 0.385)
rect(cv "Metal2" 0.185 0.31 0.315 0.39)
rect(cv "Metal3" 0.21 0.285 0.29 0.415)
rect(cv "Metal1" 2.405 0.47 2.485 1.35)
rect(cv "Via1" 2.41 0.475 2.48 0.545)
rect(cv "Metal1" 2.405 0.445 2.485 0.575)
rect(cv "Metal2" 2.38 0.47 2.51 0.55)
rect(cv "Metal2" 0.53 0.47 2.485 0.55)
rect(cv "Via2" 0.535 0.475 0.605 0.545)
rect(cv "Metal2" 0.505 0.47 0.635 0.55)
rect(cv "Metal3" 0.53 0.445 0.61 0.575)
rect(cv "Poly" 2.32 1.9 2.365 2.18)
rect(cv "Poly" 2.27 1.98 2.41 2.18)
rect(cv "Cont" 2.31 2.05 2.37 2.11)
rect(cv "Metal1" 2.27 2.005 2.41 2.155)
rect(cv "Metal1" 2.27 2.01 2.41 2.15)
rect(cv "Via1" 2.305 2.045 2.375 2.115)
rect(cv "Metal1" 2.27 2.005 2.41 2.155)
rect(cv "Metal2" 2.275 2.04 2.405 2.12)
rect(cv "Metal2" 0.85 2.04 2.38 2.12)
rect(cv "Via2" 0.855 2.045 0.925 2.115)
rect(cv "Metal2" 0.825 2.04 0.955 2.12)
rect(cv "Metal3" 0.85 2.015 0.93 2.145)
dev(cv "P" "pmos1v" 2.67 2.86 1080 45)
rect(cv "Metal1" 2.55 3.36 2.63 4.23)
rect(cv "Via1" 2.555 4.155 2.625 4.225)
rect(cv "Metal1" 2.55 4.125 2.63 4.255)
rect(cv "Metal2" 2.525 4.15 2.655 4.23)
rect(cv "Metal2" 0.21 4.15 2.63 4.23)
rect(cv "Via2" 0.215 4.155 0.285 4.225)
rect(cv "Metal2" 0.185 4.15 0.315 4.23)
rect(cv "Metal3" 0.21 4.125 0.29 4.255)
rect(cv "Metal1" 2.755 3.36 2.835 4.39)
rect(cv "Via1" 2.76 4.315 2.83 4.385)
rect(cv "Metal1" 2.755 4.285 2.835 4.415)
rect(cv "Metal2" 2.73 4.31 2.86 4.39)
rect(cv "Metal2" 0.53 4.31 2.835 4.39)
rect(cv "Via2" 0.535 4.315 0.605 4.385)
rect(cv "Metal2" 0.505 4.31 0.635 4.39)
rect(cv "Metal3" 0.53 4.285 0.61 4.415)
rect(cv "Poly" 2.67 2.53 2.715 2.81)
rect(cv "Poly" 2.62 2.53 2.76 2.73)
rect(cv "Cont" 2.66 2.6 2.72 2.66)
rect(cv "Metal1" 2.62 2.555 2.76 2.705)
rect(cv "Metal1" 2.62 2.49 2.76 2.7)
rect(cv "Via1" 2.655 2.525 2.725 2.595)
rect(cv "Metal1" 2.62 2.485 2.76 2.635)
rect(cv "Metal2" 2.625 2.52 2.755 2.6)
rect(cv "Metal2" 1.17 2.52 2.73 2.6)
rect(cv "Via2" 1.175 2.525 1.245 2.595)
rect(cv "Metal2" 1.145 2.52 1.275 2.6)
rect(cv "Metal3" 1.17 2.495 1.25 2.625)
rect(cv "Nwell" 2.07 2.66 3.79 4.14)
rect(cv "Oxide" 3.47 2.93 3.67 3.13)
rect(cv "Nimp" 3.41 2.87 3.73 3.19)
rect(cv "Cont" 3.54 3 3.6 3.06)
rect(cv "Metal1" 3.53 2.965 3.61 3.095)
rect(cv "Metal1" 3.53 2.99 3.61 4.79)
rect(cv "Via1" 3.535 4.715 3.605 4.785)
rect(cv "Metal1" 3.53 4.685 3.61 4.815)
rect(cv "Metal2" 3.505 4.71 3.635 4.79)
rect(cv "Metal2" 1.49 4.71 3.61 4.79)
rect(cv "Via2" 1.495 4.715 1.565 4.785)
rect(cv "Metal2" 1.465 4.71 1.595 4.79)
rect(cv "Metal3" 1.49 4.685 1.57 4.815)
rect(cv "Oxide" 3.47 0.84 3.67 1.04)
rect(cv "Pimp" 3.41 0.78 3.73 1.1)
rect(cv "Cont" 3.54 0.91 3.6 0.97)
rect(cv "Metal1" 3.53 0.875 3.61 1.005)
rect(cv "Metal1" 3.53 0.08 3.61 0.98)
rect(cv "Via1" 3.535 0.085 3.605 0.155)
rect(cv "Metal1" 3.53 0.055 3.61 0.185)
rect(cv "Metal2" 3.505 0.08 3.635 0.16)
rect(cv "Metal2" 1.81 0.08 3.61 0.16)
rect(cv "Via2" 1.815 0.085 1.885 0.155)
rect(cv "Metal2" 1.785 0.08 1.915 0.16)
rect(cv "Metal3" 1.81 0.055 1.89 0.185)
port(cv "A" "Metal3" 0.25 4.97)
port(cv "B" "Metal3" 0.57 4.97)
port(cv "EN" "Metal3" 0.89 4.97)
port(cv "ENB" "Metal3" 1.21 4.97)
port(cv "VDD" "Metal3" 1.53 4.97)
port(cv "GND" "Metal3" 1.85 4.97)
rect(cv "prBoundary" 0.0 0.0 3.87 5.05)
dbSave(cv) printf("LAYOUT tg %L\n" cv~>bBox) dbClose(cv)
cv=dbOpenCellViewByType("sram_project" "precharge_unit" "layout" "maskLayout" "w")
rect(cv "Metal3" 0.18 0.03 0.32 4.44)
rect(cv "Metal3" 0.5 0.03 0.64 4.44)
rect(cv "Metal3" 0.82 0.03 0.96 4.44)
rect(cv "Metal3" 1.14 0.03 1.28 4.44)
rect(cv "Metal3" 1.46 0.03 1.6 4.44)
dev(cv "P0" "pmos1v" 2.35 1.62 1080 45)
rect(cv "Metal1" 2.23 2.12 2.31 2.99)
rect(cv "Via1" 2.235 2.915 2.305 2.985)
rect(cv "Metal1" 2.23 2.885 2.31 3.015)
rect(cv "Metal2" 2.205 2.91 2.335 2.99)
rect(cv "Metal2" 1.17 2.91 2.31 2.99)
rect(cv "Via2" 1.175 2.915 1.245 2.985)
rect(cv "Metal2" 1.145 2.91 1.275 2.99)
rect(cv "Metal3" 1.17 2.885 1.25 3.015)
rect(cv "Metal1" 2.435 2.12 2.515 3.15)
rect(cv "Via1" 2.44 3.075 2.51 3.145)
rect(cv "Metal1" 2.435 3.045 2.515 3.175)
rect(cv "Metal2" 2.41 3.07 2.54 3.15)
rect(cv "Metal2" 0.21 3.07 2.515 3.15)
rect(cv "Via2" 0.215 3.075 0.285 3.145)
rect(cv "Metal2" 0.185 3.07 0.315 3.15)
rect(cv "Metal3" 0.21 3.045 0.29 3.175)
rect(cv "Poly" 2.35 1.29 2.395 1.57)
rect(cv "Poly" 2.3 1.29 2.44 1.49)
rect(cv "Cont" 2.34 1.36 2.4 1.42)
rect(cv "Metal1" 2.3 1.315 2.44 1.465)
rect(cv "Metal1" 2.3 0.93 2.44 1.46)
rect(cv "Via1" 2.335 0.965 2.405 1.035)
rect(cv "Metal1" 2.3 0.925 2.44 1.075)
rect(cv "Metal2" 2.305 0.96 2.435 1.04)
rect(cv "Metal2" 0.85 0.96 2.41 1.04)
rect(cv "Via2" 0.855 0.965 0.925 1.035)
rect(cv "Metal2" 0.825 0.96 0.955 1.04)
rect(cv "Metal3" 0.85 0.935 0.93 1.065)
dev(cv "P1" "pmos1v" 3.05 1.62 1080 45)
rect(cv "Metal1" 2.93 2.12 3.01 3.31)
rect(cv "Via1" 2.935 3.235 3.005 3.305)
rect(cv "Metal1" 2.93 3.205 3.01 3.335)
rect(cv "Metal2" 2.905 3.23 3.035 3.31)
rect(cv "Metal2" 1.17 3.23 3.01 3.31)
rect(cv "Via2" 1.175 3.235 1.245 3.305)
rect(cv "Metal2" 1.145 3.23 1.275 3.31)
rect(cv "Metal3" 1.17 3.205 1.25 3.335)
rect(cv "Metal1" 3.135 2.12 3.215 3.47)
rect(cv "Via1" 3.14 3.395 3.21 3.465)
rect(cv "Metal1" 3.135 3.365 3.215 3.495)
rect(cv "Metal2" 3.11 3.39 3.24 3.47)
rect(cv "Metal2" 0.53 3.39 3.215 3.47)
rect(cv "Via2" 0.535 3.395 0.605 3.465)
rect(cv "Metal2" 0.505 3.39 0.635 3.47)
rect(cv "Metal3" 0.53 3.365 0.61 3.495)
rect(cv "Poly" 3.05 1.29 3.095 1.57)
rect(cv "Poly" 3 1.29 3.14 1.49)
rect(cv "Cont" 3.04 1.36 3.1 1.42)
rect(cv "Metal1" 3 1.315 3.14 1.465)
rect(cv "Metal1" 3 1.09 3.14 1.46)
rect(cv "Via1" 3.035 1.125 3.105 1.195)
rect(cv "Metal1" 3 1.085 3.14 1.235)
rect(cv "Metal2" 3.005 1.12 3.135 1.2)
rect(cv "Metal2" 0.85 1.12 3.11 1.2)
rect(cv "Via2" 0.855 1.125 0.925 1.195)
rect(cv "Metal2" 0.825 1.12 0.955 1.2)
rect(cv "Metal3" 0.85 1.095 0.93 1.225)
dev(cv "PEQ" "pmos1v" 3.75 1.62 1080 45)
rect(cv "Metal1" 3.63 2.12 3.71 3.63)
rect(cv "Via1" 3.635 3.555 3.705 3.625)
rect(cv "Metal1" 3.63 3.525 3.71 3.655)
rect(cv "Metal2" 3.605 3.55 3.735 3.63)
rect(cv "Metal2" 0.53 3.55 3.71 3.63)
rect(cv "Via2" 0.535 3.555 0.605 3.625)
rect(cv "Metal2" 0.505 3.55 0.635 3.63)
rect(cv "Metal3" 0.53 3.525 0.61 3.655)
rect(cv "Metal1" 3.835 2.12 3.915 3.79)
rect(cv "Via1" 3.84 3.715 3.91 3.785)
rect(cv "Metal1" 3.835 3.685 3.915 3.815)
rect(cv "Metal2" 3.81 3.71 3.94 3.79)
rect(cv "Metal2" 0.21 3.71 3.915 3.79)
rect(cv "Via2" 0.215 3.715 0.285 3.785)
rect(cv "Metal2" 0.185 3.71 0.315 3.79)
rect(cv "Metal3" 0.21 3.685 0.29 3.815)
rect(cv "Poly" 3.75 1.29 3.795 1.57)
rect(cv "Poly" 3.7 1.29 3.84 1.49)
rect(cv "Cont" 3.74 1.36 3.8 1.42)
rect(cv "Metal1" 3.7 1.315 3.84 1.465)
rect(cv "Metal1" 3.7 1.25 3.84 1.46)
rect(cv "Via1" 3.735 1.285 3.805 1.355)
rect(cv "Metal1" 3.7 1.245 3.84 1.395)
rect(cv "Metal2" 3.705 1.28 3.835 1.36)
rect(cv "Metal2" 0.85 1.28 3.81 1.36)
rect(cv "Via2" 0.855 1.285 0.925 1.355)
rect(cv "Metal2" 0.825 1.28 0.955 1.36)
rect(cv "Metal3" 0.85 1.255 0.93 1.385)
rect(cv "Nwell" 1.75 1.42 4.87 2.9)
rect(cv "Oxide" 4.55 1.69 4.75 1.89)
rect(cv "Nimp" 4.49 1.63 4.81 1.95)
rect(cv "Cont" 4.62 1.76 4.68 1.82)
rect(cv "Metal1" 4.61 1.725 4.69 1.855)
rect(cv "Metal1" 4.61 1.75 4.69 4.19)
rect(cv "Via1" 4.615 4.115 4.685 4.185)
rect(cv "Metal1" 4.61 4.085 4.69 4.215)
rect(cv "Metal2" 4.585 4.11 4.715 4.19)
rect(cv "Metal2" 1.17 4.11 4.69 4.19)
rect(cv "Via2" 1.175 4.115 1.245 4.185)
rect(cv "Metal2" 1.145 4.11 1.275 4.19)
rect(cv "Metal3" 1.17 4.085 1.25 4.215)
rect(cv "Oxide" 4.55 0.52 4.75 0.72)
rect(cv "Pimp" 4.49 0.46 4.81 0.78)
rect(cv "Cont" 4.62 0.59 4.68 0.65)
rect(cv "Metal1" 4.61 0.555 4.69 0.685)
rect(cv "Metal1" 4.61 0.08 4.69 0.66)
rect(cv "Via1" 4.615 0.085 4.685 0.155)
rect(cv "Metal1" 4.61 0.055 4.69 0.185)
rect(cv "Metal2" 4.585 0.08 4.715 0.16)
rect(cv "Metal2" 1.49 0.08 4.69 0.16)
rect(cv "Via2" 1.495 0.085 1.565 0.155)
rect(cv "Metal2" 1.465 0.08 1.595 0.16)
rect(cv "Metal3" 1.49 0.055 1.57 0.185)
port(cv "BL" "Metal3" 0.25 4.37)
port(cv "BLB" "Metal3" 0.57 4.37)
port(cv "PCB" "Metal3" 0.89 4.37)
port(cv "VDD" "Metal3" 1.21 4.37)
port(cv "GND" "Metal3" 1.53 4.37)
rect(cv "prBoundary" 0.0 0.0 4.95 4.45)
dbSave(cv) printf("LAYOUT precharge_unit %L\n" cv~>bBox) dbClose(cv)
cv=dbOpenCellViewByType("sram_project" "sense_amp" "layout" "maskLayout" "w")
rect(cv "Metal3" 0.18 0.03 0.32 7.08)
rect(cv "Metal3" 0.5 0.03 0.64 7.08)
rect(cv "Metal3" 0.82 0.03 0.96 7.08)
rect(cv "Metal3" 1.14 0.03 1.28 7.08)
rect(cv "Metal3" 1.46 0.03 1.6 7.08)
rect(cv "Metal3" 1.78 0.03 1.92 7.08)
rect(cv "Metal3" 2.1 0.03 2.24 7.08)
rect(cv "Metal3" 2.42 0.03 2.56 7.08)
rect(cv "Metal3" 2.74 0.03 2.88 7.08)
dev(cv "NM41" "nmos1v" 3.28 1.73 240 45)
rect(cv "Metal1" 3.16 0.31 3.24 1.89)
rect(cv "Via1" 3.165 0.315 3.235 0.385)
rect(cv "Metal1" 3.16 0.285 3.24 0.415)
rect(cv "Metal2" 3.135 0.31 3.265 0.39)
rect(cv "Metal2" 2.77 0.31 3.24 0.39)
rect(cv "Via2" 2.775 0.315 2.845 0.385)
rect(cv "Metal2" 2.745 0.31 2.875 0.39)
rect(cv "Metal3" 2.77 0.285 2.85 0.415)
rect(cv "Metal1" 3.365 0.47 3.445 1.89)
rect(cv "Via1" 3.37 0.475 3.44 0.545)
rect(cv "Metal1" 3.365 0.445 3.445 0.575)
rect(cv "Metal2" 3.34 0.47 3.47 0.55)
rect(cv "Metal2" 2.45 0.47 3.445 0.55)
rect(cv "Via2" 2.455 0.475 2.525 0.545)
rect(cv "Metal2" 2.425 0.47 2.555 0.55)
rect(cv "Metal3" 2.45 0.445 2.53 0.575)
rect(cv "Poly" 3.28 2.02 3.325 2.42)
rect(cv "Poly" 3.23 2.22 3.37 2.42)
rect(cv "Cont" 3.27 2.29 3.33 2.35)
rect(cv "Metal1" 3.23 2.245 3.37 2.395)
rect(cv "Metal1" 3.23 2.25 3.37 2.39)
rect(cv "Via1" 3.265 2.285 3.335 2.355)
rect(cv "Metal1" 3.23 2.245 3.37 2.395)
rect(cv "Metal2" 3.235 2.28 3.365 2.36)
rect(cv "Metal2" 0.21 2.28 3.34 2.36)
rect(cv "Via2" 0.215 2.285 0.285 2.355)
rect(cv "Metal2" 0.185 2.28 0.315 2.36)
rect(cv "Metal3" 0.21 2.255 0.29 2.385)
dev(cv "NM40" "nmos1v" 3.98 1.73 240 45)
rect(cv "Metal1" 3.86 0.63 3.94 1.89)
rect(cv "Via1" 3.865 0.635 3.935 0.705)
rect(cv "Metal1" 3.86 0.605 3.94 0.735)
rect(cv "Metal2" 3.835 0.63 3.965 0.71)
rect(cv "Metal2" 2.77 0.63 3.94 0.71)
rect(cv "Via2" 2.775 0.635 2.845 0.705)
rect(cv "Metal2" 2.745 0.63 2.875 0.71)
rect(cv "Metal3" 2.77 0.605 2.85 0.735)
rect(cv "Metal1" 4.065 0.79 4.145 1.89)
rect(cv "Via1" 4.07 0.795 4.14 0.865)
rect(cv "Metal1" 4.065 0.765 4.145 0.895)
rect(cv "Metal2" 4.04 0.79 4.17 0.87)
rect(cv "Metal2" 2.13 0.79 4.145 0.87)
rect(cv "Via2" 2.135 0.795 2.205 0.865)
rect(cv "Metal2" 2.105 0.79 2.235 0.87)
rect(cv "Metal3" 2.13 0.765 2.21 0.895)
rect(cv "Poly" 3.98 2.02 4.025 2.42)
rect(cv "Poly" 3.93 2.22 4.07 2.42)
rect(cv "Cont" 3.97 2.29 4.03 2.35)
rect(cv "Metal1" 3.93 2.245 4.07 2.395)
rect(cv "Metal1" 3.93 2.25 4.07 2.55)
rect(cv "Via1" 3.965 2.445 4.035 2.515)
rect(cv "Metal1" 3.93 2.405 4.07 2.555)
rect(cv "Metal2" 3.935 2.44 4.065 2.52)
rect(cv "Metal2" 0.53 2.44 4.04 2.52)
rect(cv "Via2" 0.535 2.445 0.605 2.515)
rect(cv "Metal2" 0.505 2.44 0.635 2.52)
rect(cv "Metal3" 0.53 2.415 0.61 2.545)
dev(cv "NM39" "nmos1v" 4.68 1.73 360 45)
rect(cv "Metal1" 4.56 0.95 4.64 1.95)
rect(cv "Via1" 4.565 0.955 4.635 1.025)
rect(cv "Metal1" 4.56 0.925 4.64 1.055)
rect(cv "Metal2" 4.535 0.95 4.665 1.03)
rect(cv "Metal2" 1.49 0.95 4.64 1.03)
rect(cv "Via2" 1.495 0.955 1.565 1.025)
rect(cv "Metal2" 1.465 0.95 1.595 1.03)
rect(cv "Metal3" 1.49 0.925 1.57 1.055)
rect(cv "Metal1" 4.765 1.11 4.845 1.95)
rect(cv "Via1" 4.77 1.115 4.84 1.185)
rect(cv "Metal1" 4.765 1.085 4.845 1.215)
rect(cv "Metal2" 4.74 1.11 4.87 1.19)
rect(cv "Metal2" 1.81 1.11 4.845 1.19)
rect(cv "Via2" 1.815 1.115 1.885 1.185)
rect(cv "Metal2" 1.785 1.11 1.915 1.19)
rect(cv "Metal3" 1.81 1.085 1.89 1.215)
rect(cv "Poly" 4.68 2.14 4.725 2.42)
rect(cv "Poly" 4.63 2.22 4.77 2.42)
rect(cv "Cont" 4.67 2.29 4.73 2.35)
rect(cv "Metal1" 4.63 2.245 4.77 2.395)
rect(cv "Metal1" 4.63 2.25 4.77 2.71)
rect(cv "Via1" 4.665 2.605 4.735 2.675)
rect(cv "Metal1" 4.63 2.565 4.77 2.715)
rect(cv "Metal2" 4.635 2.6 4.765 2.68)
rect(cv "Metal2" 2.45 2.6 4.74 2.68)
rect(cv "Via2" 2.455 2.605 2.525 2.675)
rect(cv "Metal2" 2.425 2.6 2.555 2.68)
rect(cv "Metal3" 2.45 2.575 2.53 2.705)
dev(cv "NM38" "nmos1v" 5.38 1.73 360 45)
rect(cv "Metal1" 5.26 1.27 5.34 1.95)
rect(cv "Via1" 5.265 1.275 5.335 1.345)
rect(cv "Metal1" 5.26 1.245 5.34 1.375)
rect(cv "Metal2" 5.235 1.27 5.365 1.35)
rect(cv "Metal2" 1.49 1.27 5.34 1.35)
rect(cv "Via2" 1.495 1.275 1.565 1.345)
rect(cv "Metal2" 1.465 1.27 1.595 1.35)
rect(cv "Metal3" 1.49 1.245 1.57 1.375)
rect(cv "Metal1" 5.465 1.43 5.545 1.95)
rect(cv "Via1" 5.47 1.435 5.54 1.505)
rect(cv "Metal1" 5.465 1.405 5.545 1.535)
rect(cv "Metal2" 5.44 1.43 5.57 1.51)
rect(cv "Metal2" 2.77 1.43 5.545 1.51)
rect(cv "Via2" 2.775 1.435 2.845 1.505)
rect(cv "Metal2" 2.745 1.43 2.875 1.51)
rect(cv "Metal3" 2.77 1.405 2.85 1.535)
rect(cv "Poly" 5.38 2.14 5.425 2.42)
rect(cv "Poly" 5.33 2.22 5.47 2.42)
rect(cv "Cont" 5.37 2.29 5.43 2.35)
rect(cv "Metal1" 5.33 2.245 5.47 2.395)
rect(cv "Metal1" 5.33 2.25 5.47 2.87)
rect(cv "Via1" 5.365 2.765 5.435 2.835)
rect(cv "Metal1" 5.33 2.725 5.47 2.875)
rect(cv "Metal2" 5.335 2.76 5.465 2.84)
rect(cv "Metal2" 0.85 2.76 5.44 2.84)
rect(cv "Via2" 0.855 2.765 0.925 2.835)
rect(cv "Metal2" 0.825 2.76 0.955 2.84)
rect(cv "Metal3" 0.85 2.735 0.93 2.865)
dev(cv "PM6" "pmos1v" 3.63 3.9 1440 45)
rect(cv "Metal1" 3.51 4.58 3.59 5.63)
rect(cv "Via1" 3.515 5.555 3.585 5.625)
rect(cv "Metal1" 3.51 5.525 3.59 5.655)
rect(cv "Metal2" 3.485 5.55 3.615 5.63)
rect(cv "Metal2" 1.17 5.55 3.59 5.63)
rect(cv "Via2" 1.175 5.555 1.245 5.625)
rect(cv "Metal2" 1.145 5.55 1.275 5.63)
rect(cv "Metal3" 1.17 5.525 1.25 5.655)
rect(cv "Metal1" 3.715 4.58 3.795 5.79)
rect(cv "Via1" 3.72 5.715 3.79 5.785)
rect(cv "Metal1" 3.715 5.685 3.795 5.815)
rect(cv "Metal2" 3.69 5.71 3.82 5.79)
rect(cv "Metal2" 2.13 5.71 3.795 5.79)
rect(cv "Via2" 2.135 5.715 2.205 5.785)
rect(cv "Metal2" 2.105 5.71 2.235 5.79)
rect(cv "Metal3" 2.13 5.685 2.21 5.815)
rect(cv "Poly" 3.63 3.57 3.675 3.85)
rect(cv "Poly" 3.58 3.57 3.72 3.77)
rect(cv "Cont" 3.62 3.64 3.68 3.7)
rect(cv "Metal1" 3.58 3.595 3.72 3.745)
rect(cv "Metal1" 3.58 3.21 3.72 3.74)
rect(cv "Via1" 3.615 3.245 3.685 3.315)
rect(cv "Metal1" 3.58 3.205 3.72 3.355)
rect(cv "Metal2" 3.585 3.24 3.715 3.32)
rect(cv "Metal2" 2.13 3.24 3.69 3.32)
rect(cv "Via2" 2.135 3.245 2.205 3.315)
rect(cv "Metal2" 2.105 3.24 2.235 3.32)
rect(cv "Metal3" 2.13 3.215 2.21 3.345)
dev(cv "PM5" "pmos1v" 4.33 3.9 1440 45)
rect(cv "Metal1" 4.21 4.58 4.29 5.95)
rect(cv "Via1" 4.215 5.875 4.285 5.945)
rect(cv "Metal1" 4.21 5.845 4.29 5.975)
rect(cv "Metal2" 4.185 5.87 4.315 5.95)
rect(cv "Metal2" 1.17 5.87 4.29 5.95)
rect(cv "Via2" 1.175 5.875 1.245 5.945)
rect(cv "Metal2" 1.145 5.87 1.275 5.95)
rect(cv "Metal3" 1.17 5.845 1.25 5.975)
rect(cv "Metal1" 4.415 4.58 4.495 6.11)
rect(cv "Via1" 4.42 6.035 4.49 6.105)
rect(cv "Metal1" 4.415 6.005 4.495 6.135)
rect(cv "Metal2" 4.39 6.03 4.52 6.11)
rect(cv "Metal2" 2.45 6.03 4.495 6.11)
rect(cv "Via2" 2.455 6.035 2.525 6.105)
rect(cv "Metal2" 2.425 6.03 2.555 6.11)
rect(cv "Metal3" 2.45 6.005 2.53 6.135)
rect(cv "Poly" 4.33 3.57 4.375 3.85)
rect(cv "Poly" 4.28 3.57 4.42 3.77)
rect(cv "Cont" 4.32 3.64 4.38 3.7)
rect(cv "Metal1" 4.28 3.595 4.42 3.745)
rect(cv "Metal1" 4.28 3.37 4.42 3.74)
rect(cv "Via1" 4.315 3.405 4.385 3.475)
rect(cv "Metal1" 4.28 3.365 4.42 3.515)
rect(cv "Metal2" 4.285 3.4 4.415 3.48)
rect(cv "Metal2" 2.13 3.4 4.39 3.48)
rect(cv "Via2" 2.135 3.405 2.205 3.475)
rect(cv "Metal2" 2.105 3.4 2.235 3.48)
rect(cv "Metal3" 2.13 3.375 2.21 3.505)
dev(cv "PM7" "pmos1v" 5.03 3.9 360 45)
rect(cv "Metal1" 4.91 4.04 4.99 6.27)
rect(cv "Via1" 4.915 6.195 4.985 6.265)
rect(cv "Metal1" 4.91 6.165 4.99 6.295)
rect(cv "Metal2" 4.885 6.19 5.015 6.27)
rect(cv "Metal2" 1.17 6.19 4.99 6.27)
rect(cv "Via2" 1.175 6.195 1.245 6.265)
rect(cv "Metal2" 1.145 6.19 1.275 6.27)
rect(cv "Metal3" 1.17 6.165 1.25 6.295)
rect(cv "Metal1" 5.115 4.04 5.195 6.43)
rect(cv "Via1" 5.12 6.355 5.19 6.425)
rect(cv "Metal1" 5.115 6.325 5.195 6.455)
rect(cv "Metal2" 5.09 6.35 5.22 6.43)
rect(cv "Metal2" 1.81 6.35 5.195 6.43)
rect(cv "Via2" 1.815 6.355 1.885 6.425)
rect(cv "Metal2" 1.785 6.35 1.915 6.43)
rect(cv "Metal3" 1.81 6.325 1.89 6.455)
rect(cv "Poly" 5.03 3.57 5.075 3.85)
rect(cv "Poly" 4.98 3.57 5.12 3.77)
rect(cv "Cont" 5.02 3.64 5.08 3.7)
rect(cv "Metal1" 4.98 3.595 5.12 3.745)
rect(cv "Metal1" 4.98 3.53 5.12 3.74)
rect(cv "Via1" 5.015 3.565 5.085 3.635)
rect(cv "Metal1" 4.98 3.525 5.12 3.675)
rect(cv "Metal2" 4.985 3.56 5.115 3.64)
rect(cv "Metal2" 2.45 3.56 5.09 3.64)
rect(cv "Via2" 2.455 3.565 2.525 3.635)
rect(cv "Metal2" 2.425 3.56 2.555 3.64)
rect(cv "Metal3" 2.45 3.535 2.53 3.665)
rect(cv "Nwell" 3.03 3.7 6.85 5.54)
rect(cv "Oxide" 6.53 3.97 6.73 4.17)
rect(cv "Nimp" 6.47 3.91 6.79 4.23)
rect(cv "Cont" 6.6 4.04 6.66 4.1)
rect(cv "Metal1" 6.59 4.005 6.67 4.135)
rect(cv "Metal1" 6.59 4.03 6.67 6.83)
rect(cv "Via1" 6.595 6.755 6.665 6.825)
rect(cv "Metal1" 6.59 6.725 6.67 6.855)
rect(cv "Metal2" 6.565 6.75 6.695 6.83)
rect(cv "Metal2" 1.17 6.75 6.67 6.83)
rect(cv "Via2" 1.175 6.755 1.245 6.825)
rect(cv "Metal2" 1.145 6.75 1.275 6.83)
rect(cv "Metal3" 1.17 6.725 1.25 6.855)
rect(cv "Oxide" 6.53 1.8 6.73 2)
rect(cv "Pimp" 6.47 1.74 6.79 2.06)
rect(cv "Cont" 6.6 1.87 6.66 1.93)
rect(cv "Metal1" 6.59 1.835 6.67 1.965)
rect(cv "Metal1" 6.59 0.08 6.67 1.94)
rect(cv "Via1" 6.595 0.085 6.665 0.155)
rect(cv "Metal1" 6.59 0.055 6.67 0.185)
rect(cv "Metal2" 6.565 0.08 6.695 0.16)
rect(cv "Metal2" 1.49 0.08 6.67 0.16)
rect(cv "Via2" 1.495 0.085 1.565 0.155)
rect(cv "Metal2" 1.465 0.08 1.595 0.16)
rect(cv "Metal3" 1.49 0.055 1.57 0.185)
port(cv "BIT" "Metal3" 0.25 7.01)
port(cv "BIT_bar" "Metal3" 0.57 7.01)
port(cv "RE" "Metal3" 0.89 7.01)
port(cv "VDD" "Metal3" 1.21 7.01)
port(cv "GND" "Metal3" 1.53 7.01)
port(cv "AMP_OUT" "Metal3" 1.85 7.01)
rect(cv "prBoundary" 0.0 0.0 6.93 7.09)
dbSave(cv) printf("LAYOUT sense_amp %L\n" cv~>bBox) dbClose(cv)
src=dbOpenCellViewByType("sram_cell" "sram_cell" "layout" "" "r")
cv=dbCopyCellView(src "sram_project" "bitcell" "layout" nil nil t)
foreach(te cv~>terminals when(te~>name=="Vdd" te~>name="VDD" dbRenameNet(te~>net "VDD")))
foreach(s cv~>shapes when(s~>objType=="label" && s~>theLabel=="Vdd" s~>theLabel="VDD"))
dbSave(cv) dbClose(cv)
cv=dbOpenCellViewByType("sram_project" "bit_array" "layout" "maskLayout" "w")
dbCreateInst(cv dbOpenCellViewByType("sram_project" "bitcell" "layout" "" "r") "B0_0" list(6.31 0.35) "R0")
dbCreateInst(cv dbOpenCellViewByType("sram_project" "bitcell" "layout" "" "r") "B0_1" list(8.61 0.35) "R0")
dbCreateInst(cv dbOpenCellViewByType("sram_project" "bitcell" "layout" "" "r") "B0_2" list(10.91 0.35) "R0")
dbCreateInst(cv dbOpenCellViewByType("sram_project" "bitcell" "layout" "" "r") "B0_3" list(13.21 0.35) "R0")
dbCreateInst(cv dbOpenCellViewByType("sram_project" "bitcell" "layout" "" "r") "B0_4" list(15.51 0.35) "R0")
dbCreateInst(cv dbOpenCellViewByType("sram_project" "bitcell" "layout" "" "r") "B0_5" list(17.81 0.35) "R0")
dbCreateInst(cv dbOpenCellViewByType("sram_project" "bitcell" "layout" "" "r") "B1_0" list(6.31 2.37) "R0")
dbCreateInst(cv dbOpenCellViewByType("sram_project" "bitcell" "layout" "" "r") "B1_1" list(8.61 2.37) "R0")
dbCreateInst(cv dbOpenCellViewByType("sram_project" "bitcell" "layout" "" "r") "B1_2" list(10.91 2.37) "R0")
dbCreateInst(cv dbOpenCellViewByType("sram_project" "bitcell" "layout" "" "r") "B1_3" list(13.21 2.37) "R0")
dbCreateInst(cv dbOpenCellViewByType("sram_project" "bitcell" "layout" "" "r") "B1_4" list(15.51 2.37) "R0")
dbCreateInst(cv dbOpenCellViewByType("sram_project" "bitcell" "layout" "" "r") "B1_5" list(17.81 2.37) "R0")
dbCreateInst(cv dbOpenCellViewByType("sram_project" "bitcell" "layout" "" "r") "B2_0" list(6.31 4.39) "R0")
dbCreateInst(cv dbOpenCellViewByType("sram_project" "bitcell" "layout" "" "r") "B2_1" list(8.61 4.39) "R0")
dbCreateInst(cv dbOpenCellViewByType("sram_project" "bitcell" "layout" "" "r") "B2_2" list(10.91 4.39) "R0")
dbCreateInst(cv dbOpenCellViewByType("sram_project" "bitcell" "layout" "" "r") "B2_3" list(13.21 4.39) "R0")
dbCreateInst(cv dbOpenCellViewByType("sram_project" "bitcell" "layout" "" "r") "B2_4" list(15.51 4.39) "R0")
dbCreateInst(cv dbOpenCellViewByType("sram_project" "bitcell" "layout" "" "r") "B2_5" list(17.81 4.39) "R0")
dbCreateInst(cv dbOpenCellViewByType("sram_project" "bitcell" "layout" "" "r") "B3_0" list(6.31 6.41) "R0")
dbCreateInst(cv dbOpenCellViewByType("sram_project" "bitcell" "layout" "" "r") "B3_1" list(8.61 6.41) "R0")
dbCreateInst(cv dbOpenCellViewByType("sram_project" "bitcell" "layout" "" "r") "B3_2" list(10.91 6.41) "R0")
dbCreateInst(cv dbOpenCellViewByType("sram_project" "bitcell" "layout" "" "r") "B3_3" list(13.21 6.41) "R0")
dbCreateInst(cv dbOpenCellViewByType("sram_project" "bitcell" "layout" "" "r") "B3_4" list(15.51 6.41) "R0")
dbCreateInst(cv dbOpenCellViewByType("sram_project" "bitcell" "layout" "" "r") "B3_5" list(17.81 6.41) "R0")
rect(cv "Metal2" 0.21 0.415 19.795 0.495)
rect(cv "Via2" 0.215 0.42 0.285 0.49)
rect(cv "Metal2" 0.185 0.415 0.315 0.495)
rect(cv "Metal3" 0.21 0.39 0.29 0.52)
rect(cv "Metal2" 0.53 2.435 19.795 2.515)
rect(cv "Via2" 0.535 2.44 0.605 2.51)
rect(cv "Metal2" 0.505 2.435 0.635 2.515)
rect(cv "Metal3" 0.53 2.41 0.61 2.54)
rect(cv "Metal2" 0.85 4.455 19.795 4.535)
rect(cv "Via2" 0.855 4.46 0.925 4.53)
rect(cv "Metal2" 0.825 4.455 0.955 4.535)
rect(cv "Metal3" 0.85 4.43 0.93 4.56)
rect(cv "Metal2" 1.17 6.475 19.795 6.555)
rect(cv "Via2" 1.175 6.48 1.245 6.55)
rect(cv "Metal2" 1.145 6.475 1.275 6.555)
rect(cv "Metal3" 1.17 6.45 1.25 6.58)
rect(cv "Via1" 6.41 1.125 6.48 1.195)
rect(cv "Metal1" 6.405 1.095 6.485 1.225)
rect(cv "Metal2" 6.32 1.115 6.57 1.205)
rect(cv "Via2" 6.41 1.125 6.48 1.195)
rect(cv "Metal2" 6.38 1.12 6.51 1.2)
rect(cv "Metal3" 6.405 1.095 6.485 1.225)
rect(cv "Via1" 6.41 3.145 6.48 3.215)
rect(cv "Metal1" 6.405 3.115 6.485 3.245)
rect(cv "Metal2" 6.32 3.135 6.57 3.225)
rect(cv "Via2" 6.41 3.145 6.48 3.215)
rect(cv "Metal2" 6.38 3.14 6.51 3.22)
rect(cv "Metal3" 6.405 3.115 6.485 3.245)
rect(cv "Via1" 6.41 5.165 6.48 5.235)
rect(cv "Metal1" 6.405 5.135 6.485 5.265)
rect(cv "Metal2" 6.32 5.155 6.57 5.245)
rect(cv "Via2" 6.41 5.165 6.48 5.235)
rect(cv "Metal2" 6.38 5.16 6.51 5.24)
rect(cv "Metal3" 6.405 5.135 6.485 5.265)
rect(cv "Via1" 6.41 7.185 6.48 7.255)
rect(cv "Metal1" 6.405 7.155 6.485 7.285)
rect(cv "Metal2" 6.32 7.175 6.57 7.265)
rect(cv "Via2" 6.41 7.185 6.48 7.255)
rect(cv "Metal2" 6.38 7.18 6.51 7.26)
rect(cv "Metal3" 6.405 7.155 6.485 7.285)
rect(cv "Metal3" 6.405 1.12 6.485 9.44)
rect(cv "Via2" 6.41 9.365 6.48 9.435)
rect(cv "Metal2" 6.38 9.36 6.51 9.44)
rect(cv "Metal3" 6.405 9.335 6.485 9.465)
rect(cv "Via1" 8.265 1.455 8.335 1.525)
rect(cv "Metal1" 8.26 1.425 8.34 1.555)
rect(cv "Metal2" 8.175 1.445 8.425 1.535)
rect(cv "Via2" 8.265 1.455 8.335 1.525)
rect(cv "Metal2" 8.235 1.45 8.365 1.53)
rect(cv "Metal3" 8.26 1.425 8.34 1.555)
rect(cv "Via1" 8.265 3.475 8.335 3.545)
rect(cv "Metal1" 8.26 3.445 8.34 3.575)
rect(cv "Metal2" 8.175 3.465 8.425 3.555)
rect(cv "Via2" 8.265 3.475 8.335 3.545)
rect(cv "Metal2" 8.235 3.47 8.365 3.55)
rect(cv "Metal3" 8.26 3.445 8.34 3.575)
rect(cv "Via1" 8.265 5.495 8.335 5.565)
rect(cv "Metal1" 8.26 5.465 8.34 5.595)
rect(cv "Metal2" 8.175 5.485 8.425 5.575)
rect(cv "Via2" 8.265 5.495 8.335 5.565)
rect(cv "Metal2" 8.235 5.49 8.365 5.57)
rect(cv "Metal3" 8.26 5.465 8.34 5.595)
rect(cv "Via1" 8.265 7.515 8.335 7.585)
rect(cv "Metal1" 8.26 7.485 8.34 7.615)
rect(cv "Metal2" 8.175 7.505 8.425 7.595)
rect(cv "Via2" 8.265 7.515 8.335 7.585)
rect(cv "Metal2" 8.235 7.51 8.365 7.59)
rect(cv "Metal3" 8.26 7.485 8.34 7.615)
rect(cv "Metal3" 8.26 1.45 8.34 8.48)
rect(cv "Via2" 8.265 8.405 8.335 8.475)
rect(cv "Metal2" 8.235 8.4 8.365 8.48)
rect(cv "Metal3" 8.26 8.375 8.34 8.505)
rect(cv "Via1" 7.165 1.935 7.235 2.005)
rect(cv "Metal1" 7.135 1.93 7.265 2.01)
rect(cv "Metal2" 7.075 1.925 7.325 2.015)
rect(cv "Via2" 7.165 1.935 7.235 2.005)
rect(cv "Metal2" 7.135 1.93 7.265 2.01)
rect(cv "Metal3" 7.16 1.905 7.24 2.035)
rect(cv "Via1" 7.165 3.955 7.235 4.025)
rect(cv "Metal1" 7.135 3.95 7.265 4.03)
rect(cv "Metal2" 7.075 3.945 7.325 4.035)
rect(cv "Via2" 7.165 3.955 7.235 4.025)
rect(cv "Metal2" 7.135 3.95 7.265 4.03)
rect(cv "Metal3" 7.16 3.925 7.24 4.055)
rect(cv "Via1" 7.165 5.975 7.235 6.045)
rect(cv "Metal1" 7.135 5.97 7.265 6.05)
rect(cv "Metal2" 7.075 5.965 7.325 6.055)
rect(cv "Via2" 7.165 5.975 7.235 6.045)
rect(cv "Metal2" 7.135 5.97 7.265 6.05)
rect(cv "Metal3" 7.16 5.945 7.24 6.075)
rect(cv "Via1" 7.165 7.995 7.235 8.065)
rect(cv "Metal1" 7.135 7.99 7.265 8.07)
rect(cv "Metal2" 7.075 7.985 7.325 8.075)
rect(cv "Via2" 7.165 7.995 7.235 8.065)
rect(cv "Metal2" 7.135 7.99 7.265 8.07)
rect(cv "Metal3" 7.16 7.965 7.24 8.095)
rect(cv "Metal3" 7.16 1.93 7.24 10.4)
rect(cv "Via2" 7.165 10.325 7.235 10.395)
rect(cv "Metal2" 7.135 10.32 7.265 10.4)
rect(cv "Metal3" 7.16 10.295 7.24 10.425)
rect(cv "Via1" 6.975 0.685 7.045 0.755)
rect(cv "Metal1" 6.945 0.68 7.075 0.76)
rect(cv "Metal2" 6.885 0.675 7.135 0.765)
rect(cv "Via2" 6.975 0.685 7.045 0.755)
rect(cv "Metal2" 6.945 0.68 7.075 0.76)
rect(cv "Metal3" 6.97 0.655 7.05 0.785)
rect(cv "Via1" 6.975 2.705 7.045 2.775)
rect(cv "Metal1" 6.945 2.7 7.075 2.78)
rect(cv "Metal2" 6.885 2.695 7.135 2.785)
rect(cv "Via2" 6.975 2.705 7.045 2.775)
rect(cv "Metal2" 6.945 2.7 7.075 2.78)
rect(cv "Metal3" 6.97 2.675 7.05 2.805)
rect(cv "Via1" 6.975 4.725 7.045 4.795)
rect(cv "Metal1" 6.945 4.72 7.075 4.8)
rect(cv "Metal2" 6.885 4.715 7.135 4.805)
rect(cv "Via2" 6.975 4.725 7.045 4.795)
rect(cv "Metal2" 6.945 4.72 7.075 4.8)
rect(cv "Metal3" 6.97 4.695 7.05 4.825)
rect(cv "Via1" 6.975 6.745 7.045 6.815)
rect(cv "Metal1" 6.945 6.74 7.075 6.82)
rect(cv "Metal2" 6.885 6.735 7.135 6.825)
rect(cv "Via2" 6.975 6.745 7.045 6.815)
rect(cv "Metal2" 6.945 6.74 7.075 6.82)
rect(cv "Metal3" 6.97 6.715 7.05 6.845)
rect(cv "Metal3" 6.97 0.68 7.05 10.56)
rect(cv "Via2" 6.975 10.485 7.045 10.555)
rect(cv "Metal2" 6.945 10.48 7.075 10.56)
rect(cv "Metal3" 6.97 10.455 7.05 10.585)
rect(cv "Via1" 8.71 1.125 8.78 1.195)
rect(cv "Metal1" 8.705 1.095 8.785 1.225)
rect(cv "Metal2" 8.62 1.115 8.87 1.205)
rect(cv "Via2" 8.71 1.125 8.78 1.195)
rect(cv "Metal2" 8.68 1.12 8.81 1.2)
rect(cv "Metal3" 8.705 1.095 8.785 1.225)
rect(cv "Via1" 8.71 3.145 8.78 3.215)
rect(cv "Metal1" 8.705 3.115 8.785 3.245)
rect(cv "Metal2" 8.62 3.135 8.87 3.225)
rect(cv "Via2" 8.71 3.145 8.78 3.215)
rect(cv "Metal2" 8.68 3.14 8.81 3.22)
rect(cv "Metal3" 8.705 3.115 8.785 3.245)
rect(cv "Via1" 8.71 5.165 8.78 5.235)
rect(cv "Metal1" 8.705 5.135 8.785 5.265)
rect(cv "Metal2" 8.62 5.155 8.87 5.245)
rect(cv "Via2" 8.71 5.165 8.78 5.235)
rect(cv "Metal2" 8.68 5.16 8.81 5.24)
rect(cv "Metal3" 8.705 5.135 8.785 5.265)
rect(cv "Via1" 8.71 7.185 8.78 7.255)
rect(cv "Metal1" 8.705 7.155 8.785 7.285)
rect(cv "Metal2" 8.62 7.175 8.87 7.265)
rect(cv "Via2" 8.71 7.185 8.78 7.255)
rect(cv "Metal2" 8.68 7.18 8.81 7.26)
rect(cv "Metal3" 8.705 7.155 8.785 7.285)
rect(cv "Metal3" 8.705 1.12 8.785 9.6)
rect(cv "Via2" 8.71 9.525 8.78 9.595)
rect(cv "Metal2" 8.68 9.52 8.81 9.6)
rect(cv "Metal3" 8.705 9.495 8.785 9.625)
rect(cv "Via1" 10.565 1.455 10.635 1.525)
rect(cv "Metal1" 10.56 1.425 10.64 1.555)
rect(cv "Metal2" 10.475 1.445 10.725 1.535)
rect(cv "Via2" 10.565 1.455 10.635 1.525)
rect(cv "Metal2" 10.535 1.45 10.665 1.53)
rect(cv "Metal3" 10.56 1.425 10.64 1.555)
rect(cv "Via1" 10.565 3.475 10.635 3.545)
rect(cv "Metal1" 10.56 3.445 10.64 3.575)
rect(cv "Metal2" 10.475 3.465 10.725 3.555)
rect(cv "Via2" 10.565 3.475 10.635 3.545)
rect(cv "Metal2" 10.535 3.47 10.665 3.55)
rect(cv "Metal3" 10.56 3.445 10.64 3.575)
rect(cv "Via1" 10.565 5.495 10.635 5.565)
rect(cv "Metal1" 10.56 5.465 10.64 5.595)
rect(cv "Metal2" 10.475 5.485 10.725 5.575)
rect(cv "Via2" 10.565 5.495 10.635 5.565)
rect(cv "Metal2" 10.535 5.49 10.665 5.57)
rect(cv "Metal3" 10.56 5.465 10.64 5.595)
rect(cv "Via1" 10.565 7.515 10.635 7.585)
rect(cv "Metal1" 10.56 7.485 10.64 7.615)
rect(cv "Metal2" 10.475 7.505 10.725 7.595)
rect(cv "Via2" 10.565 7.515 10.635 7.585)
rect(cv "Metal2" 10.535 7.51 10.665 7.59)
rect(cv "Metal3" 10.56 7.485 10.64 7.615)
rect(cv "Metal3" 10.56 1.45 10.64 8.64)
rect(cv "Via2" 10.565 8.565 10.635 8.635)
rect(cv "Metal2" 10.535 8.56 10.665 8.64)
rect(cv "Metal3" 10.56 8.535 10.64 8.665)
rect(cv "Via1" 9.465 1.935 9.535 2.005)
rect(cv "Metal1" 9.435 1.93 9.565 2.01)
rect(cv "Metal2" 9.375 1.925 9.625 2.015)
rect(cv "Via2" 9.465 1.935 9.535 2.005)
rect(cv "Metal2" 9.435 1.93 9.565 2.01)
rect(cv "Metal3" 9.46 1.905 9.54 2.035)
rect(cv "Via1" 9.465 3.955 9.535 4.025)
rect(cv "Metal1" 9.435 3.95 9.565 4.03)
rect(cv "Metal2" 9.375 3.945 9.625 4.035)
rect(cv "Via2" 9.465 3.955 9.535 4.025)
rect(cv "Metal2" 9.435 3.95 9.565 4.03)
rect(cv "Metal3" 9.46 3.925 9.54 4.055)
rect(cv "Via1" 9.465 5.975 9.535 6.045)
rect(cv "Metal1" 9.435 5.97 9.565 6.05)
rect(cv "Metal2" 9.375 5.965 9.625 6.055)
rect(cv "Via2" 9.465 5.975 9.535 6.045)
rect(cv "Metal2" 9.435 5.97 9.565 6.05)
rect(cv "Metal3" 9.46 5.945 9.54 6.075)
rect(cv "Via1" 9.465 7.995 9.535 8.065)
rect(cv "Metal1" 9.435 7.99 9.565 8.07)
rect(cv "Metal2" 9.375 7.985 9.625 8.075)
rect(cv "Via2" 9.465 7.995 9.535 8.065)
rect(cv "Metal2" 9.435 7.99 9.565 8.07)
rect(cv "Metal3" 9.46 7.965 9.54 8.095)
rect(cv "Metal3" 9.46 1.93 9.54 10.4)
rect(cv "Via2" 9.465 10.325 9.535 10.395)
rect(cv "Metal2" 9.435 10.32 9.565 10.4)
rect(cv "Metal3" 9.46 10.295 9.54 10.425)
rect(cv "Via1" 9.275 0.685 9.345 0.755)
rect(cv "Metal1" 9.245 0.68 9.375 0.76)
rect(cv "Metal2" 9.185 0.675 9.435 0.765)
rect(cv "Via2" 9.275 0.685 9.345 0.755)
rect(cv "Metal2" 9.245 0.68 9.375 0.76)
rect(cv "Metal3" 9.27 0.655 9.35 0.785)
rect(cv "Via1" 9.275 2.705 9.345 2.775)
rect(cv "Metal1" 9.245 2.7 9.375 2.78)
rect(cv "Metal2" 9.185 2.695 9.435 2.785)
rect(cv "Via2" 9.275 2.705 9.345 2.775)
rect(cv "Metal2" 9.245 2.7 9.375 2.78)
rect(cv "Metal3" 9.27 2.675 9.35 2.805)
rect(cv "Via1" 9.275 4.725 9.345 4.795)
rect(cv "Metal1" 9.245 4.72 9.375 4.8)
rect(cv "Metal2" 9.185 4.715 9.435 4.805)
rect(cv "Via2" 9.275 4.725 9.345 4.795)
rect(cv "Metal2" 9.245 4.72 9.375 4.8)
rect(cv "Metal3" 9.27 4.695 9.35 4.825)
rect(cv "Via1" 9.275 6.745 9.345 6.815)
rect(cv "Metal1" 9.245 6.74 9.375 6.82)
rect(cv "Metal2" 9.185 6.735 9.435 6.825)
rect(cv "Via2" 9.275 6.745 9.345 6.815)
rect(cv "Metal2" 9.245 6.74 9.375 6.82)
rect(cv "Metal3" 9.27 6.715 9.35 6.845)
rect(cv "Metal3" 9.27 0.68 9.35 10.56)
rect(cv "Via2" 9.275 10.485 9.345 10.555)
rect(cv "Metal2" 9.245 10.48 9.375 10.56)
rect(cv "Metal3" 9.27 10.455 9.35 10.585)
rect(cv "Via1" 11.01 1.125 11.08 1.195)
rect(cv "Metal1" 11.005 1.095 11.085 1.225)
rect(cv "Metal2" 10.92 1.115 11.17 1.205)
rect(cv "Via2" 11.01 1.125 11.08 1.195)
rect(cv "Metal2" 10.98 1.12 11.11 1.2)
rect(cv "Metal3" 11.005 1.095 11.085 1.225)
rect(cv "Via1" 11.01 3.145 11.08 3.215)
rect(cv "Metal1" 11.005 3.115 11.085 3.245)
rect(cv "Metal2" 10.92 3.135 11.17 3.225)
rect(cv "Via2" 11.01 3.145 11.08 3.215)
rect(cv "Metal2" 10.98 3.14 11.11 3.22)
rect(cv "Metal3" 11.005 3.115 11.085 3.245)
rect(cv "Via1" 11.01 5.165 11.08 5.235)
rect(cv "Metal1" 11.005 5.135 11.085 5.265)
rect(cv "Metal2" 10.92 5.155 11.17 5.245)
rect(cv "Via2" 11.01 5.165 11.08 5.235)
rect(cv "Metal2" 10.98 5.16 11.11 5.24)
rect(cv "Metal3" 11.005 5.135 11.085 5.265)
rect(cv "Via1" 11.01 7.185 11.08 7.255)
rect(cv "Metal1" 11.005 7.155 11.085 7.285)
rect(cv "Metal2" 10.92 7.175 11.17 7.265)
rect(cv "Via2" 11.01 7.185 11.08 7.255)
rect(cv "Metal2" 10.98 7.18 11.11 7.26)
rect(cv "Metal3" 11.005 7.155 11.085 7.285)
rect(cv "Metal3" 11.005 1.12 11.085 9.76)
rect(cv "Via2" 11.01 9.685 11.08 9.755)
rect(cv "Metal2" 10.98 9.68 11.11 9.76)
rect(cv "Metal3" 11.005 9.655 11.085 9.785)
rect(cv "Via1" 12.865 1.455 12.935 1.525)
rect(cv "Metal1" 12.86 1.425 12.94 1.555)
rect(cv "Metal2" 12.775 1.445 13.025 1.535)
rect(cv "Via2" 12.865 1.455 12.935 1.525)
rect(cv "Metal2" 12.835 1.45 12.965 1.53)
rect(cv "Metal3" 12.86 1.425 12.94 1.555)
rect(cv "Via1" 12.865 3.475 12.935 3.545)
rect(cv "Metal1" 12.86 3.445 12.94 3.575)
rect(cv "Metal2" 12.775 3.465 13.025 3.555)
rect(cv "Via2" 12.865 3.475 12.935 3.545)
rect(cv "Metal2" 12.835 3.47 12.965 3.55)
rect(cv "Metal3" 12.86 3.445 12.94 3.575)
rect(cv "Via1" 12.865 5.495 12.935 5.565)
rect(cv "Metal1" 12.86 5.465 12.94 5.595)
rect(cv "Metal2" 12.775 5.485 13.025 5.575)
rect(cv "Via2" 12.865 5.495 12.935 5.565)
rect(cv "Metal2" 12.835 5.49 12.965 5.57)
rect(cv "Metal3" 12.86 5.465 12.94 5.595)
rect(cv "Via1" 12.865 7.515 12.935 7.585)
rect(cv "Metal1" 12.86 7.485 12.94 7.615)
rect(cv "Metal2" 12.775 7.505 13.025 7.595)
rect(cv "Via2" 12.865 7.515 12.935 7.585)
rect(cv "Metal2" 12.835 7.51 12.965 7.59)
rect(cv "Metal3" 12.86 7.485 12.94 7.615)
rect(cv "Metal3" 12.86 1.45 12.94 8.8)
rect(cv "Via2" 12.865 8.725 12.935 8.795)
rect(cv "Metal2" 12.835 8.72 12.965 8.8)
rect(cv "Metal3" 12.86 8.695 12.94 8.825)
rect(cv "Via1" 11.765 1.935 11.835 2.005)
rect(cv "Metal1" 11.735 1.93 11.865 2.01)
rect(cv "Metal2" 11.675 1.925 11.925 2.015)
rect(cv "Via2" 11.765 1.935 11.835 2.005)
rect(cv "Metal2" 11.735 1.93 11.865 2.01)
rect(cv "Metal3" 11.76 1.905 11.84 2.035)
rect(cv "Via1" 11.765 3.955 11.835 4.025)
rect(cv "Metal1" 11.735 3.95 11.865 4.03)
rect(cv "Metal2" 11.675 3.945 11.925 4.035)
rect(cv "Via2" 11.765 3.955 11.835 4.025)
rect(cv "Metal2" 11.735 3.95 11.865 4.03)
rect(cv "Metal3" 11.76 3.925 11.84 4.055)
rect(cv "Via1" 11.765 5.975 11.835 6.045)
rect(cv "Metal1" 11.735 5.97 11.865 6.05)
rect(cv "Metal2" 11.675 5.965 11.925 6.055)
rect(cv "Via2" 11.765 5.975 11.835 6.045)
rect(cv "Metal2" 11.735 5.97 11.865 6.05)
rect(cv "Metal3" 11.76 5.945 11.84 6.075)
rect(cv "Via1" 11.765 7.995 11.835 8.065)
rect(cv "Metal1" 11.735 7.99 11.865 8.07)
rect(cv "Metal2" 11.675 7.985 11.925 8.075)
rect(cv "Via2" 11.765 7.995 11.835 8.065)
rect(cv "Metal2" 11.735 7.99 11.865 8.07)
rect(cv "Metal3" 11.76 7.965 11.84 8.095)
rect(cv "Metal3" 11.76 1.93 11.84 10.4)
rect(cv "Via2" 11.765 10.325 11.835 10.395)
rect(cv "Metal2" 11.735 10.32 11.865 10.4)
rect(cv "Metal3" 11.76 10.295 11.84 10.425)
rect(cv "Via1" 11.575 0.685 11.645 0.755)
rect(cv "Metal1" 11.545 0.68 11.675 0.76)
rect(cv "Metal2" 11.485 0.675 11.735 0.765)
rect(cv "Via2" 11.575 0.685 11.645 0.755)
rect(cv "Metal2" 11.545 0.68 11.675 0.76)
rect(cv "Metal3" 11.57 0.655 11.65 0.785)
rect(cv "Via1" 11.575 2.705 11.645 2.775)
rect(cv "Metal1" 11.545 2.7 11.675 2.78)
rect(cv "Metal2" 11.485 2.695 11.735 2.785)
rect(cv "Via2" 11.575 2.705 11.645 2.775)
rect(cv "Metal2" 11.545 2.7 11.675 2.78)
rect(cv "Metal3" 11.57 2.675 11.65 2.805)
rect(cv "Via1" 11.575 4.725 11.645 4.795)
rect(cv "Metal1" 11.545 4.72 11.675 4.8)
rect(cv "Metal2" 11.485 4.715 11.735 4.805)
rect(cv "Via2" 11.575 4.725 11.645 4.795)
rect(cv "Metal2" 11.545 4.72 11.675 4.8)
rect(cv "Metal3" 11.57 4.695 11.65 4.825)
rect(cv "Via1" 11.575 6.745 11.645 6.815)
rect(cv "Metal1" 11.545 6.74 11.675 6.82)
rect(cv "Metal2" 11.485 6.735 11.735 6.825)
rect(cv "Via2" 11.575 6.745 11.645 6.815)
rect(cv "Metal2" 11.545 6.74 11.675 6.82)
rect(cv "Metal3" 11.57 6.715 11.65 6.845)
rect(cv "Metal3" 11.57 0.68 11.65 10.56)
rect(cv "Via2" 11.575 10.485 11.645 10.555)
rect(cv "Metal2" 11.545 10.48 11.675 10.56)
rect(cv "Metal3" 11.57 10.455 11.65 10.585)
rect(cv "Via1" 13.31 1.125 13.38 1.195)
rect(cv "Metal1" 13.305 1.095 13.385 1.225)
rect(cv "Metal2" 13.22 1.115 13.47 1.205)
rect(cv "Via2" 13.31 1.125 13.38 1.195)
rect(cv "Metal2" 13.28 1.12 13.41 1.2)
rect(cv "Metal3" 13.305 1.095 13.385 1.225)
rect(cv "Via1" 13.31 3.145 13.38 3.215)
rect(cv "Metal1" 13.305 3.115 13.385 3.245)
rect(cv "Metal2" 13.22 3.135 13.47 3.225)
rect(cv "Via2" 13.31 3.145 13.38 3.215)
rect(cv "Metal2" 13.28 3.14 13.41 3.22)
rect(cv "Metal3" 13.305 3.115 13.385 3.245)
rect(cv "Via1" 13.31 5.165 13.38 5.235)
rect(cv "Metal1" 13.305 5.135 13.385 5.265)
rect(cv "Metal2" 13.22 5.155 13.47 5.245)
rect(cv "Via2" 13.31 5.165 13.38 5.235)
rect(cv "Metal2" 13.28 5.16 13.41 5.24)
rect(cv "Metal3" 13.305 5.135 13.385 5.265)
rect(cv "Via1" 13.31 7.185 13.38 7.255)
rect(cv "Metal1" 13.305 7.155 13.385 7.285)
rect(cv "Metal2" 13.22 7.175 13.47 7.265)
rect(cv "Via2" 13.31 7.185 13.38 7.255)
rect(cv "Metal2" 13.28 7.18 13.41 7.26)
rect(cv "Metal3" 13.305 7.155 13.385 7.285)
rect(cv "Metal3" 13.305 1.12 13.385 9.92)
rect(cv "Via2" 13.31 9.845 13.38 9.915)
rect(cv "Metal2" 13.28 9.84 13.41 9.92)
rect(cv "Metal3" 13.305 9.815 13.385 9.945)
rect(cv "Via1" 15.165 1.455 15.235 1.525)
rect(cv "Metal1" 15.16 1.425 15.24 1.555)
rect(cv "Metal2" 15.075 1.445 15.325 1.535)
rect(cv "Via2" 15.165 1.455 15.235 1.525)
rect(cv "Metal2" 15.135 1.45 15.265 1.53)
rect(cv "Metal3" 15.16 1.425 15.24 1.555)
rect(cv "Via1" 15.165 3.475 15.235 3.545)
rect(cv "Metal1" 15.16 3.445 15.24 3.575)
rect(cv "Metal2" 15.075 3.465 15.325 3.555)
rect(cv "Via2" 15.165 3.475 15.235 3.545)
rect(cv "Metal2" 15.135 3.47 15.265 3.55)
rect(cv "Metal3" 15.16 3.445 15.24 3.575)
rect(cv "Via1" 15.165 5.495 15.235 5.565)
rect(cv "Metal1" 15.16 5.465 15.24 5.595)
rect(cv "Metal2" 15.075 5.485 15.325 5.575)
rect(cv "Via2" 15.165 5.495 15.235 5.565)
rect(cv "Metal2" 15.135 5.49 15.265 5.57)
rect(cv "Metal3" 15.16 5.465 15.24 5.595)
rect(cv "Via1" 15.165 7.515 15.235 7.585)
rect(cv "Metal1" 15.16 7.485 15.24 7.615)
rect(cv "Metal2" 15.075 7.505 15.325 7.595)
rect(cv "Via2" 15.165 7.515 15.235 7.585)
rect(cv "Metal2" 15.135 7.51 15.265 7.59)
rect(cv "Metal3" 15.16 7.485 15.24 7.615)
rect(cv "Metal3" 15.16 1.45 15.24 8.96)
rect(cv "Via2" 15.165 8.885 15.235 8.955)
rect(cv "Metal2" 15.135 8.88 15.265 8.96)
rect(cv "Metal3" 15.16 8.855 15.24 8.985)
rect(cv "Via1" 14.065 1.935 14.135 2.005)
rect(cv "Metal1" 14.035 1.93 14.165 2.01)
rect(cv "Metal2" 13.975 1.925 14.225 2.015)
rect(cv "Via2" 14.065 1.935 14.135 2.005)
rect(cv "Metal2" 14.035 1.93 14.165 2.01)
rect(cv "Metal3" 14.06 1.905 14.14 2.035)
rect(cv "Via1" 14.065 3.955 14.135 4.025)
rect(cv "Metal1" 14.035 3.95 14.165 4.03)
rect(cv "Metal2" 13.975 3.945 14.225 4.035)
rect(cv "Via2" 14.065 3.955 14.135 4.025)
rect(cv "Metal2" 14.035 3.95 14.165 4.03)
rect(cv "Metal3" 14.06 3.925 14.14 4.055)
rect(cv "Via1" 14.065 5.975 14.135 6.045)
rect(cv "Metal1" 14.035 5.97 14.165 6.05)
rect(cv "Metal2" 13.975 5.965 14.225 6.055)
rect(cv "Via2" 14.065 5.975 14.135 6.045)
rect(cv "Metal2" 14.035 5.97 14.165 6.05)
rect(cv "Metal3" 14.06 5.945 14.14 6.075)
rect(cv "Via1" 14.065 7.995 14.135 8.065)
rect(cv "Metal1" 14.035 7.99 14.165 8.07)
rect(cv "Metal2" 13.975 7.985 14.225 8.075)
rect(cv "Via2" 14.065 7.995 14.135 8.065)
rect(cv "Metal2" 14.035 7.99 14.165 8.07)
rect(cv "Metal3" 14.06 7.965 14.14 8.095)
rect(cv "Metal3" 14.06 1.93 14.14 10.4)
rect(cv "Via2" 14.065 10.325 14.135 10.395)
rect(cv "Metal2" 14.035 10.32 14.165 10.4)
rect(cv "Metal3" 14.06 10.295 14.14 10.425)
rect(cv "Via1" 13.875 0.685 13.945 0.755)
rect(cv "Metal1" 13.845 0.68 13.975 0.76)
rect(cv "Metal2" 13.785 0.675 14.035 0.765)
rect(cv "Via2" 13.875 0.685 13.945 0.755)
rect(cv "Metal2" 13.845 0.68 13.975 0.76)
rect(cv "Metal3" 13.87 0.655 13.95 0.785)
rect(cv "Via1" 13.875 2.705 13.945 2.775)
rect(cv "Metal1" 13.845 2.7 13.975 2.78)
rect(cv "Metal2" 13.785 2.695 14.035 2.785)
rect(cv "Via2" 13.875 2.705 13.945 2.775)
rect(cv "Metal2" 13.845 2.7 13.975 2.78)
rect(cv "Metal3" 13.87 2.675 13.95 2.805)
rect(cv "Via1" 13.875 4.725 13.945 4.795)
rect(cv "Metal1" 13.845 4.72 13.975 4.8)
rect(cv "Metal2" 13.785 4.715 14.035 4.805)
rect(cv "Via2" 13.875 4.725 13.945 4.795)
rect(cv "Metal2" 13.845 4.72 13.975 4.8)
rect(cv "Metal3" 13.87 4.695 13.95 4.825)
rect(cv "Via1" 13.875 6.745 13.945 6.815)
rect(cv "Metal1" 13.845 6.74 13.975 6.82)
rect(cv "Metal2" 13.785 6.735 14.035 6.825)
rect(cv "Via2" 13.875 6.745 13.945 6.815)
rect(cv "Metal2" 13.845 6.74 13.975 6.82)
rect(cv "Metal3" 13.87 6.715 13.95 6.845)
rect(cv "Metal3" 13.87 0.68 13.95 10.56)
rect(cv "Via2" 13.875 10.485 13.945 10.555)
rect(cv "Metal2" 13.845 10.48 13.975 10.56)
rect(cv "Metal3" 13.87 10.455 13.95 10.585)
rect(cv "Via1" 15.61 1.125 15.68 1.195)
rect(cv "Metal1" 15.605 1.095 15.685 1.225)
rect(cv "Metal2" 15.52 1.115 15.77 1.205)
rect(cv "Via2" 15.61 1.125 15.68 1.195)
rect(cv "Metal2" 15.58 1.12 15.71 1.2)
rect(cv "Metal3" 15.605 1.095 15.685 1.225)
rect(cv "Via1" 15.61 3.145 15.68 3.215)
rect(cv "Metal1" 15.605 3.115 15.685 3.245)
rect(cv "Metal2" 15.52 3.135 15.77 3.225)
rect(cv "Via2" 15.61 3.145 15.68 3.215)
rect(cv "Metal2" 15.58 3.14 15.71 3.22)
rect(cv "Metal3" 15.605 3.115 15.685 3.245)
rect(cv "Via1" 15.61 5.165 15.68 5.235)
rect(cv "Metal1" 15.605 5.135 15.685 5.265)
rect(cv "Metal2" 15.52 5.155 15.77 5.245)
rect(cv "Via2" 15.61 5.165 15.68 5.235)
rect(cv "Metal2" 15.58 5.16 15.71 5.24)
rect(cv "Metal3" 15.605 5.135 15.685 5.265)
rect(cv "Via1" 15.61 7.185 15.68 7.255)
rect(cv "Metal1" 15.605 7.155 15.685 7.285)
rect(cv "Metal2" 15.52 7.175 15.77 7.265)
rect(cv "Via2" 15.61 7.185 15.68 7.255)
rect(cv "Metal2" 15.58 7.18 15.71 7.26)
rect(cv "Metal3" 15.605 7.155 15.685 7.285)
rect(cv "Metal3" 15.605 1.12 15.685 10.08)
rect(cv "Via2" 15.61 10.005 15.68 10.075)
rect(cv "Metal2" 15.58 10 15.71 10.08)
rect(cv "Metal3" 15.605 9.975 15.685 10.105)
rect(cv "Via1" 17.465 1.455 17.535 1.525)
rect(cv "Metal1" 17.46 1.425 17.54 1.555)
rect(cv "Metal2" 17.375 1.445 17.625 1.535)
rect(cv "Via2" 17.465 1.455 17.535 1.525)
rect(cv "Metal2" 17.435 1.45 17.565 1.53)
rect(cv "Metal3" 17.46 1.425 17.54 1.555)
rect(cv "Via1" 17.465 3.475 17.535 3.545)
rect(cv "Metal1" 17.46 3.445 17.54 3.575)
rect(cv "Metal2" 17.375 3.465 17.625 3.555)
rect(cv "Via2" 17.465 3.475 17.535 3.545)
rect(cv "Metal2" 17.435 3.47 17.565 3.55)
rect(cv "Metal3" 17.46 3.445 17.54 3.575)
rect(cv "Via1" 17.465 5.495 17.535 5.565)
rect(cv "Metal1" 17.46 5.465 17.54 5.595)
rect(cv "Metal2" 17.375 5.485 17.625 5.575)
rect(cv "Via2" 17.465 5.495 17.535 5.565)
rect(cv "Metal2" 17.435 5.49 17.565 5.57)
rect(cv "Metal3" 17.46 5.465 17.54 5.595)
rect(cv "Via1" 17.465 7.515 17.535 7.585)
rect(cv "Metal1" 17.46 7.485 17.54 7.615)
rect(cv "Metal2" 17.375 7.505 17.625 7.595)
rect(cv "Via2" 17.465 7.515 17.535 7.585)
rect(cv "Metal2" 17.435 7.51 17.565 7.59)
rect(cv "Metal3" 17.46 7.485 17.54 7.615)
rect(cv "Metal3" 17.46 1.45 17.54 9.12)
rect(cv "Via2" 17.465 9.045 17.535 9.115)
rect(cv "Metal2" 17.435 9.04 17.565 9.12)
rect(cv "Metal3" 17.46 9.015 17.54 9.145)
rect(cv "Via1" 16.365 1.935 16.435 2.005)
rect(cv "Metal1" 16.335 1.93 16.465 2.01)
rect(cv "Metal2" 16.275 1.925 16.525 2.015)
rect(cv "Via2" 16.365 1.935 16.435 2.005)
rect(cv "Metal2" 16.335 1.93 16.465 2.01)
rect(cv "Metal3" 16.36 1.905 16.44 2.035)
rect(cv "Via1" 16.365 3.955 16.435 4.025)
rect(cv "Metal1" 16.335 3.95 16.465 4.03)
rect(cv "Metal2" 16.275 3.945 16.525 4.035)
rect(cv "Via2" 16.365 3.955 16.435 4.025)
rect(cv "Metal2" 16.335 3.95 16.465 4.03)
rect(cv "Metal3" 16.36 3.925 16.44 4.055)
rect(cv "Via1" 16.365 5.975 16.435 6.045)
rect(cv "Metal1" 16.335 5.97 16.465 6.05)
rect(cv "Metal2" 16.275 5.965 16.525 6.055)
rect(cv "Via2" 16.365 5.975 16.435 6.045)
rect(cv "Metal2" 16.335 5.97 16.465 6.05)
rect(cv "Metal3" 16.36 5.945 16.44 6.075)
rect(cv "Via1" 16.365 7.995 16.435 8.065)
rect(cv "Metal1" 16.335 7.99 16.465 8.07)
rect(cv "Metal2" 16.275 7.985 16.525 8.075)
rect(cv "Via2" 16.365 7.995 16.435 8.065)
rect(cv "Metal2" 16.335 7.99 16.465 8.07)
rect(cv "Metal3" 16.36 7.965 16.44 8.095)
rect(cv "Metal3" 16.36 1.93 16.44 10.4)
rect(cv "Via2" 16.365 10.325 16.435 10.395)
rect(cv "Metal2" 16.335 10.32 16.465 10.4)
rect(cv "Metal3" 16.36 10.295 16.44 10.425)
rect(cv "Via1" 16.175 0.685 16.245 0.755)
rect(cv "Metal1" 16.145 0.68 16.275 0.76)
rect(cv "Metal2" 16.085 0.675 16.335 0.765)
rect(cv "Via2" 16.175 0.685 16.245 0.755)
rect(cv "Metal2" 16.145 0.68 16.275 0.76)
rect(cv "Metal3" 16.17 0.655 16.25 0.785)
rect(cv "Via1" 16.175 2.705 16.245 2.775)
rect(cv "Metal1" 16.145 2.7 16.275 2.78)
rect(cv "Metal2" 16.085 2.695 16.335 2.785)
rect(cv "Via2" 16.175 2.705 16.245 2.775)
rect(cv "Metal2" 16.145 2.7 16.275 2.78)
rect(cv "Metal3" 16.17 2.675 16.25 2.805)
rect(cv "Via1" 16.175 4.725 16.245 4.795)
rect(cv "Metal1" 16.145 4.72 16.275 4.8)
rect(cv "Metal2" 16.085 4.715 16.335 4.805)
rect(cv "Via2" 16.175 4.725 16.245 4.795)
rect(cv "Metal2" 16.145 4.72 16.275 4.8)
rect(cv "Metal3" 16.17 4.695 16.25 4.825)
rect(cv "Via1" 16.175 6.745 16.245 6.815)
rect(cv "Metal1" 16.145 6.74 16.275 6.82)
rect(cv "Metal2" 16.085 6.735 16.335 6.825)
rect(cv "Via2" 16.175 6.745 16.245 6.815)
rect(cv "Metal2" 16.145 6.74 16.275 6.82)
rect(cv "Metal3" 16.17 6.715 16.25 6.845)
rect(cv "Metal3" 16.17 0.68 16.25 10.56)
rect(cv "Via2" 16.175 10.485 16.245 10.555)
rect(cv "Metal2" 16.145 10.48 16.275 10.56)
rect(cv "Metal3" 16.17 10.455 16.25 10.585)
rect(cv "Via1" 17.91 1.125 17.98 1.195)
rect(cv "Metal1" 17.905 1.095 17.985 1.225)
rect(cv "Metal2" 17.82 1.115 18.07 1.205)
rect(cv "Via2" 17.91 1.125 17.98 1.195)
rect(cv "Metal2" 17.88 1.12 18.01 1.2)
rect(cv "Metal3" 17.905 1.095 17.985 1.225)
rect(cv "Via1" 17.91 3.145 17.98 3.215)
rect(cv "Metal1" 17.905 3.115 17.985 3.245)
rect(cv "Metal2" 17.82 3.135 18.07 3.225)
rect(cv "Via2" 17.91 3.145 17.98 3.215)
rect(cv "Metal2" 17.88 3.14 18.01 3.22)
rect(cv "Metal3" 17.905 3.115 17.985 3.245)
rect(cv "Via1" 17.91 5.165 17.98 5.235)
rect(cv "Metal1" 17.905 5.135 17.985 5.265)
rect(cv "Metal2" 17.82 5.155 18.07 5.245)
rect(cv "Via2" 17.91 5.165 17.98 5.235)
rect(cv "Metal2" 17.88 5.16 18.01 5.24)
rect(cv "Metal3" 17.905 5.135 17.985 5.265)
rect(cv "Via1" 17.91 7.185 17.98 7.255)
rect(cv "Metal1" 17.905 7.155 17.985 7.285)
rect(cv "Metal2" 17.82 7.175 18.07 7.265)
rect(cv "Via2" 17.91 7.185 17.98 7.255)
rect(cv "Metal2" 17.88 7.18 18.01 7.26)
rect(cv "Metal3" 17.905 7.155 17.985 7.285)
rect(cv "Metal3" 17.905 1.12 17.985 10.24)
rect(cv "Via2" 17.91 10.165 17.98 10.235)
rect(cv "Metal2" 17.88 10.16 18.01 10.24)
rect(cv "Metal3" 17.905 10.135 17.985 10.265)
rect(cv "Via1" 19.765 1.455 19.835 1.525)
rect(cv "Metal1" 19.76 1.425 19.84 1.555)
rect(cv "Metal2" 19.675 1.445 19.925 1.535)
rect(cv "Via2" 19.765 1.455 19.835 1.525)
rect(cv "Metal2" 19.735 1.45 19.865 1.53)
rect(cv "Metal3" 19.76 1.425 19.84 1.555)
rect(cv "Via1" 19.765 3.475 19.835 3.545)
rect(cv "Metal1" 19.76 3.445 19.84 3.575)
rect(cv "Metal2" 19.675 3.465 19.925 3.555)
rect(cv "Via2" 19.765 3.475 19.835 3.545)
rect(cv "Metal2" 19.735 3.47 19.865 3.55)
rect(cv "Metal3" 19.76 3.445 19.84 3.575)
rect(cv "Via1" 19.765 5.495 19.835 5.565)
rect(cv "Metal1" 19.76 5.465 19.84 5.595)
rect(cv "Metal2" 19.675 5.485 19.925 5.575)
rect(cv "Via2" 19.765 5.495 19.835 5.565)
rect(cv "Metal2" 19.735 5.49 19.865 5.57)
rect(cv "Metal3" 19.76 5.465 19.84 5.595)
rect(cv "Via1" 19.765 7.515 19.835 7.585)
rect(cv "Metal1" 19.76 7.485 19.84 7.615)
rect(cv "Metal2" 19.675 7.505 19.925 7.595)
rect(cv "Via2" 19.765 7.515 19.835 7.585)
rect(cv "Metal2" 19.735 7.51 19.865 7.59)
rect(cv "Metal3" 19.76 7.485 19.84 7.615)
rect(cv "Metal3" 19.76 1.45 19.84 9.28)
rect(cv "Via2" 19.765 9.205 19.835 9.275)
rect(cv "Metal2" 19.735 9.2 19.865 9.28)
rect(cv "Metal3" 19.76 9.175 19.84 9.305)
rect(cv "Via1" 18.665 1.935 18.735 2.005)
rect(cv "Metal1" 18.635 1.93 18.765 2.01)
rect(cv "Metal2" 18.575 1.925 18.825 2.015)
rect(cv "Via2" 18.665 1.935 18.735 2.005)
rect(cv "Metal2" 18.635 1.93 18.765 2.01)
rect(cv "Metal3" 18.66 1.905 18.74 2.035)
rect(cv "Via1" 18.665 3.955 18.735 4.025)
rect(cv "Metal1" 18.635 3.95 18.765 4.03)
rect(cv "Metal2" 18.575 3.945 18.825 4.035)
rect(cv "Via2" 18.665 3.955 18.735 4.025)
rect(cv "Metal2" 18.635 3.95 18.765 4.03)
rect(cv "Metal3" 18.66 3.925 18.74 4.055)
rect(cv "Via1" 18.665 5.975 18.735 6.045)
rect(cv "Metal1" 18.635 5.97 18.765 6.05)
rect(cv "Metal2" 18.575 5.965 18.825 6.055)
rect(cv "Via2" 18.665 5.975 18.735 6.045)
rect(cv "Metal2" 18.635 5.97 18.765 6.05)
rect(cv "Metal3" 18.66 5.945 18.74 6.075)
rect(cv "Via1" 18.665 7.995 18.735 8.065)
rect(cv "Metal1" 18.635 7.99 18.765 8.07)
rect(cv "Metal2" 18.575 7.985 18.825 8.075)
rect(cv "Via2" 18.665 7.995 18.735 8.065)
rect(cv "Metal2" 18.635 7.99 18.765 8.07)
rect(cv "Metal3" 18.66 7.965 18.74 8.095)
rect(cv "Metal3" 18.66 1.93 18.74 10.4)
rect(cv "Via2" 18.665 10.325 18.735 10.395)
rect(cv "Metal2" 18.635 10.32 18.765 10.4)
rect(cv "Metal3" 18.66 10.295 18.74 10.425)
rect(cv "Via1" 18.475 0.685 18.545 0.755)
rect(cv "Metal1" 18.445 0.68 18.575 0.76)
rect(cv "Metal2" 18.385 0.675 18.635 0.765)
rect(cv "Via2" 18.475 0.685 18.545 0.755)
rect(cv "Metal2" 18.445 0.68 18.575 0.76)
rect(cv "Metal3" 18.47 0.655 18.55 0.785)
rect(cv "Via1" 18.475 2.705 18.545 2.775)
rect(cv "Metal1" 18.445 2.7 18.575 2.78)
rect(cv "Metal2" 18.385 2.695 18.635 2.785)
rect(cv "Via2" 18.475 2.705 18.545 2.775)
rect(cv "Metal2" 18.445 2.7 18.575 2.78)
rect(cv "Metal3" 18.47 2.675 18.55 2.805)
rect(cv "Via1" 18.475 4.725 18.545 4.795)
rect(cv "Metal1" 18.445 4.72 18.575 4.8)
rect(cv "Metal2" 18.385 4.715 18.635 4.805)
rect(cv "Via2" 18.475 4.725 18.545 4.795)
rect(cv "Metal2" 18.445 4.72 18.575 4.8)
rect(cv "Metal3" 18.47 4.695 18.55 4.825)
rect(cv "Via1" 18.475 6.745 18.545 6.815)
rect(cv "Metal1" 18.445 6.74 18.575 6.82)
rect(cv "Metal2" 18.385 6.735 18.635 6.825)
rect(cv "Via2" 18.475 6.745 18.545 6.815)
rect(cv "Metal2" 18.445 6.74 18.575 6.82)
rect(cv "Metal3" 18.47 6.715 18.55 6.845)
rect(cv "Metal3" 18.47 0.68 18.55 10.56)
rect(cv "Via2" 18.475 10.485 18.545 10.555)
rect(cv "Metal2" 18.445 10.48 18.575 10.56)
rect(cv "Metal3" 18.47 10.455 18.55 10.585)
rect(cv "Metal3" 0.18 0.385 0.32 11.01)
port(cv "WL0" "Metal3" 0.25 10.94)
rect(cv "Metal3" 0.5 2.405 0.64 11.01)
port(cv "WL1" "Metal3" 0.57 10.94)
rect(cv "Metal3" 0.82 4.425 0.96 11.01)
port(cv "WL2" "Metal3" 0.89 10.94)
rect(cv "Metal3" 1.14 6.445 1.28 11.01)
port(cv "WL3" "Metal3" 1.21 10.94)
rect(cv "Metal2" 1.49 8.4 8.34 8.48)
rect(cv "Via2" 1.495 8.405 1.565 8.475)
rect(cv "Metal2" 1.465 8.4 1.595 8.48)
rect(cv "Metal3" 1.49 8.375 1.57 8.505)
rect(cv "Metal3" 1.46 8.37 1.6 11.01)
port(cv "BL0" "Metal3" 1.53 10.94)
rect(cv "Metal2" 1.81 8.56 10.64 8.64)
rect(cv "Via2" 1.815 8.565 1.885 8.635)
rect(cv "Metal2" 1.785 8.56 1.915 8.64)
rect(cv "Metal3" 1.81 8.535 1.89 8.665)
rect(cv "Metal3" 1.78 8.53 1.92 11.01)
port(cv "BL1" "Metal3" 1.85 10.94)
rect(cv "Metal2" 2.13 8.72 12.94 8.8)
rect(cv "Via2" 2.135 8.725 2.205 8.795)
rect(cv "Metal2" 2.105 8.72 2.235 8.8)
rect(cv "Metal3" 2.13 8.695 2.21 8.825)
rect(cv "Metal3" 2.1 8.69 2.24 11.01)
port(cv "BL2" "Metal3" 2.17 10.94)
rect(cv "Metal2" 2.45 8.88 15.24 8.96)
rect(cv "Via2" 2.455 8.885 2.525 8.955)
rect(cv "Metal2" 2.425 8.88 2.555 8.96)
rect(cv "Metal3" 2.45 8.855 2.53 8.985)
rect(cv "Metal3" 2.42 8.85 2.56 11.01)
port(cv "BL3" "Metal3" 2.49 10.94)
rect(cv "Metal2" 2.77 9.04 17.54 9.12)
rect(cv "Via2" 2.775 9.045 2.845 9.115)
rect(cv "Metal2" 2.745 9.04 2.875 9.12)
rect(cv "Metal3" 2.77 9.015 2.85 9.145)
rect(cv "Metal3" 2.74 9.01 2.88 11.01)
port(cv "BL4" "Metal3" 2.81 10.94)
rect(cv "Metal2" 3.09 9.2 19.84 9.28)
rect(cv "Via2" 3.095 9.205 3.165 9.275)
rect(cv "Metal2" 3.065 9.2 3.195 9.28)
rect(cv "Metal3" 3.09 9.175 3.17 9.305)
rect(cv "Metal3" 3.06 9.17 3.2 11.01)
port(cv "BL5" "Metal3" 3.13 10.94)
rect(cv "Metal2" 3.41 9.36 6.485 9.44)
rect(cv "Via2" 3.415 9.365 3.485 9.435)
rect(cv "Metal2" 3.385 9.36 3.515 9.44)
rect(cv "Metal3" 3.41 9.335 3.49 9.465)
rect(cv "Metal3" 3.38 9.33 3.52 11.01)
port(cv "BLB0" "Metal3" 3.45 10.94)
rect(cv "Metal2" 3.73 9.52 8.785 9.6)
rect(cv "Via2" 3.735 9.525 3.805 9.595)
rect(cv "Metal2" 3.705 9.52 3.835 9.6)
rect(cv "Metal3" 3.73 9.495 3.81 9.625)
rect(cv "Metal3" 3.7 9.49 3.84 11.01)
port(cv "BLB1" "Metal3" 3.77 10.94)
rect(cv "Metal2" 4.05 9.68 11.085 9.76)
rect(cv "Via2" 4.055 9.685 4.125 9.755)
rect(cv "Metal2" 4.025 9.68 4.155 9.76)
rect(cv "Metal3" 4.05 9.655 4.13 9.785)
rect(cv "Metal3" 4.02 9.65 4.16 11.01)
port(cv "BLB2" "Metal3" 4.09 10.94)
rect(cv "Metal2" 4.37 9.84 13.385 9.92)
rect(cv "Via2" 4.375 9.845 4.445 9.915)
rect(cv "Metal2" 4.345 9.84 4.475 9.92)
rect(cv "Metal3" 4.37 9.815 4.45 9.945)
rect(cv "Metal3" 4.34 9.81 4.48 11.01)
port(cv "BLB3" "Metal3" 4.41 10.94)
rect(cv "Metal2" 4.69 10 15.685 10.08)
rect(cv "Via2" 4.695 10.005 4.765 10.075)
rect(cv "Metal2" 4.665 10 4.795 10.08)
rect(cv "Metal3" 4.69 9.975 4.77 10.105)
rect(cv "Metal3" 4.66 9.97 4.8 11.01)
port(cv "BLB4" "Metal3" 4.73 10.94)
rect(cv "Metal2" 5.01 10.16 17.985 10.24)
rect(cv "Via2" 5.015 10.165 5.085 10.235)
rect(cv "Metal2" 4.985 10.16 5.115 10.24)
rect(cv "Metal3" 5.01 10.135 5.09 10.265)
rect(cv "Metal3" 4.98 10.13 5.12 11.01)
port(cv "BLB5" "Metal3" 5.05 10.94)
rect(cv "Metal2" 5.33 10.32 18.74 10.4)
rect(cv "Via2" 5.335 10.325 5.405 10.395)
rect(cv "Metal2" 5.305 10.32 5.435 10.4)
rect(cv "Metal3" 5.33 10.295 5.41 10.425)
rect(cv "Metal3" 5.3 10.29 5.44 11.01)
port(cv "VDD" "Metal3" 5.37 10.94)
rect(cv "Metal2" 5.65 10.48 18.55 10.56)
rect(cv "Via2" 5.655 10.485 5.725 10.555)
rect(cv "Metal2" 5.625 10.48 5.755 10.56)
rect(cv "Metal3" 5.65 10.455 5.73 10.585)
rect(cv "Metal3" 5.62 10.45 5.76 11.01)
port(cv "GND" "Metal3" 5.69 10.94)
rect(cv "prBoundary" 0.0 0.0 20.11 11.02)
dbSave(cv) printf("LAYOUT bit_array %L\n" cv~>bBox) dbClose(cv)
cv=dbOpenCellViewByType("sram_project" "read_latch" "layout" "maskLayout" "w")
dbCreateInst(cv dbOpenCellViewByType("sram_project" "tg" "layout" "" "r") "INPUT" list(2.47 0.35) "R0")
dbCreateInst(cv dbOpenCellViewByType("sram_project" "inv" "layout" "" "r") "I0" list(6.74 0.35) "R0")
dbCreateInst(cv dbOpenCellViewByType("sram_project" "inv" "layout" "" "r") "I1" list(10.37 0.35) "R0")
dbCreateInst(cv dbOpenCellViewByType("sram_project" "tg" "layout" "" "r") "FEEDBACK" list(14 0.35) "R0")
rect(cv "Via3" 2.685 5.285 2.755 5.355)
rect(cv "Metal3" 2.675 5.195 2.765 5.445)
rect(cv "Metal4" 2.595 5.275 2.845 5.365)
rect(cv "Via4" 2.685 5.285 2.755 5.355)
rect(cv "Metal4" 2.595 5.275 2.845 5.365)
rect(cv "Metal5" 2.675 5.195 2.765 5.445)
rect(cv "Metal5" 2.68 5.28 2.76 5.84)
rect(cv "Via4" 2.685 5.765 2.755 5.835)
rect(cv "Metal4" 2.595 5.755 2.845 5.845)
rect(cv "Metal5" 2.675 5.675 2.765 5.925)
rect(cv "Via3" 3.005 5.285 3.075 5.355)
rect(cv "Metal3" 2.995 5.195 3.085 5.445)
rect(cv "Metal4" 2.915 5.275 3.165 5.365)
rect(cv "Via4" 3.005 5.285 3.075 5.355)
rect(cv "Metal4" 2.915 5.275 3.165 5.365)
rect(cv "Metal5" 2.995 5.195 3.085 5.445)
rect(cv "Metal5" 3 5.28 3.08 6.8)
rect(cv "Via4" 3.005 6.725 3.075 6.795)
rect(cv "Metal4" 2.915 6.715 3.165 6.805)
rect(cv "Metal5" 2.995 6.635 3.085 6.885)
rect(cv "Via3" 3.325 5.285 3.395 5.355)
rect(cv "Metal3" 3.315 5.195 3.405 5.445)
rect(cv "Metal4" 3.235 5.275 3.485 5.365)
rect(cv "Via4" 3.325 5.285 3.395 5.355)
rect(cv "Metal4" 3.235 5.275 3.485 5.365)
rect(cv "Metal5" 3.315 5.195 3.405 5.445)
rect(cv "Metal5" 3.32 5.28 3.4 6)
rect(cv "Via4" 3.325 5.925 3.395 5.995)
rect(cv "Metal4" 3.235 5.915 3.485 6.005)
rect(cv "Metal5" 3.315 5.835 3.405 6.085)
rect(cv "Via3" 3.645 5.285 3.715 5.355)
rect(cv "Metal3" 3.635 5.195 3.725 5.445)
rect(cv "Metal4" 3.555 5.275 3.805 5.365)
rect(cv "Via4" 3.645 5.285 3.715 5.355)
rect(cv "Metal4" 3.555 5.275 3.805 5.365)
rect(cv "Metal5" 3.635 5.195 3.725 5.445)
rect(cv "Metal5" 3.64 5.28 3.72 6.16)
rect(cv "Via4" 3.645 6.085 3.715 6.155)
rect(cv "Metal4" 3.555 6.075 3.805 6.165)
rect(cv "Metal5" 3.635 5.995 3.725 6.245)
rect(cv "Via3" 3.965 5.285 4.035 5.355)
rect(cv "Metal3" 3.955 5.195 4.045 5.445)
rect(cv "Metal4" 3.875 5.275 4.125 5.365)
rect(cv "Via4" 3.965 5.285 4.035 5.355)
rect(cv "Metal4" 3.875 5.275 4.125 5.365)
rect(cv "Metal5" 3.955 5.195 4.045 5.445)
rect(cv "Metal5" 3.96 5.28 4.04 6.48)
rect(cv "Via4" 3.965 6.405 4.035 6.475)
rect(cv "Metal4" 3.875 6.395 4.125 6.485)
rect(cv "Metal5" 3.955 6.315 4.045 6.565)
rect(cv "Via3" 4.285 5.285 4.355 5.355)
rect(cv "Metal3" 4.275 5.195 4.365 5.445)
rect(cv "Metal4" 4.195 5.275 4.445 5.365)
rect(cv "Via4" 4.285 5.285 4.355 5.355)
rect(cv "Metal4" 4.195 5.275 4.445 5.365)
rect(cv "Metal5" 4.275 5.195 4.365 5.445)
rect(cv "Metal5" 4.28 5.28 4.36 6.64)
rect(cv "Via4" 4.285 6.565 4.355 6.635)
rect(cv "Metal4" 4.195 6.555 4.445 6.645)
rect(cv "Metal5" 4.275 6.475 4.365 6.725)
rect(cv "Via3" 6.955 3.845 7.025 3.915)
rect(cv "Metal3" 6.945 3.755 7.035 4.005)
rect(cv "Metal4" 6.865 3.835 7.115 3.925)
rect(cv "Via4" 6.955 3.845 7.025 3.915)
rect(cv "Metal4" 6.865 3.835 7.115 3.925)
rect(cv "Metal5" 6.945 3.755 7.035 4.005)
rect(cv "Metal5" 6.95 3.84 7.03 6.8)
rect(cv "Via4" 6.955 6.725 7.025 6.795)
rect(cv "Metal4" 6.865 6.715 7.115 6.805)
rect(cv "Metal5" 6.945 6.635 7.035 6.885)
rect(cv "Via3" 7.275 3.845 7.345 3.915)
rect(cv "Metal3" 7.265 3.755 7.355 4.005)
rect(cv "Metal4" 7.185 3.835 7.435 3.925)
rect(cv "Via4" 7.275 3.845 7.345 3.915)
rect(cv "Metal4" 7.185 3.835 7.435 3.925)
rect(cv "Metal5" 7.265 3.755 7.355 4.005)
rect(cv "Metal5" 7.27 3.84 7.35 6.96)
rect(cv "Via4" 7.275 6.885 7.345 6.955)
rect(cv "Metal4" 7.185 6.875 7.435 6.965)
rect(cv "Metal5" 7.265 6.795 7.355 7.045)
rect(cv "Via3" 7.595 3.845 7.665 3.915)
rect(cv "Metal3" 7.585 3.755 7.675 4.005)
rect(cv "Metal4" 7.505 3.835 7.755 3.925)
rect(cv "Via4" 7.595 3.845 7.665 3.915)
rect(cv "Metal4" 7.505 3.835 7.755 3.925)
rect(cv "Metal5" 7.585 3.755 7.675 4.005)
rect(cv "Metal5" 7.59 3.84 7.67 6.48)
rect(cv "Via4" 7.595 6.405 7.665 6.475)
rect(cv "Metal4" 7.505 6.395 7.755 6.485)
rect(cv "Metal5" 7.585 6.315 7.675 6.565)
rect(cv "Via3" 7.915 3.845 7.985 3.915)
rect(cv "Metal3" 7.905 3.755 7.995 4.005)
rect(cv "Metal4" 7.825 3.835 8.075 3.925)
rect(cv "Via4" 7.915 3.845 7.985 3.915)
rect(cv "Metal4" 7.825 3.835 8.075 3.925)
rect(cv "Metal5" 7.905 3.755 7.995 4.005)
rect(cv "Metal5" 7.91 3.84 7.99 6.64)
rect(cv "Via4" 7.915 6.565 7.985 6.635)
rect(cv "Metal4" 7.825 6.555 8.075 6.645)
rect(cv "Metal5" 7.905 6.475 7.995 6.725)
rect(cv "Via3" 10.585 3.845 10.655 3.915)
rect(cv "Metal3" 10.575 3.755 10.665 4.005)
rect(cv "Metal4" 10.495 3.835 10.745 3.925)
rect(cv "Via4" 10.585 3.845 10.655 3.915)
rect(cv "Metal4" 10.495 3.835 10.745 3.925)
rect(cv "Metal5" 10.575 3.755 10.665 4.005)
rect(cv "Metal5" 10.58 3.84 10.66 6.96)
rect(cv "Via4" 10.585 6.885 10.655 6.955)
rect(cv "Metal4" 10.495 6.875 10.745 6.965)
rect(cv "Metal5" 10.575 6.795 10.665 7.045)
rect(cv "Via3" 10.905 3.845 10.975 3.915)
rect(cv "Metal3" 10.895 3.755 10.985 4.005)
rect(cv "Metal4" 10.815 3.835 11.065 3.925)
rect(cv "Via4" 10.905 3.845 10.975 3.915)
rect(cv "Metal4" 10.815 3.835 11.065 3.925)
rect(cv "Metal5" 10.895 3.755 10.985 4.005)
rect(cv "Metal5" 10.9 3.84 10.98 6.32)
rect(cv "Via4" 10.905 6.245 10.975 6.315)
rect(cv "Metal4" 10.815 6.235 11.065 6.325)
rect(cv "Metal5" 10.895 6.155 10.985 6.405)
rect(cv "Via3" 11.225 3.845 11.295 3.915)
rect(cv "Metal3" 11.215 3.755 11.305 4.005)
rect(cv "Metal4" 11.135 3.835 11.385 3.925)
rect(cv "Via4" 11.225 3.845 11.295 3.915)
rect(cv "Metal4" 11.135 3.835 11.385 3.925)
rect(cv "Metal5" 11.215 3.755 11.305 4.005)
rect(cv "Metal5" 11.22 3.84 11.3 6.48)
rect(cv "Via4" 11.225 6.405 11.295 6.475)
rect(cv "Metal4" 11.135 6.395 11.385 6.485)
rect(cv "Metal5" 11.215 6.315 11.305 6.565)
rect(cv "Via3" 11.545 3.845 11.615 3.915)
rect(cv "Metal3" 11.535 3.755 11.625 4.005)
rect(cv "Metal4" 11.455 3.835 11.705 3.925)
rect(cv "Via4" 11.545 3.845 11.615 3.915)
rect(cv "Metal4" 11.455 3.835 11.705 3.925)
rect(cv "Metal5" 11.535 3.755 11.625 4.005)
rect(cv "Metal5" 11.54 3.84 11.62 6.64)
rect(cv "Via4" 11.545 6.565 11.615 6.635)
rect(cv "Metal4" 11.455 6.555 11.705 6.645)
rect(cv "Metal5" 11.535 6.475 11.625 6.725)
rect(cv "Via3" 14.215 5.285 14.285 5.355)
rect(cv "Metal3" 14.205 5.195 14.295 5.445)
rect(cv "Metal4" 14.125 5.275 14.375 5.365)
rect(cv "Via4" 14.215 5.285 14.285 5.355)
rect(cv "Metal4" 14.125 5.275 14.375 5.365)
rect(cv "Metal5" 14.205 5.195 14.295 5.445)
rect(cv "Metal5" 14.21 5.28 14.29 6.32)
rect(cv "Via4" 14.215 6.245 14.285 6.315)
rect(cv "Metal4" 14.125 6.235 14.375 6.325)
rect(cv "Metal5" 14.205 6.155 14.295 6.405)
rect(cv "Via3" 14.535 5.285 14.605 5.355)
rect(cv "Metal3" 14.525 5.195 14.615 5.445)
rect(cv "Metal4" 14.445 5.275 14.695 5.365)
rect(cv "Via4" 14.535 5.285 14.605 5.355)
rect(cv "Metal4" 14.445 5.275 14.695 5.365)
rect(cv "Metal5" 14.525 5.195 14.615 5.445)
rect(cv "Metal5" 14.53 5.28 14.61 6.8)
rect(cv "Via4" 14.535 6.725 14.605 6.795)
rect(cv "Metal4" 14.445 6.715 14.695 6.805)
rect(cv "Metal5" 14.525 6.635 14.615 6.885)
rect(cv "Via3" 14.855 5.285 14.925 5.355)
rect(cv "Metal3" 14.845 5.195 14.935 5.445)
rect(cv "Metal4" 14.765 5.275 15.015 5.365)
rect(cv "Via4" 14.855 5.285 14.925 5.355)
rect(cv "Metal4" 14.765 5.275 15.015 5.365)
rect(cv "Metal5" 14.845 5.195 14.935 5.445)
rect(cv "Metal5" 14.85 5.28 14.93 6.16)
rect(cv "Via4" 14.855 6.085 14.925 6.155)
rect(cv "Metal4" 14.765 6.075 15.015 6.165)
rect(cv "Metal5" 14.845 5.995 14.935 6.245)
rect(cv "Via3" 15.175 5.285 15.245 5.355)
rect(cv "Metal3" 15.165 5.195 15.255 5.445)
rect(cv "Metal4" 15.085 5.275 15.335 5.365)
rect(cv "Via4" 15.175 5.285 15.245 5.355)
rect(cv "Metal4" 15.085 5.275 15.335 5.365)
rect(cv "Metal5" 15.165 5.195 15.255 5.445)
rect(cv "Metal5" 15.17 5.28 15.25 6)
rect(cv "Via4" 15.175 5.925 15.245 5.995)
rect(cv "Metal4" 15.085 5.915 15.335 6.005)
rect(cv "Metal5" 15.165 5.835 15.255 6.085)
rect(cv "Via3" 15.495 5.285 15.565 5.355)
rect(cv "Metal3" 15.485 5.195 15.575 5.445)
rect(cv "Metal4" 15.405 5.275 15.655 5.365)
rect(cv "Via4" 15.495 5.285 15.565 5.355)
rect(cv "Metal4" 15.405 5.275 15.655 5.365)
rect(cv "Metal5" 15.485 5.195 15.575 5.445)
rect(cv "Metal5" 15.49 5.28 15.57 6.48)
rect(cv "Via4" 15.495 6.405 15.565 6.475)
rect(cv "Metal4" 15.405 6.395 15.655 6.485)
rect(cv "Metal5" 15.485 6.315 15.575 6.565)
rect(cv "Via3" 15.815 5.285 15.885 5.355)
rect(cv "Metal3" 15.805 5.195 15.895 5.445)
rect(cv "Metal4" 15.725 5.275 15.975 5.365)
rect(cv "Via4" 15.815 5.285 15.885 5.355)
rect(cv "Metal4" 15.725 5.275 15.975 5.365)
rect(cv "Metal5" 15.805 5.195 15.895 5.445)
rect(cv "Metal5" 15.81 5.28 15.89 6.64)
rect(cv "Via4" 15.815 6.565 15.885 6.635)
rect(cv "Metal4" 15.725 6.555 15.975 6.645)
rect(cv "Metal5" 15.805 6.475 15.895 6.725)
rect(cv "Metal4" 0.21 5.76 2.76 5.84)
rect(cv "Via3" 0.215 5.765 0.285 5.835)
rect(cv "Metal3" 0.205 5.675 0.295 5.925)
rect(cv "Metal4" 0.125 5.755 0.375 5.845)
rect(cv "Metal3" 0.18 5.73 0.32 7.41)
port(cv "D" "Metal3" 0.25 7.34)
rect(cv "Metal4" 0.53 5.92 15.25 6)
rect(cv "Via3" 0.535 5.925 0.605 5.995)
rect(cv "Metal3" 0.525 5.835 0.615 6.085)
rect(cv "Metal4" 0.445 5.915 0.695 6.005)
rect(cv "Metal3" 0.5 5.89 0.64 7.41)
port(cv "EN" "Metal3" 0.57 7.34)
rect(cv "Metal4" 0.85 6.08 14.93 6.16)
rect(cv "Via3" 0.855 6.085 0.925 6.155)
rect(cv "Metal3" 0.845 5.995 0.935 6.245)
rect(cv "Metal4" 0.765 6.075 1.015 6.165)
rect(cv "Metal3" 0.82 6.05 0.96 7.41)
port(cv "ENB" "Metal3" 0.89 7.34)
rect(cv "Metal4" 1.17 6.24 14.29 6.32)
rect(cv "Via3" 1.175 6.245 1.245 6.315)
rect(cv "Metal3" 1.165 6.155 1.255 6.405)
rect(cv "Metal4" 1.085 6.235 1.335 6.325)
rect(cv "Metal3" 1.14 6.21 1.28 7.41)
port(cv "Q" "Metal3" 1.21 7.34)
rect(cv "Metal4" 1.49 6.4 15.57 6.48)
rect(cv "Via3" 1.495 6.405 1.565 6.475)
rect(cv "Metal3" 1.485 6.315 1.575 6.565)
rect(cv "Metal4" 1.405 6.395 1.655 6.485)
rect(cv "Metal3" 1.46 6.37 1.6 7.41)
port(cv "VDD" "Metal3" 1.53 7.34)
rect(cv "Metal4" 1.81 6.56 15.89 6.64)
rect(cv "Via3" 1.815 6.565 1.885 6.635)
rect(cv "Metal3" 1.805 6.475 1.895 6.725)
rect(cv "Metal4" 1.725 6.555 1.975 6.645)
rect(cv "Metal3" 1.78 6.53 1.92 7.41)
port(cv "GND" "Metal3" 1.85 7.34)
rect(cv "Metal4" 3 6.72 14.61 6.8)
rect(cv "Metal4" 7.27 6.88 10.66 6.96)
rect(cv "prBoundary" 0.0 0.0 18.27 7.42)
dbSave(cv) printf("LAYOUT read_latch %L\n" cv~>bBox) dbClose(cv)
cv=dbOpenCellViewByType("sram_project" "row_decoder" "layout" "maskLayout" "w")
dbCreateInst(cv dbOpenCellViewByType("sram_project" "inv" "layout" "" "r") "I0" list(3.43 0.35) "R0")
dbCreateInst(cv dbOpenCellViewByType("sram_project" "inv" "layout" "" "r") "I1" list(7.06 0.35) "R0")
dbCreateInst(cv dbOpenCellViewByType("sram_project" "and3" "layout" "" "r") "R0" list(10.69 0.35) "R0")
dbCreateInst(cv dbOpenCellViewByType("sram_project" "and3" "layout" "" "r") "R1" list(18.02 0.35) "R0")
dbCreateInst(cv dbOpenCellViewByType("sram_project" "and3" "layout" "" "r") "R2" list(25.35 0.35) "R0")
dbCreateInst(cv dbOpenCellViewByType("sram_project" "and3" "layout" "" "r") "R3" list(32.68 0.35) "R0")
rect(cv "Via3" 3.645 3.845 3.715 3.915)
rect(cv "Metal3" 3.635 3.755 3.725 4.005)
rect(cv "Metal4" 3.555 3.835 3.805 3.925)
rect(cv "Via4" 3.645 3.845 3.715 3.915)
rect(cv "Metal4" 3.555 3.835 3.805 3.925)
rect(cv "Metal5" 3.635 3.755 3.725 4.005)
rect(cv "Metal5" 3.64 3.84 3.72 8.16)
rect(cv "Via4" 3.645 8.085 3.715 8.155)
rect(cv "Metal4" 3.555 8.075 3.805 8.165)
rect(cv "Metal5" 3.635 7.995 3.725 8.245)
rect(cv "Via3" 3.965 3.845 4.035 3.915)
rect(cv "Metal3" 3.955 3.755 4.045 4.005)
rect(cv "Metal4" 3.875 3.835 4.125 3.925)
rect(cv "Via4" 3.965 3.845 4.035 3.915)
rect(cv "Metal4" 3.875 3.835 4.125 3.925)
rect(cv "Metal5" 3.955 3.755 4.045 4.005)
rect(cv "Metal5" 3.96 3.84 4.04 9.44)
rect(cv "Via4" 3.965 9.365 4.035 9.435)
rect(cv "Metal4" 3.875 9.355 4.125 9.445)
rect(cv "Metal5" 3.955 9.275 4.045 9.525)
rect(cv "Via3" 4.285 3.845 4.355 3.915)
rect(cv "Metal3" 4.275 3.755 4.365 4.005)
rect(cv "Metal4" 4.195 3.835 4.445 3.925)
rect(cv "Via4" 4.285 3.845 4.355 3.915)
rect(cv "Metal4" 4.195 3.835 4.445 3.925)
rect(cv "Metal5" 4.275 3.755 4.365 4.005)
rect(cv "Metal5" 4.28 3.84 4.36 9.12)
rect(cv "Via4" 4.285 9.045 4.355 9.115)
rect(cv "Metal4" 4.195 9.035 4.445 9.125)
rect(cv "Metal5" 4.275 8.955 4.365 9.205)
rect(cv "Via3" 4.605 3.845 4.675 3.915)
rect(cv "Metal3" 4.595 3.755 4.685 4.005)
rect(cv "Metal4" 4.515 3.835 4.765 3.925)
rect(cv "Via4" 4.605 3.845 4.675 3.915)
rect(cv "Metal4" 4.515 3.835 4.765 3.925)
rect(cv "Metal5" 4.595 3.755 4.685 4.005)
rect(cv "Metal5" 4.6 3.84 4.68 9.28)
rect(cv "Via4" 4.605 9.205 4.675 9.275)
rect(cv "Metal4" 4.515 9.195 4.765 9.285)
rect(cv "Metal5" 4.595 9.115 4.685 9.365)
rect(cv "Via3" 7.275 3.845 7.345 3.915)
rect(cv "Metal3" 7.265 3.755 7.355 4.005)
rect(cv "Metal4" 7.185 3.835 7.435 3.925)
rect(cv "Via4" 7.275 3.845 7.345 3.915)
rect(cv "Metal4" 7.185 3.835 7.435 3.925)
rect(cv "Metal5" 7.265 3.755 7.355 4.005)
rect(cv "Metal5" 7.27 3.84 7.35 8)
rect(cv "Via4" 7.275 7.925 7.345 7.995)
rect(cv "Metal4" 7.185 7.915 7.435 8.005)
rect(cv "Metal5" 7.265 7.835 7.355 8.085)
rect(cv "Via3" 7.595 3.845 7.665 3.915)
rect(cv "Metal3" 7.585 3.755 7.675 4.005)
rect(cv "Metal4" 7.505 3.835 7.755 3.925)
rect(cv "Via4" 7.595 3.845 7.665 3.915)
rect(cv "Metal4" 7.505 3.835 7.755 3.925)
rect(cv "Metal5" 7.585 3.755 7.675 4.005)
rect(cv "Metal5" 7.59 3.84 7.67 9.6)
rect(cv "Via4" 7.595 9.525 7.665 9.595)
rect(cv "Metal4" 7.505 9.515 7.755 9.605)
rect(cv "Metal5" 7.585 9.435 7.675 9.685)
rect(cv "Via3" 7.915 3.845 7.985 3.915)
rect(cv "Metal3" 7.905 3.755 7.995 4.005)
rect(cv "Metal4" 7.825 3.835 8.075 3.925)
rect(cv "Via4" 7.915 3.845 7.985 3.915)
rect(cv "Metal4" 7.825 3.835 8.075 3.925)
rect(cv "Metal5" 7.905 3.755 7.995 4.005)
rect(cv "Metal5" 7.91 3.84 7.99 9.12)
rect(cv "Via4" 7.915 9.045 7.985 9.115)
rect(cv "Metal4" 7.825 9.035 8.075 9.125)
rect(cv "Metal5" 7.905 8.955 7.995 9.205)
rect(cv "Via3" 8.235 3.845 8.305 3.915)
rect(cv "Metal3" 8.225 3.755 8.315 4.005)
rect(cv "Metal4" 8.145 3.835 8.395 3.925)
rect(cv "Via4" 8.235 3.845 8.305 3.915)
rect(cv "Metal4" 8.145 3.835 8.395 3.925)
rect(cv "Metal5" 8.225 3.755 8.315 4.005)
rect(cv "Metal5" 8.23 3.84 8.31 9.28)
rect(cv "Via4" 8.235 9.205 8.305 9.275)
rect(cv "Metal4" 8.145 9.195 8.395 9.285)
rect(cv "Metal5" 8.225 9.115 8.315 9.365)
rect(cv "Via3" 10.905 7.445 10.975 7.515)
rect(cv "Metal3" 10.895 7.355 10.985 7.605)
rect(cv "Metal4" 10.815 7.435 11.065 7.525)
rect(cv "Via4" 10.905 7.445 10.975 7.515)
rect(cv "Metal4" 10.815 7.435 11.065 7.525)
rect(cv "Metal5" 10.895 7.355 10.985 7.605)
rect(cv "Metal5" 10.9 7.44 10.98 9.6)
rect(cv "Via4" 10.905 9.525 10.975 9.595)
rect(cv "Metal4" 10.815 9.515 11.065 9.605)
rect(cv "Metal5" 10.895 9.435 10.985 9.685)
rect(cv "Via3" 11.225 7.445 11.295 7.515)
rect(cv "Metal3" 11.215 7.355 11.305 7.605)
rect(cv "Metal4" 11.135 7.435 11.385 7.525)
rect(cv "Via4" 11.225 7.445 11.295 7.515)
rect(cv "Metal4" 11.135 7.435 11.385 7.525)
rect(cv "Metal5" 11.215 7.355 11.305 7.605)
rect(cv "Metal5" 11.22 7.44 11.3 9.44)
rect(cv "Via4" 11.225 9.365 11.295 9.435)
rect(cv "Metal4" 11.135 9.355 11.385 9.445)
rect(cv "Metal5" 11.215 9.275 11.305 9.525)
rect(cv "Via3" 11.545 7.445 11.615 7.515)
rect(cv "Metal3" 11.535 7.355 11.625 7.605)
rect(cv "Metal4" 11.455 7.435 11.705 7.525)
rect(cv "Via4" 11.545 7.445 11.615 7.515)
rect(cv "Metal4" 11.455 7.435 11.705 7.525)
rect(cv "Metal5" 11.535 7.355 11.625 7.605)
rect(cv "Metal5" 11.54 7.44 11.62 8.32)
rect(cv "Via4" 11.545 8.245 11.615 8.315)
rect(cv "Metal4" 11.455 8.235 11.705 8.325)
rect(cv "Metal5" 11.535 8.155 11.625 8.405)
rect(cv "Via3" 11.865 7.445 11.935 7.515)
rect(cv "Metal3" 11.855 7.355 11.945 7.605)
rect(cv "Metal4" 11.775 7.435 12.025 7.525)
rect(cv "Via4" 11.865 7.445 11.935 7.515)
rect(cv "Metal4" 11.775 7.435 12.025 7.525)
rect(cv "Metal5" 11.855 7.355 11.945 7.605)
rect(cv "Metal5" 11.86 7.44 11.94 8.48)
rect(cv "Via4" 11.865 8.405 11.935 8.475)
rect(cv "Metal4" 11.775 8.395 12.025 8.485)
rect(cv "Metal5" 11.855 8.315 11.945 8.565)
rect(cv "Via3" 12.185 7.445 12.255 7.515)
rect(cv "Metal3" 12.175 7.355 12.265 7.605)
rect(cv "Metal4" 12.095 7.435 12.345 7.525)
rect(cv "Via4" 12.185 7.445 12.255 7.515)
rect(cv "Metal4" 12.095 7.435 12.345 7.525)
rect(cv "Metal5" 12.175 7.355 12.265 7.605)
rect(cv "Metal5" 12.18 7.44 12.26 9.12)
rect(cv "Via4" 12.185 9.045 12.255 9.115)
rect(cv "Metal4" 12.095 9.035 12.345 9.125)
rect(cv "Metal5" 12.175 8.955 12.265 9.205)
rect(cv "Via3" 12.505 7.445 12.575 7.515)
rect(cv "Metal3" 12.495 7.355 12.585 7.605)
rect(cv "Metal4" 12.415 7.435 12.665 7.525)
rect(cv "Via4" 12.505 7.445 12.575 7.515)
rect(cv "Metal4" 12.415 7.435 12.665 7.525)
rect(cv "Metal5" 12.495 7.355 12.585 7.605)
rect(cv "Metal5" 12.5 7.44 12.58 9.28)
rect(cv "Via4" 12.505 9.205 12.575 9.275)
rect(cv "Metal4" 12.415 9.195 12.665 9.285)
rect(cv "Metal5" 12.495 9.115 12.585 9.365)
rect(cv "Via3" 18.235 7.445 18.305 7.515)
rect(cv "Metal3" 18.225 7.355 18.315 7.605)
rect(cv "Metal4" 18.145 7.435 18.395 7.525)
rect(cv "Via4" 18.235 7.445 18.305 7.515)
rect(cv "Metal4" 18.145 7.435 18.395 7.525)
rect(cv "Metal5" 18.225 7.355 18.315 7.605)
rect(cv "Metal5" 18.23 7.44 18.31 9.6)
rect(cv "Via4" 18.235 9.525 18.305 9.595)
rect(cv "Metal4" 18.145 9.515 18.395 9.605)
rect(cv "Metal5" 18.225 9.435 18.315 9.685)
rect(cv "Via3" 18.555 7.445 18.625 7.515)
rect(cv "Metal3" 18.545 7.355 18.635 7.605)
rect(cv "Metal4" 18.465 7.435 18.715 7.525)
rect(cv "Via4" 18.555 7.445 18.625 7.515)
rect(cv "Metal4" 18.465 7.435 18.715 7.525)
rect(cv "Metal5" 18.545 7.355 18.635 7.605)
rect(cv "Metal5" 18.55 7.44 18.63 8.16)
rect(cv "Via4" 18.555 8.085 18.625 8.155)
rect(cv "Metal4" 18.465 8.075 18.715 8.165)
rect(cv "Metal5" 18.545 7.995 18.635 8.245)
rect(cv "Via3" 18.875 7.445 18.945 7.515)
rect(cv "Metal3" 18.865 7.355 18.955 7.605)
rect(cv "Metal4" 18.785 7.435 19.035 7.525)
rect(cv "Via4" 18.875 7.445 18.945 7.515)
rect(cv "Metal4" 18.785 7.435 19.035 7.525)
rect(cv "Metal5" 18.865 7.355 18.955 7.605)
rect(cv "Metal5" 18.87 7.44 18.95 8.32)
rect(cv "Via4" 18.875 8.245 18.945 8.315)
rect(cv "Metal4" 18.785 8.235 19.035 8.325)
rect(cv "Metal5" 18.865 8.155 18.955 8.405)
rect(cv "Via3" 19.195 7.445 19.265 7.515)
rect(cv "Metal3" 19.185 7.355 19.275 7.605)
rect(cv "Metal4" 19.105 7.435 19.355 7.525)
rect(cv "Via4" 19.195 7.445 19.265 7.515)
rect(cv "Metal4" 19.105 7.435 19.355 7.525)
rect(cv "Metal5" 19.185 7.355 19.275 7.605)
rect(cv "Metal5" 19.19 7.44 19.27 8.64)
rect(cv "Via4" 19.195 8.565 19.265 8.635)
rect(cv "Metal4" 19.105 8.555 19.355 8.645)
rect(cv "Metal5" 19.185 8.475 19.275 8.725)
rect(cv "Via3" 19.515 7.445 19.585 7.515)
rect(cv "Metal3" 19.505 7.355 19.595 7.605)
rect(cv "Metal4" 19.425 7.435 19.675 7.525)
rect(cv "Via4" 19.515 7.445 19.585 7.515)
rect(cv "Metal4" 19.425 7.435 19.675 7.525)
rect(cv "Metal5" 19.505 7.355 19.595 7.605)
rect(cv "Metal5" 19.51 7.44 19.59 9.12)
rect(cv "Via4" 19.515 9.045 19.585 9.115)
rect(cv "Metal4" 19.425 9.035 19.675 9.125)
rect(cv "Metal5" 19.505 8.955 19.595 9.205)
rect(cv "Via3" 19.835 7.445 19.905 7.515)
rect(cv "Metal3" 19.825 7.355 19.915 7.605)
rect(cv "Metal4" 19.745 7.435 19.995 7.525)
rect(cv "Via4" 19.835 7.445 19.905 7.515)
rect(cv "Metal4" 19.745 7.435 19.995 7.525)
rect(cv "Metal5" 19.825 7.355 19.915 7.605)
rect(cv "Metal5" 19.83 7.44 19.91 9.28)
rect(cv "Via4" 19.835 9.205 19.905 9.275)
rect(cv "Metal4" 19.745 9.195 19.995 9.285)
rect(cv "Metal5" 19.825 9.115 19.915 9.365)
rect(cv "Via3" 25.565 7.445 25.635 7.515)
rect(cv "Metal3" 25.555 7.355 25.645 7.605)
rect(cv "Metal4" 25.475 7.435 25.725 7.525)
rect(cv "Via4" 25.565 7.445 25.635 7.515)
rect(cv "Metal4" 25.475 7.435 25.725 7.525)
rect(cv "Metal5" 25.555 7.355 25.645 7.605)
rect(cv "Metal5" 25.56 7.44 25.64 8)
rect(cv "Via4" 25.565 7.925 25.635 7.995)
rect(cv "Metal4" 25.475 7.915 25.725 8.005)
rect(cv "Metal5" 25.555 7.835 25.645 8.085)
rect(cv "Via3" 25.885 7.445 25.955 7.515)
rect(cv "Metal3" 25.875 7.355 25.965 7.605)
rect(cv "Metal4" 25.795 7.435 26.045 7.525)
rect(cv "Via4" 25.885 7.445 25.955 7.515)
rect(cv "Metal4" 25.795 7.435 26.045 7.525)
rect(cv "Metal5" 25.875 7.355 25.965 7.605)
rect(cv "Metal5" 25.88 7.44 25.96 9.44)
rect(cv "Via4" 25.885 9.365 25.955 9.435)
rect(cv "Metal4" 25.795 9.355 26.045 9.445)
rect(cv "Metal5" 25.875 9.275 25.965 9.525)
rect(cv "Via3" 26.205 7.445 26.275 7.515)
rect(cv "Metal3" 26.195 7.355 26.285 7.605)
rect(cv "Metal4" 26.115 7.435 26.365 7.525)
rect(cv "Via4" 26.205 7.445 26.275 7.515)
rect(cv "Metal4" 26.115 7.435 26.365 7.525)
rect(cv "Metal5" 26.195 7.355 26.285 7.605)
rect(cv "Metal5" 26.2 7.44 26.28 8.32)
rect(cv "Via4" 26.205 8.245 26.275 8.315)
rect(cv "Metal4" 26.115 8.235 26.365 8.325)
rect(cv "Metal5" 26.195 8.155 26.285 8.405)
rect(cv "Via3" 26.525 7.445 26.595 7.515)
rect(cv "Metal3" 26.515 7.355 26.605 7.605)
rect(cv "Metal4" 26.435 7.435 26.685 7.525)
rect(cv "Via4" 26.525 7.445 26.595 7.515)
rect(cv "Metal4" 26.435 7.435 26.685 7.525)
rect(cv "Metal5" 26.515 7.355 26.605 7.605)
rect(cv "Metal5" 26.52 7.44 26.6 8.8)
rect(cv "Via4" 26.525 8.725 26.595 8.795)
rect(cv "Metal4" 26.435 8.715 26.685 8.805)
rect(cv "Metal5" 26.515 8.635 26.605 8.885)
rect(cv "Via3" 26.845 7.445 26.915 7.515)
rect(cv "Metal3" 26.835 7.355 26.925 7.605)
rect(cv "Metal4" 26.755 7.435 27.005 7.525)
rect(cv "Via4" 26.845 7.445 26.915 7.515)
rect(cv "Metal4" 26.755 7.435 27.005 7.525)
rect(cv "Metal5" 26.835 7.355 26.925 7.605)
rect(cv "Metal5" 26.84 7.44 26.92 9.12)
rect(cv "Via4" 26.845 9.045 26.915 9.115)
rect(cv "Metal4" 26.755 9.035 27.005 9.125)
rect(cv "Metal5" 26.835 8.955 26.925 9.205)
rect(cv "Via3" 27.165 7.445 27.235 7.515)
rect(cv "Metal3" 27.155 7.355 27.245 7.605)
rect(cv "Metal4" 27.075 7.435 27.325 7.525)
rect(cv "Via4" 27.165 7.445 27.235 7.515)
rect(cv "Metal4" 27.075 7.435 27.325 7.525)
rect(cv "Metal5" 27.155 7.355 27.245 7.605)
rect(cv "Metal5" 27.16 7.44 27.24 9.28)
rect(cv "Via4" 27.165 9.205 27.235 9.275)
rect(cv "Metal4" 27.075 9.195 27.325 9.285)
rect(cv "Metal5" 27.155 9.115 27.245 9.365)
rect(cv "Via3" 32.895 7.445 32.965 7.515)
rect(cv "Metal3" 32.885 7.355 32.975 7.605)
rect(cv "Metal4" 32.805 7.435 33.055 7.525)
rect(cv "Via4" 32.895 7.445 32.965 7.515)
rect(cv "Metal4" 32.805 7.435 33.055 7.525)
rect(cv "Metal5" 32.885 7.355 32.975 7.605)
rect(cv "Metal5" 32.89 7.44 32.97 8)
rect(cv "Via4" 32.895 7.925 32.965 7.995)
rect(cv "Metal4" 32.805 7.915 33.055 8.005)
rect(cv "Metal5" 32.885 7.835 32.975 8.085)
rect(cv "Via3" 33.215 7.445 33.285 7.515)
rect(cv "Metal3" 33.205 7.355 33.295 7.605)
rect(cv "Metal4" 33.125 7.435 33.375 7.525)
rect(cv "Via4" 33.215 7.445 33.285 7.515)
rect(cv "Metal4" 33.125 7.435 33.375 7.525)
rect(cv "Metal5" 33.205 7.355 33.295 7.605)
rect(cv "Metal5" 33.21 7.44 33.29 8.16)
rect(cv "Via4" 33.215 8.085 33.285 8.155)
rect(cv "Metal4" 33.125 8.075 33.375 8.165)
rect(cv "Metal5" 33.205 7.995 33.295 8.245)
rect(cv "Via3" 33.535 7.445 33.605 7.515)
rect(cv "Metal3" 33.525 7.355 33.615 7.605)
rect(cv "Metal4" 33.445 7.435 33.695 7.525)
rect(cv "Via4" 33.535 7.445 33.605 7.515)
rect(cv "Metal4" 33.445 7.435 33.695 7.525)
rect(cv "Metal5" 33.525 7.355 33.615 7.605)
rect(cv "Metal5" 33.53 7.44 33.61 8.32)
rect(cv "Via4" 33.535 8.245 33.605 8.315)
rect(cv "Metal4" 33.445 8.235 33.695 8.325)
rect(cv "Metal5" 33.525 8.155 33.615 8.405)
rect(cv "Via3" 33.855 7.445 33.925 7.515)
rect(cv "Metal3" 33.845 7.355 33.935 7.605)
rect(cv "Metal4" 33.765 7.435 34.015 7.525)
rect(cv "Via4" 33.855 7.445 33.925 7.515)
rect(cv "Metal4" 33.765 7.435 34.015 7.525)
rect(cv "Metal5" 33.845 7.355 33.935 7.605)
rect(cv "Metal5" 33.85 7.44 33.93 8.96)
rect(cv "Via4" 33.855 8.885 33.925 8.955)
rect(cv "Metal4" 33.765 8.875 34.015 8.965)
rect(cv "Metal5" 33.845 8.795 33.935 9.045)
rect(cv "Via3" 34.175 7.445 34.245 7.515)
rect(cv "Metal3" 34.165 7.355 34.255 7.605)
rect(cv "Metal4" 34.085 7.435 34.335 7.525)
rect(cv "Via4" 34.175 7.445 34.245 7.515)
rect(cv "Metal4" 34.085 7.435 34.335 7.525)
rect(cv "Metal5" 34.165 7.355 34.255 7.605)
rect(cv "Metal5" 34.17 7.44 34.25 9.12)
rect(cv "Via4" 34.175 9.045 34.245 9.115)
rect(cv "Metal4" 34.085 9.035 34.335 9.125)
rect(cv "Metal5" 34.165 8.955 34.255 9.205)
rect(cv "Via3" 34.495 7.445 34.565 7.515)
rect(cv "Metal3" 34.485 7.355 34.575 7.605)
rect(cv "Metal4" 34.405 7.435 34.655 7.525)
rect(cv "Via4" 34.495 7.445 34.565 7.515)
rect(cv "Metal4" 34.405 7.435 34.655 7.525)
rect(cv "Metal5" 34.485 7.355 34.575 7.605)
rect(cv "Metal5" 34.49 7.44 34.57 9.28)
rect(cv "Via4" 34.495 9.205 34.565 9.275)
rect(cv "Metal4" 34.405 9.195 34.655 9.285)
rect(cv "Metal5" 34.485 9.115 34.575 9.365)
rect(cv "Metal4" 0.21 7.92 32.97 8)
rect(cv "Via3" 0.215 7.925 0.285 7.995)
rect(cv "Metal3" 0.205 7.835 0.295 8.085)
rect(cv "Metal4" 0.125 7.915 0.375 8.005)
rect(cv "Metal3" 0.18 7.89 0.32 10.05)
port(cv "R1" "Metal3" 0.25 9.98)
rect(cv "Metal4" 0.53 8.08 33.29 8.16)
rect(cv "Via3" 0.535 8.085 0.605 8.155)
rect(cv "Metal3" 0.525 7.995 0.615 8.245)
rect(cv "Metal4" 0.445 8.075 0.695 8.165)
rect(cv "Metal3" 0.5 8.05 0.64 10.05)
port(cv "R0" "Metal3" 0.57 9.98)
rect(cv "Metal4" 0.85 8.24 33.61 8.32)
rect(cv "Via3" 0.855 8.245 0.925 8.315)
rect(cv "Metal3" 0.845 8.155 0.935 8.405)
rect(cv "Metal4" 0.765 8.235 1.015 8.325)
rect(cv "Metal3" 0.82 8.21 0.96 10.05)
port(cv "EN" "Metal3" 0.89 9.98)
rect(cv "Metal4" 1.17 8.4 11.94 8.48)
rect(cv "Via3" 1.175 8.405 1.245 8.475)
rect(cv "Metal3" 1.165 8.315 1.255 8.565)
rect(cv "Metal4" 1.085 8.395 1.335 8.485)
rect(cv "Metal3" 1.14 8.37 1.28 10.05)
port(cv "WL0" "Metal3" 1.21 9.98)
rect(cv "Metal4" 1.49 8.56 19.27 8.64)
rect(cv "Via3" 1.495 8.565 1.565 8.635)
rect(cv "Metal3" 1.485 8.475 1.575 8.725)
rect(cv "Metal4" 1.405 8.555 1.655 8.645)
rect(cv "Metal3" 1.46 8.53 1.6 10.05)
port(cv "WL1" "Metal3" 1.53 9.98)
rect(cv "Metal4" 1.81 8.72 26.6 8.8)
rect(cv "Via3" 1.815 8.725 1.885 8.795)
rect(cv "Metal3" 1.805 8.635 1.895 8.885)
rect(cv "Metal4" 1.725 8.715 1.975 8.805)
rect(cv "Metal3" 1.78 8.69 1.92 10.05)
port(cv "WL2" "Metal3" 1.85 9.98)
rect(cv "Metal4" 2.13 8.88 33.93 8.96)
rect(cv "Via3" 2.135 8.885 2.205 8.955)
rect(cv "Metal3" 2.125 8.795 2.215 9.045)
rect(cv "Metal4" 2.045 8.875 2.295 8.965)
rect(cv "Metal3" 2.1 8.85 2.24 10.05)
port(cv "WL3" "Metal3" 2.17 9.98)
rect(cv "Metal4" 2.45 9.04 34.25 9.12)
rect(cv "Via3" 2.455 9.045 2.525 9.115)
rect(cv "Metal3" 2.445 8.955 2.535 9.205)
rect(cv "Metal4" 2.365 9.035 2.615 9.125)
rect(cv "Metal3" 2.42 9.01 2.56 10.05)
port(cv "VDD" "Metal3" 2.49 9.98)
rect(cv "Metal4" 2.77 9.2 34.57 9.28)
rect(cv "Via3" 2.775 9.205 2.845 9.275)
rect(cv "Metal3" 2.765 9.115 2.855 9.365)
rect(cv "Metal4" 2.685 9.195 2.935 9.285)
rect(cv "Metal3" 2.74 9.17 2.88 10.05)
port(cv "GND" "Metal3" 2.81 9.98)
rect(cv "Metal4" 3.96 9.36 25.96 9.44)
rect(cv "Metal4" 7.59 9.52 18.31 9.6)
rect(cv "prBoundary" 0.0 0.0 40.01 10.06)
dbSave(cv) printf("LAYOUT row_decoder %L\n" cv~>bBox) dbClose(cv)
cv=dbOpenCellViewByType("sram_project" "column_decoder" "layout" "maskLayout" "w")
dbCreateInst(cv dbOpenCellViewByType("sram_project" "inv" "layout" "" "r") "I0" list(4.07 0.35) "R0")
dbCreateInst(cv dbOpenCellViewByType("sram_project" "inv" "layout" "" "r") "I1" list(7.7 0.35) "R0")
dbCreateInst(cv dbOpenCellViewByType("sram_project" "inv" "layout" "" "r") "I2" list(11.33 0.35) "R0")
dbCreateInst(cv dbOpenCellViewByType("sram_project" "and3" "layout" "" "r") "C0" list(14.96 0.35) "R0")
dbCreateInst(cv dbOpenCellViewByType("sram_project" "and3" "layout" "" "r") "C1" list(22.29 0.35) "R0")
dbCreateInst(cv dbOpenCellViewByType("sram_project" "and3" "layout" "" "r") "C2" list(29.62 0.35) "R0")
dbCreateInst(cv dbOpenCellViewByType("sram_project" "and3" "layout" "" "r") "C3" list(36.95 0.35) "R0")
dbCreateInst(cv dbOpenCellViewByType("sram_project" "and3" "layout" "" "r") "C4" list(44.28 0.35) "R0")
dbCreateInst(cv dbOpenCellViewByType("sram_project" "and3" "layout" "" "r") "C5" list(51.61 0.35) "R0")
rect(cv "Via3" 4.285 3.845 4.355 3.915)
rect(cv "Metal3" 4.275 3.755 4.365 4.005)
rect(cv "Metal4" 4.195 3.835 4.445 3.925)
rect(cv "Via4" 4.285 3.845 4.355 3.915)
rect(cv "Metal4" 4.195 3.835 4.445 3.925)
rect(cv "Metal5" 4.275 3.755 4.365 4.005)
rect(cv "Metal5" 4.28 3.84 4.36 8.32)
rect(cv "Via4" 4.285 8.245 4.355 8.315)
rect(cv "Metal4" 4.195 8.235 4.445 8.325)
rect(cv "Metal5" 4.275 8.155 4.365 8.405)
rect(cv "Via3" 4.605 3.845 4.675 3.915)
rect(cv "Metal3" 4.595 3.755 4.685 4.005)
rect(cv "Metal4" 4.515 3.835 4.765 3.925)
rect(cv "Via4" 4.605 3.845 4.675 3.915)
rect(cv "Metal4" 4.515 3.835 4.765 3.925)
rect(cv "Metal5" 4.595 3.755 4.685 4.005)
rect(cv "Metal5" 4.6 3.84 4.68 9.76)
rect(cv "Via4" 4.605 9.685 4.675 9.755)
rect(cv "Metal4" 4.515 9.675 4.765 9.765)
rect(cv "Metal5" 4.595 9.595 4.685 9.845)
rect(cv "Via3" 4.925 3.845 4.995 3.915)
rect(cv "Metal3" 4.915 3.755 5.005 4.005)
rect(cv "Metal4" 4.835 3.835 5.085 3.925)
rect(cv "Via4" 4.925 3.845 4.995 3.915)
rect(cv "Metal4" 4.835 3.835 5.085 3.925)
rect(cv "Metal5" 4.915 3.755 5.005 4.005)
rect(cv "Metal5" 4.92 3.84 5 9.44)
rect(cv "Via4" 4.925 9.365 4.995 9.435)
rect(cv "Metal4" 4.835 9.355 5.085 9.445)
rect(cv "Metal5" 4.915 9.275 5.005 9.525)
rect(cv "Via3" 5.245 3.845 5.315 3.915)
rect(cv "Metal3" 5.235 3.755 5.325 4.005)
rect(cv "Metal4" 5.155 3.835 5.405 3.925)
rect(cv "Via4" 5.245 3.845 5.315 3.915)
rect(cv "Metal4" 5.155 3.835 5.405 3.925)
rect(cv "Metal5" 5.235 3.755 5.325 4.005)
rect(cv "Metal5" 5.24 3.84 5.32 9.6)
rect(cv "Via4" 5.245 9.525 5.315 9.595)
rect(cv "Metal4" 5.155 9.515 5.405 9.605)
rect(cv "Metal5" 5.235 9.435 5.325 9.685)
rect(cv "Via3" 7.915 3.845 7.985 3.915)
rect(cv "Metal3" 7.905 3.755 7.995 4.005)
rect(cv "Metal4" 7.825 3.835 8.075 3.925)
rect(cv "Via4" 7.915 3.845 7.985 3.915)
rect(cv "Metal4" 7.825 3.835 8.075 3.925)
rect(cv "Metal5" 7.905 3.755 7.995 4.005)
rect(cv "Metal5" 7.91 3.84 7.99 8.16)
rect(cv "Via4" 7.915 8.085 7.985 8.155)
rect(cv "Metal4" 7.825 8.075 8.075 8.165)
rect(cv "Metal5" 7.905 7.995 7.995 8.245)
rect(cv "Via3" 8.235 3.845 8.305 3.915)
rect(cv "Metal3" 8.225 3.755 8.315 4.005)
rect(cv "Metal4" 8.145 3.835 8.395 3.925)
rect(cv "Via4" 8.235 3.845 8.305 3.915)
rect(cv "Metal4" 8.145 3.835 8.395 3.925)
rect(cv "Metal5" 8.225 3.755 8.315 4.005)
rect(cv "Metal5" 8.23 3.84 8.31 9.92)
rect(cv "Via4" 8.235 9.845 8.305 9.915)
rect(cv "Metal4" 8.145 9.835 8.395 9.925)
rect(cv "Metal5" 8.225 9.755 8.315 10.005)
rect(cv "Via3" 8.555 3.845 8.625 3.915)
rect(cv "Metal3" 8.545 3.755 8.635 4.005)
rect(cv "Metal4" 8.465 3.835 8.715 3.925)
rect(cv "Via4" 8.555 3.845 8.625 3.915)
rect(cv "Metal4" 8.465 3.835 8.715 3.925)
rect(cv "Metal5" 8.545 3.755 8.635 4.005)
rect(cv "Metal5" 8.55 3.84 8.63 9.44)
rect(cv "Via4" 8.555 9.365 8.625 9.435)
rect(cv "Metal4" 8.465 9.355 8.715 9.445)
rect(cv "Metal5" 8.545 9.275 8.635 9.525)
rect(cv "Via3" 8.875 3.845 8.945 3.915)
rect(cv "Metal3" 8.865 3.755 8.955 4.005)
rect(cv "Metal4" 8.785 3.835 9.035 3.925)
rect(cv "Via4" 8.875 3.845 8.945 3.915)
rect(cv "Metal4" 8.785 3.835 9.035 3.925)
rect(cv "Metal5" 8.865 3.755 8.955 4.005)
rect(cv "Metal5" 8.87 3.84 8.95 9.6)
rect(cv "Via4" 8.875 9.525 8.945 9.595)
rect(cv "Metal4" 8.785 9.515 9.035 9.605)
rect(cv "Metal5" 8.865 9.435 8.955 9.685)
rect(cv "Via3" 11.545 3.845 11.615 3.915)
rect(cv "Metal3" 11.535 3.755 11.625 4.005)
rect(cv "Metal4" 11.455 3.835 11.705 3.925)
rect(cv "Via4" 11.545 3.845 11.615 3.915)
rect(cv "Metal4" 11.455 3.835 11.705 3.925)
rect(cv "Metal5" 11.535 3.755 11.625 4.005)
rect(cv "Metal5" 11.54 3.84 11.62 8)
rect(cv "Via4" 11.545 7.925 11.615 7.995)
rect(cv "Metal4" 11.455 7.915 11.705 8.005)
rect(cv "Metal5" 11.535 7.835 11.625 8.085)
rect(cv "Via3" 11.865 3.845 11.935 3.915)
rect(cv "Metal3" 11.855 3.755 11.945 4.005)
rect(cv "Metal4" 11.775 3.835 12.025 3.925)
rect(cv "Via4" 11.865 3.845 11.935 3.915)
rect(cv "Metal4" 11.775 3.835 12.025 3.925)
rect(cv "Metal5" 11.855 3.755 11.945 4.005)
rect(cv "Metal5" 11.86 3.84 11.94 10.08)
rect(cv "Via4" 11.865 10.005 11.935 10.075)
rect(cv "Metal4" 11.775 9.995 12.025 10.085)
rect(cv "Metal5" 11.855 9.915 11.945 10.165)
rect(cv "Via3" 12.185 3.845 12.255 3.915)
rect(cv "Metal3" 12.175 3.755 12.265 4.005)
rect(cv "Metal4" 12.095 3.835 12.345 3.925)
rect(cv "Via4" 12.185 3.845 12.255 3.915)
rect(cv "Metal4" 12.095 3.835 12.345 3.925)
rect(cv "Metal5" 12.175 3.755 12.265 4.005)
rect(cv "Metal5" 12.18 3.84 12.26 9.44)
rect(cv "Via4" 12.185 9.365 12.255 9.435)
rect(cv "Metal4" 12.095 9.355 12.345 9.445)
rect(cv "Metal5" 12.175 9.275 12.265 9.525)
rect(cv "Via3" 12.505 3.845 12.575 3.915)
rect(cv "Metal3" 12.495 3.755 12.585 4.005)
rect(cv "Metal4" 12.415 3.835 12.665 3.925)
rect(cv "Via4" 12.505 3.845 12.575 3.915)
rect(cv "Metal4" 12.415 3.835 12.665 3.925)
rect(cv "Metal5" 12.495 3.755 12.585 4.005)
rect(cv "Metal5" 12.5 3.84 12.58 9.6)
rect(cv "Via4" 12.505 9.525 12.575 9.595)
rect(cv "Metal4" 12.415 9.515 12.665 9.605)
rect(cv "Metal5" 12.495 9.435 12.585 9.685)
rect(cv "Via3" 15.175 7.445 15.245 7.515)
rect(cv "Metal3" 15.165 7.355 15.255 7.605)
rect(cv "Metal4" 15.085 7.435 15.335 7.525)
rect(cv "Via4" 15.175 7.445 15.245 7.515)
rect(cv "Metal4" 15.085 7.435 15.335 7.525)
rect(cv "Metal5" 15.165 7.355 15.255 7.605)
rect(cv "Metal5" 15.17 7.44 15.25 10.08)
rect(cv "Via4" 15.175 10.005 15.245 10.075)
rect(cv "Metal4" 15.085 9.995 15.335 10.085)
rect(cv "Metal5" 15.165 9.915 15.255 10.165)
rect(cv "Via3" 15.495 7.445 15.565 7.515)
rect(cv "Metal3" 15.485 7.355 15.575 7.605)
rect(cv "Metal4" 15.405 7.435 15.655 7.525)
rect(cv "Via4" 15.495 7.445 15.565 7.515)
rect(cv "Metal4" 15.405 7.435 15.655 7.525)
rect(cv "Metal5" 15.485 7.355 15.575 7.605)
rect(cv "Metal5" 15.49 7.44 15.57 9.92)
rect(cv "Via4" 15.495 9.845 15.565 9.915)
rect(cv "Metal4" 15.405 9.835 15.655 9.925)
rect(cv "Metal5" 15.485 9.755 15.575 10.005)
rect(cv "Via3" 15.815 7.445 15.885 7.515)
rect(cv "Metal3" 15.805 7.355 15.895 7.605)
rect(cv "Metal4" 15.725 7.435 15.975 7.525)
rect(cv "Via4" 15.815 7.445 15.885 7.515)
rect(cv "Metal4" 15.725 7.435 15.975 7.525)
rect(cv "Metal5" 15.805 7.355 15.895 7.605)
rect(cv "Metal5" 15.81 7.44 15.89 9.76)
rect(cv "Via4" 15.815 9.685 15.885 9.755)
rect(cv "Metal4" 15.725 9.675 15.975 9.765)
rect(cv "Metal5" 15.805 9.595 15.895 9.845)
rect(cv "Via3" 16.135 7.445 16.205 7.515)
rect(cv "Metal3" 16.125 7.355 16.215 7.605)
rect(cv "Metal4" 16.045 7.435 16.295 7.525)
rect(cv "Via4" 16.135 7.445 16.205 7.515)
rect(cv "Metal4" 16.045 7.435 16.295 7.525)
rect(cv "Metal5" 16.125 7.355 16.215 7.605)
rect(cv "Metal5" 16.13 7.44 16.21 8.48)
rect(cv "Via4" 16.135 8.405 16.205 8.475)
rect(cv "Metal4" 16.045 8.395 16.295 8.485)
rect(cv "Metal5" 16.125 8.315 16.215 8.565)
rect(cv "Via3" 16.455 7.445 16.525 7.515)
rect(cv "Metal3" 16.445 7.355 16.535 7.605)
rect(cv "Metal4" 16.365 7.435 16.615 7.525)
rect(cv "Via4" 16.455 7.445 16.525 7.515)
rect(cv "Metal4" 16.365 7.435 16.615 7.525)
rect(cv "Metal5" 16.445 7.355 16.535 7.605)
rect(cv "Metal5" 16.45 7.44 16.53 9.44)
rect(cv "Via4" 16.455 9.365 16.525 9.435)
rect(cv "Metal4" 16.365 9.355 16.615 9.445)
rect(cv "Metal5" 16.445 9.275 16.535 9.525)
rect(cv "Via3" 16.775 7.445 16.845 7.515)
rect(cv "Metal3" 16.765 7.355 16.855 7.605)
rect(cv "Metal4" 16.685 7.435 16.935 7.525)
rect(cv "Via4" 16.775 7.445 16.845 7.515)
rect(cv "Metal4" 16.685 7.435 16.935 7.525)
rect(cv "Metal5" 16.765 7.355 16.855 7.605)
rect(cv "Metal5" 16.77 7.44 16.85 9.6)
rect(cv "Via4" 16.775 9.525 16.845 9.595)
rect(cv "Metal4" 16.685 9.515 16.935 9.605)
rect(cv "Metal5" 16.765 9.435 16.855 9.685)
rect(cv "Via3" 22.505 7.445 22.575 7.515)
rect(cv "Metal3" 22.495 7.355 22.585 7.605)
rect(cv "Metal4" 22.415 7.435 22.665 7.525)
rect(cv "Via4" 22.505 7.445 22.575 7.515)
rect(cv "Metal4" 22.415 7.435 22.665 7.525)
rect(cv "Metal5" 22.495 7.355 22.585 7.605)
rect(cv "Metal5" 22.5 7.44 22.58 10.08)
rect(cv "Via4" 22.505 10.005 22.575 10.075)
rect(cv "Metal4" 22.415 9.995 22.665 10.085)
rect(cv "Metal5" 22.495 9.915 22.585 10.165)
rect(cv "Via3" 22.825 7.445 22.895 7.515)
rect(cv "Metal3" 22.815 7.355 22.905 7.605)
rect(cv "Metal4" 22.735 7.435 22.985 7.525)
rect(cv "Via4" 22.825 7.445 22.895 7.515)
rect(cv "Metal4" 22.735 7.435 22.985 7.525)
rect(cv "Metal5" 22.815 7.355 22.905 7.605)
rect(cv "Metal5" 22.82 7.44 22.9 9.92)
rect(cv "Via4" 22.825 9.845 22.895 9.915)
rect(cv "Metal4" 22.735 9.835 22.985 9.925)
rect(cv "Metal5" 22.815 9.755 22.905 10.005)
rect(cv "Via3" 23.145 7.445 23.215 7.515)
rect(cv "Metal3" 23.135 7.355 23.225 7.605)
rect(cv "Metal4" 23.055 7.435 23.305 7.525)
rect(cv "Via4" 23.145 7.445 23.215 7.515)
rect(cv "Metal4" 23.055 7.435 23.305 7.525)
rect(cv "Metal5" 23.135 7.355 23.225 7.605)
rect(cv "Metal5" 23.14 7.44 23.22 8.32)
rect(cv "Via4" 23.145 8.245 23.215 8.315)
rect(cv "Metal4" 23.055 8.235 23.305 8.325)
rect(cv "Metal5" 23.135 8.155 23.225 8.405)
rect(cv "Via3" 23.465 7.445 23.535 7.515)
rect(cv "Metal3" 23.455 7.355 23.545 7.605)
rect(cv "Metal4" 23.375 7.435 23.625 7.525)
rect(cv "Via4" 23.465 7.445 23.535 7.515)
rect(cv "Metal4" 23.375 7.435 23.625 7.525)
rect(cv "Metal5" 23.455 7.355 23.545 7.605)
rect(cv "Metal5" 23.46 7.44 23.54 8.64)
rect(cv "Via4" 23.465 8.565 23.535 8.635)
rect(cv "Metal4" 23.375 8.555 23.625 8.645)
rect(cv "Metal5" 23.455 8.475 23.545 8.725)
rect(cv "Via3" 23.785 7.445 23.855 7.515)
rect(cv "Metal3" 23.775 7.355 23.865 7.605)
rect(cv "Metal4" 23.695 7.435 23.945 7.525)
rect(cv "Via4" 23.785 7.445 23.855 7.515)
rect(cv "Metal4" 23.695 7.435 23.945 7.525)
rect(cv "Metal5" 23.775 7.355 23.865 7.605)
rect(cv "Metal5" 23.78 7.44 23.86 9.44)
rect(cv "Via4" 23.785 9.365 23.855 9.435)
rect(cv "Metal4" 23.695 9.355 23.945 9.445)
rect(cv "Metal5" 23.775 9.275 23.865 9.525)
rect(cv "Via3" 24.105 7.445 24.175 7.515)
rect(cv "Metal3" 24.095 7.355 24.185 7.605)
rect(cv "Metal4" 24.015 7.435 24.265 7.525)
rect(cv "Via4" 24.105 7.445 24.175 7.515)
rect(cv "Metal4" 24.015 7.435 24.265 7.525)
rect(cv "Metal5" 24.095 7.355 24.185 7.605)
rect(cv "Metal5" 24.1 7.44 24.18 9.6)
rect(cv "Via4" 24.105 9.525 24.175 9.595)
rect(cv "Metal4" 24.015 9.515 24.265 9.605)
rect(cv "Metal5" 24.095 9.435 24.185 9.685)
rect(cv "Via3" 29.835 7.445 29.905 7.515)
rect(cv "Metal3" 29.825 7.355 29.915 7.605)
rect(cv "Metal4" 29.745 7.435 29.995 7.525)
rect(cv "Via4" 29.835 7.445 29.905 7.515)
rect(cv "Metal4" 29.745 7.435 29.995 7.525)
rect(cv "Metal5" 29.825 7.355 29.915 7.605)
rect(cv "Metal5" 29.83 7.44 29.91 10.08)
rect(cv "Via4" 29.835 10.005 29.905 10.075)
rect(cv "Metal4" 29.745 9.995 29.995 10.085)
rect(cv "Metal5" 29.825 9.915 29.915 10.165)
rect(cv "Via3" 30.155 7.445 30.225 7.515)
rect(cv "Metal3" 30.145 7.355 30.235 7.605)
rect(cv "Metal4" 30.065 7.435 30.315 7.525)
rect(cv "Via4" 30.155 7.445 30.225 7.515)
rect(cv "Metal4" 30.065 7.435 30.315 7.525)
rect(cv "Metal5" 30.145 7.355 30.235 7.605)
rect(cv "Metal5" 30.15 7.44 30.23 8.16)
rect(cv "Via4" 30.155 8.085 30.225 8.155)
rect(cv "Metal4" 30.065 8.075 30.315 8.165)
rect(cv "Metal5" 30.145 7.995 30.235 8.245)
rect(cv "Via3" 30.475 7.445 30.545 7.515)
rect(cv "Metal3" 30.465 7.355 30.555 7.605)
rect(cv "Metal4" 30.385 7.435 30.635 7.525)
rect(cv "Via4" 30.475 7.445 30.545 7.515)
rect(cv "Metal4" 30.385 7.435 30.635 7.525)
rect(cv "Metal5" 30.465 7.355 30.555 7.605)
rect(cv "Metal5" 30.47 7.44 30.55 9.76)
rect(cv "Via4" 30.475 9.685 30.545 9.755)
rect(cv "Metal4" 30.385 9.675 30.635 9.765)
rect(cv "Metal5" 30.465 9.595 30.555 9.845)
rect(cv "Via3" 30.795 7.445 30.865 7.515)
rect(cv "Metal3" 30.785 7.355 30.875 7.605)
rect(cv "Metal4" 30.705 7.435 30.955 7.525)
rect(cv "Via4" 30.795 7.445 30.865 7.515)
rect(cv "Metal4" 30.705 7.435 30.955 7.525)
rect(cv "Metal5" 30.785 7.355 30.875 7.605)
rect(cv "Metal5" 30.79 7.44 30.87 8.8)
rect(cv "Via4" 30.795 8.725 30.865 8.795)
rect(cv "Metal4" 30.705 8.715 30.955 8.805)
rect(cv "Metal5" 30.785 8.635 30.875 8.885)
rect(cv "Via3" 31.115 7.445 31.185 7.515)
rect(cv "Metal3" 31.105 7.355 31.195 7.605)
rect(cv "Metal4" 31.025 7.435 31.275 7.525)
rect(cv "Via4" 31.115 7.445 31.185 7.515)
rect(cv "Metal4" 31.025 7.435 31.275 7.525)
rect(cv "Metal5" 31.105 7.355 31.195 7.605)
rect(cv "Metal5" 31.11 7.44 31.19 9.44)
rect(cv "Via4" 31.115 9.365 31.185 9.435)
rect(cv "Metal4" 31.025 9.355 31.275 9.445)
rect(cv "Metal5" 31.105 9.275 31.195 9.525)
rect(cv "Via3" 31.435 7.445 31.505 7.515)
rect(cv "Metal3" 31.425 7.355 31.515 7.605)
rect(cv "Metal4" 31.345 7.435 31.595 7.525)
rect(cv "Via4" 31.435 7.445 31.505 7.515)
rect(cv "Metal4" 31.345 7.435 31.595 7.525)
rect(cv "Metal5" 31.425 7.355 31.515 7.605)
rect(cv "Metal5" 31.43 7.44 31.51 9.6)
rect(cv "Via4" 31.435 9.525 31.505 9.595)
rect(cv "Metal4" 31.345 9.515 31.595 9.605)
rect(cv "Metal5" 31.425 9.435 31.515 9.685)
rect(cv "Via3" 37.165 7.445 37.235 7.515)
rect(cv "Metal3" 37.155 7.355 37.245 7.605)
rect(cv "Metal4" 37.075 7.435 37.325 7.525)
rect(cv "Via4" 37.165 7.445 37.235 7.515)
rect(cv "Metal4" 37.075 7.435 37.325 7.525)
rect(cv "Metal5" 37.155 7.355 37.245 7.605)
rect(cv "Metal5" 37.16 7.44 37.24 10.08)
rect(cv "Via4" 37.165 10.005 37.235 10.075)
rect(cv "Metal4" 37.075 9.995 37.325 10.085)
rect(cv "Metal5" 37.155 9.915 37.245 10.165)
rect(cv "Via3" 37.485 7.445 37.555 7.515)
rect(cv "Metal3" 37.475 7.355 37.565 7.605)
rect(cv "Metal4" 37.395 7.435 37.645 7.525)
rect(cv "Via4" 37.485 7.445 37.555 7.515)
rect(cv "Metal4" 37.395 7.435 37.645 7.525)
rect(cv "Metal5" 37.475 7.355 37.565 7.605)
rect(cv "Metal5" 37.48 7.44 37.56 8.16)
rect(cv "Via4" 37.485 8.085 37.555 8.155)
rect(cv "Metal4" 37.395 8.075 37.645 8.165)
rect(cv "Metal5" 37.475 7.995 37.565 8.245)
rect(cv "Via3" 37.805 7.445 37.875 7.515)
rect(cv "Metal3" 37.795 7.355 37.885 7.605)
rect(cv "Metal4" 37.715 7.435 37.965 7.525)
rect(cv "Via4" 37.805 7.445 37.875 7.515)
rect(cv "Metal4" 37.715 7.435 37.965 7.525)
rect(cv "Metal5" 37.795 7.355 37.885 7.605)
rect(cv "Metal5" 37.8 7.44 37.88 8.32)
rect(cv "Via4" 37.805 8.245 37.875 8.315)
rect(cv "Metal4" 37.715 8.235 37.965 8.325)
rect(cv "Metal5" 37.795 8.155 37.885 8.405)
rect(cv "Via3" 38.125 7.445 38.195 7.515)
rect(cv "Metal3" 38.115 7.355 38.205 7.605)
rect(cv "Metal4" 38.035 7.435 38.285 7.525)
rect(cv "Via4" 38.125 7.445 38.195 7.515)
rect(cv "Metal4" 38.035 7.435 38.285 7.525)
rect(cv "Metal5" 38.115 7.355 38.205 7.605)
rect(cv "Metal5" 38.12 7.44 38.2 8.96)
rect(cv "Via4" 38.125 8.885 38.195 8.955)
rect(cv "Metal4" 38.035 8.875 38.285 8.965)
rect(cv "Metal5" 38.115 8.795 38.205 9.045)
rect(cv "Via3" 38.445 7.445 38.515 7.515)
rect(cv "Metal3" 38.435 7.355 38.525 7.605)
rect(cv "Metal4" 38.355 7.435 38.605 7.525)
rect(cv "Via4" 38.445 7.445 38.515 7.515)
rect(cv "Metal4" 38.355 7.435 38.605 7.525)
rect(cv "Metal5" 38.435 7.355 38.525 7.605)
rect(cv "Metal5" 38.44 7.44 38.52 9.44)
rect(cv "Via4" 38.445 9.365 38.515 9.435)
rect(cv "Metal4" 38.355 9.355 38.605 9.445)
rect(cv "Metal5" 38.435 9.275 38.525 9.525)
rect(cv "Via3" 38.765 7.445 38.835 7.515)
rect(cv "Metal3" 38.755 7.355 38.845 7.605)
rect(cv "Metal4" 38.675 7.435 38.925 7.525)
rect(cv "Via4" 38.765 7.445 38.835 7.515)
rect(cv "Metal4" 38.675 7.435 38.925 7.525)
rect(cv "Metal5" 38.755 7.355 38.845 7.605)
rect(cv "Metal5" 38.76 7.44 38.84 9.6)
rect(cv "Via4" 38.765 9.525 38.835 9.595)
rect(cv "Metal4" 38.675 9.515 38.925 9.605)
rect(cv "Metal5" 38.755 9.435 38.845 9.685)
rect(cv "Via3" 44.495 7.445 44.565 7.515)
rect(cv "Metal3" 44.485 7.355 44.575 7.605)
rect(cv "Metal4" 44.405 7.435 44.655 7.525)
rect(cv "Via4" 44.495 7.445 44.565 7.515)
rect(cv "Metal4" 44.405 7.435 44.655 7.525)
rect(cv "Metal5" 44.485 7.355 44.575 7.605)
rect(cv "Metal5" 44.49 7.44 44.57 8)
rect(cv "Via4" 44.495 7.925 44.565 7.995)
rect(cv "Metal4" 44.405 7.915 44.655 8.005)
rect(cv "Metal5" 44.485 7.835 44.575 8.085)
rect(cv "Via3" 44.815 7.445 44.885 7.515)
rect(cv "Metal3" 44.805 7.355 44.895 7.605)
rect(cv "Metal4" 44.725 7.435 44.975 7.525)
rect(cv "Via4" 44.815 7.445 44.885 7.515)
rect(cv "Metal4" 44.725 7.435 44.975 7.525)
rect(cv "Metal5" 44.805 7.355 44.895 7.605)
rect(cv "Metal5" 44.81 7.44 44.89 9.92)
rect(cv "Via4" 44.815 9.845 44.885 9.915)
rect(cv "Metal4" 44.725 9.835 44.975 9.925)
rect(cv "Metal5" 44.805 9.755 44.895 10.005)
rect(cv "Via3" 45.135 7.445 45.205 7.515)
rect(cv "Metal3" 45.125 7.355 45.215 7.605)
rect(cv "Metal4" 45.045 7.435 45.295 7.525)
rect(cv "Via4" 45.135 7.445 45.205 7.515)
rect(cv "Metal4" 45.045 7.435 45.295 7.525)
rect(cv "Metal5" 45.125 7.355 45.215 7.605)
rect(cv "Metal5" 45.13 7.44 45.21 9.76)
rect(cv "Via4" 45.135 9.685 45.205 9.755)
rect(cv "Metal4" 45.045 9.675 45.295 9.765)
rect(cv "Metal5" 45.125 9.595 45.215 9.845)
rect(cv "Via3" 45.455 7.445 45.525 7.515)
rect(cv "Metal3" 45.445 7.355 45.535 7.605)
rect(cv "Metal4" 45.365 7.435 45.615 7.525)
rect(cv "Via4" 45.455 7.445 45.525 7.515)
rect(cv "Metal4" 45.365 7.435 45.615 7.525)
rect(cv "Metal5" 45.445 7.355 45.535 7.605)
rect(cv "Metal5" 45.45 7.44 45.53 9.12)
rect(cv "Via4" 45.455 9.045 45.525 9.115)
rect(cv "Metal4" 45.365 9.035 45.615 9.125)
rect(cv "Metal5" 45.445 8.955 45.535 9.205)
rect(cv "Via3" 45.775 7.445 45.845 7.515)
rect(cv "Metal3" 45.765 7.355 45.855 7.605)
rect(cv "Metal4" 45.685 7.435 45.935 7.525)
rect(cv "Via4" 45.775 7.445 45.845 7.515)
rect(cv "Metal4" 45.685 7.435 45.935 7.525)
rect(cv "Metal5" 45.765 7.355 45.855 7.605)
rect(cv "Metal5" 45.77 7.44 45.85 9.44)
rect(cv "Via4" 45.775 9.365 45.845 9.435)
rect(cv "Metal4" 45.685 9.355 45.935 9.445)
rect(cv "Metal5" 45.765 9.275 45.855 9.525)
rect(cv "Via3" 46.095 7.445 46.165 7.515)
rect(cv "Metal3" 46.085 7.355 46.175 7.605)
rect(cv "Metal4" 46.005 7.435 46.255 7.525)
rect(cv "Via4" 46.095 7.445 46.165 7.515)
rect(cv "Metal4" 46.005 7.435 46.255 7.525)
rect(cv "Metal5" 46.085 7.355 46.175 7.605)
rect(cv "Metal5" 46.09 7.44 46.17 9.6)
rect(cv "Via4" 46.095 9.525 46.165 9.595)
rect(cv "Metal4" 46.005 9.515 46.255 9.605)
rect(cv "Metal5" 46.085 9.435 46.175 9.685)
rect(cv "Via3" 51.825 7.445 51.895 7.515)
rect(cv "Metal3" 51.815 7.355 51.905 7.605)
rect(cv "Metal4" 51.735 7.435 51.985 7.525)
rect(cv "Via4" 51.825 7.445 51.895 7.515)
rect(cv "Metal4" 51.735 7.435 51.985 7.525)
rect(cv "Metal5" 51.815 7.355 51.905 7.605)
rect(cv "Metal5" 51.82 7.44 51.9 8)
rect(cv "Via4" 51.825 7.925 51.895 7.995)
rect(cv "Metal4" 51.735 7.915 51.985 8.005)
rect(cv "Metal5" 51.815 7.835 51.905 8.085)
rect(cv "Via3" 52.145 7.445 52.215 7.515)
rect(cv "Metal3" 52.135 7.355 52.225 7.605)
rect(cv "Metal4" 52.055 7.435 52.305 7.525)
rect(cv "Via4" 52.145 7.445 52.215 7.515)
rect(cv "Metal4" 52.055 7.435 52.305 7.525)
rect(cv "Metal5" 52.135 7.355 52.225 7.605)
rect(cv "Metal5" 52.14 7.44 52.22 9.92)
rect(cv "Via4" 52.145 9.845 52.215 9.915)
rect(cv "Metal4" 52.055 9.835 52.305 9.925)
rect(cv "Metal5" 52.135 9.755 52.225 10.005)
rect(cv "Via3" 52.465 7.445 52.535 7.515)
rect(cv "Metal3" 52.455 7.355 52.545 7.605)
rect(cv "Metal4" 52.375 7.435 52.625 7.525)
rect(cv "Via4" 52.465 7.445 52.535 7.515)
rect(cv "Metal4" 52.375 7.435 52.625 7.525)
rect(cv "Metal5" 52.455 7.355 52.545 7.605)
rect(cv "Metal5" 52.46 7.44 52.54 8.32)
rect(cv "Via4" 52.465 8.245 52.535 8.315)
rect(cv "Metal4" 52.375 8.235 52.625 8.325)
rect(cv "Metal5" 52.455 8.155 52.545 8.405)
rect(cv "Via3" 52.785 7.445 52.855 7.515)
rect(cv "Metal3" 52.775 7.355 52.865 7.605)
rect(cv "Metal4" 52.695 7.435 52.945 7.525)
rect(cv "Via4" 52.785 7.445 52.855 7.515)
rect(cv "Metal4" 52.695 7.435 52.945 7.525)
rect(cv "Metal5" 52.775 7.355 52.865 7.605)
rect(cv "Metal5" 52.78 7.44 52.86 9.28)
rect(cv "Via4" 52.785 9.205 52.855 9.275)
rect(cv "Metal4" 52.695 9.195 52.945 9.285)
rect(cv "Metal5" 52.775 9.115 52.865 9.365)
rect(cv "Via3" 53.105 7.445 53.175 7.515)
rect(cv "Metal3" 53.095 7.355 53.185 7.605)
rect(cv "Metal4" 53.015 7.435 53.265 7.525)
rect(cv "Via4" 53.105 7.445 53.175 7.515)
rect(cv "Metal4" 53.015 7.435 53.265 7.525)
rect(cv "Metal5" 53.095 7.355 53.185 7.605)
rect(cv "Metal5" 53.1 7.44 53.18 9.44)
rect(cv "Via4" 53.105 9.365 53.175 9.435)
rect(cv "Metal4" 53.015 9.355 53.265 9.445)
rect(cv "Metal5" 53.095 9.275 53.185 9.525)
rect(cv "Via3" 53.425 7.445 53.495 7.515)
rect(cv "Metal3" 53.415 7.355 53.505 7.605)
rect(cv "Metal4" 53.335 7.435 53.585 7.525)
rect(cv "Via4" 53.425 7.445 53.495 7.515)
rect(cv "Metal4" 53.335 7.435 53.585 7.525)
rect(cv "Metal5" 53.415 7.355 53.505 7.605)
rect(cv "Metal5" 53.42 7.44 53.5 9.6)
rect(cv "Via4" 53.425 9.525 53.495 9.595)
rect(cv "Metal4" 53.335 9.515 53.585 9.605)
rect(cv "Metal5" 53.415 9.435 53.505 9.685)
rect(cv "Metal4" 0.21 7.92 51.9 8)
rect(cv "Via3" 0.215 7.925 0.285 7.995)
rect(cv "Metal3" 0.205 7.835 0.295 8.085)
rect(cv "Metal4" 0.125 7.915 0.375 8.005)
rect(cv "Metal3" 0.18 7.89 0.32 10.53)
port(cv "C2" "Metal3" 0.25 10.46)
rect(cv "Metal4" 0.53 8.08 37.56 8.16)
rect(cv "Via3" 0.535 8.085 0.605 8.155)
rect(cv "Metal3" 0.525 7.995 0.615 8.245)
rect(cv "Metal4" 0.445 8.075 0.695 8.165)
rect(cv "Metal3" 0.5 8.05 0.64 10.53)
port(cv "C1" "Metal3" 0.57 10.46)
rect(cv "Metal4" 0.85 8.24 52.54 8.32)
rect(cv "Via3" 0.855 8.245 0.925 8.315)
rect(cv "Metal3" 0.845 8.155 0.935 8.405)
rect(cv "Metal4" 0.765 8.235 1.015 8.325)
rect(cv "Metal3" 0.82 8.21 0.96 10.53)
port(cv "C0" "Metal3" 0.89 10.46)
rect(cv "Metal4" 1.17 8.4 16.21 8.48)
rect(cv "Via3" 1.175 8.405 1.245 8.475)
rect(cv "Metal3" 1.165 8.315 1.255 8.565)
rect(cv "Metal4" 1.085 8.395 1.335 8.485)
rect(cv "Metal3" 1.14 8.37 1.28 10.53)
port(cv "CS0" "Metal3" 1.21 10.46)
rect(cv "Metal4" 1.49 8.56 23.54 8.64)
rect(cv "Via3" 1.495 8.565 1.565 8.635)
rect(cv "Metal3" 1.485 8.475 1.575 8.725)
rect(cv "Metal4" 1.405 8.555 1.655 8.645)
rect(cv "Metal3" 1.46 8.53 1.6 10.53)
port(cv "CS1" "Metal3" 1.53 10.46)
rect(cv "Metal4" 1.81 8.72 30.87 8.8)
rect(cv "Via3" 1.815 8.725 1.885 8.795)
rect(cv "Metal3" 1.805 8.635 1.895 8.885)
rect(cv "Metal4" 1.725 8.715 1.975 8.805)
rect(cv "Metal3" 1.78 8.69 1.92 10.53)
port(cv "CS2" "Metal3" 1.85 10.46)
rect(cv "Metal4" 2.13 8.88 38.2 8.96)
rect(cv "Via3" 2.135 8.885 2.205 8.955)
rect(cv "Metal3" 2.125 8.795 2.215 9.045)
rect(cv "Metal4" 2.045 8.875 2.295 8.965)
rect(cv "Metal3" 2.1 8.85 2.24 10.53)
port(cv "CS3" "Metal3" 2.17 10.46)
rect(cv "Metal4" 2.45 9.04 45.53 9.12)
rect(cv "Via3" 2.455 9.045 2.525 9.115)
rect(cv "Metal3" 2.445 8.955 2.535 9.205)
rect(cv "Metal4" 2.365 9.035 2.615 9.125)
rect(cv "Metal3" 2.42 9.01 2.56 10.53)
port(cv "CS4" "Metal3" 2.49 10.46)
rect(cv "Metal4" 2.77 9.2 52.86 9.28)
rect(cv "Via3" 2.775 9.205 2.845 9.275)
rect(cv "Metal3" 2.765 9.115 2.855 9.365)
rect(cv "Metal4" 2.685 9.195 2.935 9.285)
rect(cv "Metal3" 2.74 9.17 2.88 10.53)
port(cv "CS5" "Metal3" 2.81 10.46)
rect(cv "Metal4" 3.09 9.36 53.18 9.44)
rect(cv "Via3" 3.095 9.365 3.165 9.435)
rect(cv "Metal3" 3.085 9.275 3.175 9.525)
rect(cv "Metal4" 3.005 9.355 3.255 9.445)
rect(cv "Metal3" 3.06 9.33 3.2 10.53)
port(cv "VDD" "Metal3" 3.13 10.46)
rect(cv "Metal4" 3.41 9.52 53.5 9.6)
rect(cv "Via3" 3.415 9.525 3.485 9.595)
rect(cv "Metal3" 3.405 9.435 3.495 9.685)
rect(cv "Metal4" 3.325 9.515 3.575 9.605)
rect(cv "Metal3" 3.38 9.49 3.52 10.53)
port(cv "GND" "Metal3" 3.45 10.46)
rect(cv "Metal4" 4.6 9.68 45.21 9.76)
rect(cv "Metal4" 8.23 9.84 52.22 9.92)
rect(cv "Metal4" 11.86 10 37.24 10.08)
rect(cv "prBoundary" 0.0 0.0 58.94 10.54)
dbSave(cv) printf("LAYOUT column_decoder %L\n" cv~>bBox) dbClose(cv)
cv=dbOpenCellViewByType("sram_project" "rw_control" "layout" "maskLayout" "w")
dbCreateInst(cv dbOpenCellViewByType("sram_project" "inv" "layout" "" "r") "IRD" list(5.03 0.35) "R0")
dbCreateInst(cv dbOpenCellViewByType("sram_project" "inv" "layout" "" "r") "IWR" list(8.66 0.35) "R0")
dbCreateInst(cv dbOpenCellViewByType("sram_project" "inv" "layout" "" "r") "IPRE" list(12.29 0.35) "R0")
dbCreateInst(cv dbOpenCellViewByType("sram_project" "and3" "layout" "" "r") "BAD" list(15.92 0.35) "R0")
dbCreateInst(cv dbOpenCellViewByType("sram_project" "inv" "layout" "" "r") "VALID" list(23.25 0.35) "R0")
dbCreateInst(cv dbOpenCellViewByType("sram_project" "and3" "layout" "" "r") "WA" list(26.88 0.35) "R0")
dbCreateInst(cv dbOpenCellViewByType("sram_project" "and3" "layout" "" "r") "RA" list(34.21 0.35) "R0")
dbCreateInst(cv dbOpenCellViewByType("sram_project" "and3" "layout" "" "r") "WE" list(41.54 0.35) "R0")
dbCreateInst(cv dbOpenCellViewByType("sram_project" "and3" "layout" "" "r") "RE" list(48.87 0.35) "R0")
dbCreateInst(cv dbOpenCellViewByType("sram_project" "inv" "layout" "" "r") "IWE" list(56.2 0.35) "R0")
dbCreateInst(cv dbOpenCellViewByType("sram_project" "inv" "layout" "" "r") "IRE" list(59.83 0.35) "R0")
dbCreateInst(cv dbOpenCellViewByType("sram_project" "and3" "layout" "" "r") "IDLE" list(63.46 0.35) "R0")
dbCreateInst(cv dbOpenCellViewByType("sram_project" "inv" "layout" "" "r") "ACTIVE" list(70.79 0.35) "R0")
rect(cv "Via3" 5.245 3.845 5.315 3.915)
rect(cv "Metal3" 5.235 3.755 5.325 4.005)
rect(cv "Metal4" 5.155 3.835 5.405 3.925)
rect(cv "Via4" 5.245 3.845 5.315 3.915)
rect(cv "Metal4" 5.155 3.835 5.405 3.925)
rect(cv "Metal5" 5.235 3.755 5.325 4.005)
rect(cv "Metal5" 5.24 3.84 5.32 8.48)
rect(cv "Via4" 5.245 8.405 5.315 8.475)
rect(cv "Metal4" 5.155 8.395 5.405 8.485)
rect(cv "Metal5" 5.235 8.315 5.325 8.565)
rect(cv "Via3" 5.565 3.845 5.635 3.915)
rect(cv "Metal3" 5.555 3.755 5.645 4.005)
rect(cv "Metal4" 5.475 3.835 5.725 3.925)
rect(cv "Via4" 5.565 3.845 5.635 3.915)
rect(cv "Metal4" 5.475 3.835 5.725 3.925)
rect(cv "Metal5" 5.555 3.755 5.645 4.005)
rect(cv "Metal5" 5.56 3.84 5.64 10.24)
rect(cv "Via4" 5.565 10.165 5.635 10.235)
rect(cv "Metal4" 5.475 10.155 5.725 10.245)
rect(cv "Metal5" 5.555 10.075 5.645 10.325)
rect(cv "Via3" 5.885 3.845 5.955 3.915)
rect(cv "Metal3" 5.875 3.755 5.965 4.005)
rect(cv "Metal4" 5.795 3.835 6.045 3.925)
rect(cv "Via4" 5.885 3.845 5.955 3.915)
rect(cv "Metal4" 5.795 3.835 6.045 3.925)
rect(cv "Metal5" 5.875 3.755 5.965 4.005)
rect(cv "Metal5" 5.88 3.84 5.96 9.92)
rect(cv "Via4" 5.885 9.845 5.955 9.915)
rect(cv "Metal4" 5.795 9.835 6.045 9.925)
rect(cv "Metal5" 5.875 9.755 5.965 10.005)
rect(cv "Via3" 6.205 3.845 6.275 3.915)
rect(cv "Metal3" 6.195 3.755 6.285 4.005)
rect(cv "Metal4" 6.115 3.835 6.365 3.925)
rect(cv "Via4" 6.205 3.845 6.275 3.915)
rect(cv "Metal4" 6.115 3.835 6.365 3.925)
rect(cv "Metal5" 6.195 3.755 6.285 4.005)
rect(cv "Metal5" 6.2 3.84 6.28 10.08)
rect(cv "Via4" 6.205 10.005 6.275 10.075)
rect(cv "Metal4" 6.115 9.995 6.365 10.085)
rect(cv "Metal5" 6.195 9.915 6.285 10.165)
rect(cv "Via3" 8.875 3.845 8.945 3.915)
rect(cv "Metal3" 8.865 3.755 8.955 4.005)
rect(cv "Metal4" 8.785 3.835 9.035 3.925)
rect(cv "Via4" 8.875 3.845 8.945 3.915)
rect(cv "Metal4" 8.785 3.835 9.035 3.925)
rect(cv "Metal5" 8.865 3.755 8.955 4.005)
rect(cv "Metal5" 8.87 3.84 8.95 8.32)
rect(cv "Via4" 8.875 8.245 8.945 8.315)
rect(cv "Metal4" 8.785 8.235 9.035 8.325)
rect(cv "Metal5" 8.865 8.155 8.955 8.405)
rect(cv "Via3" 9.195 3.845 9.265 3.915)
rect(cv "Metal3" 9.185 3.755 9.275 4.005)
rect(cv "Metal4" 9.105 3.835 9.355 3.925)
rect(cv "Via4" 9.195 3.845 9.265 3.915)
rect(cv "Metal4" 9.105 3.835 9.355 3.925)
rect(cv "Metal5" 9.185 3.755 9.275 4.005)
rect(cv "Metal5" 9.19 3.84 9.27 10.4)
rect(cv "Via4" 9.195 10.325 9.265 10.395)
rect(cv "Metal4" 9.105 10.315 9.355 10.405)
rect(cv "Metal5" 9.185 10.235 9.275 10.485)
rect(cv "Via3" 9.515 3.845 9.585 3.915)
rect(cv "Metal3" 9.505 3.755 9.595 4.005)
rect(cv "Metal4" 9.425 3.835 9.675 3.925)
rect(cv "Via4" 9.515 3.845 9.585 3.915)
rect(cv "Metal4" 9.425 3.835 9.675 3.925)
rect(cv "Metal5" 9.505 3.755 9.595 4.005)
rect(cv "Metal5" 9.51 3.84 9.59 9.92)
rect(cv "Via4" 9.515 9.845 9.585 9.915)
rect(cv "Metal4" 9.425 9.835 9.675 9.925)
rect(cv "Metal5" 9.505 9.755 9.595 10.005)
rect(cv "Via3" 9.835 3.845 9.905 3.915)
rect(cv "Metal3" 9.825 3.755 9.915 4.005)
rect(cv "Metal4" 9.745 3.835 9.995 3.925)
rect(cv "Via4" 9.835 3.845 9.905 3.915)
rect(cv "Metal4" 9.745 3.835 9.995 3.925)
rect(cv "Metal5" 9.825 3.755 9.915 4.005)
rect(cv "Metal5" 9.83 3.84 9.91 10.08)
rect(cv "Via4" 9.835 10.005 9.905 10.075)
rect(cv "Metal4" 9.745 9.995 9.995 10.085)
rect(cv "Metal5" 9.825 9.915 9.915 10.165)
rect(cv "Via3" 12.505 3.845 12.575 3.915)
rect(cv "Metal3" 12.495 3.755 12.585 4.005)
rect(cv "Metal4" 12.415 3.835 12.665 3.925)
rect(cv "Via4" 12.505 3.845 12.575 3.915)
rect(cv "Metal4" 12.415 3.835 12.665 3.925)
rect(cv "Metal5" 12.495 3.755 12.585 4.005)
rect(cv "Metal5" 12.5 3.84 12.58 8.16)
rect(cv "Via4" 12.505 8.085 12.575 8.155)
rect(cv "Metal4" 12.415 8.075 12.665 8.165)
rect(cv "Metal5" 12.495 7.995 12.585 8.245)
rect(cv "Via3" 12.825 3.845 12.895 3.915)
rect(cv "Metal3" 12.815 3.755 12.905 4.005)
rect(cv "Metal4" 12.735 3.835 12.985 3.925)
rect(cv "Via4" 12.825 3.845 12.895 3.915)
rect(cv "Metal4" 12.735 3.835 12.985 3.925)
rect(cv "Metal5" 12.815 3.755 12.905 4.005)
rect(cv "Metal5" 12.82 3.84 12.9 9.76)
rect(cv "Via4" 12.825 9.685 12.895 9.755)
rect(cv "Metal4" 12.735 9.675 12.985 9.765)
rect(cv "Metal5" 12.815 9.595 12.905 9.845)
rect(cv "Via3" 13.145 3.845 13.215 3.915)
rect(cv "Metal3" 13.135 3.755 13.225 4.005)
rect(cv "Metal4" 13.055 3.835 13.305 3.925)
rect(cv "Via4" 13.145 3.845 13.215 3.915)
rect(cv "Metal4" 13.055 3.835 13.305 3.925)
rect(cv "Metal5" 13.135 3.755 13.225 4.005)
rect(cv "Metal5" 13.14 3.84 13.22 9.92)
rect(cv "Via4" 13.145 9.845 13.215 9.915)
rect(cv "Metal4" 13.055 9.835 13.305 9.925)
rect(cv "Metal5" 13.135 9.755 13.225 10.005)
rect(cv "Via3" 13.465 3.845 13.535 3.915)
rect(cv "Metal3" 13.455 3.755 13.545 4.005)
rect(cv "Metal4" 13.375 3.835 13.625 3.925)
rect(cv "Via4" 13.465 3.845 13.535 3.915)
rect(cv "Metal4" 13.375 3.835 13.625 3.925)
rect(cv "Metal5" 13.455 3.755 13.545 4.005)
rect(cv "Metal5" 13.46 3.84 13.54 10.08)
rect(cv "Via4" 13.465 10.005 13.535 10.075)
rect(cv "Metal4" 13.375 9.995 13.625 10.085)
rect(cv "Metal5" 13.455 9.915 13.545 10.165)
rect(cv "Via3" 16.135 7.445 16.205 7.515)
rect(cv "Metal3" 16.125 7.355 16.215 7.605)
rect(cv "Metal4" 16.045 7.435 16.295 7.525)
rect(cv "Via4" 16.135 7.445 16.205 7.515)
rect(cv "Metal4" 16.045 7.435 16.295 7.525)
rect(cv "Metal5" 16.125 7.355 16.215 7.605)
rect(cv "Metal5" 16.13 7.44 16.21 8.64)
rect(cv "Via4" 16.135 8.565 16.205 8.635)
rect(cv "Metal4" 16.045 8.555 16.295 8.645)
rect(cv "Metal5" 16.125 8.475 16.215 8.725)
rect(cv "Via3" 16.455 7.445 16.525 7.515)
rect(cv "Metal3" 16.445 7.355 16.535 7.605)
rect(cv "Metal4" 16.365 7.435 16.615 7.525)
rect(cv "Via4" 16.455 7.445 16.525 7.515)
rect(cv "Metal4" 16.365 7.435 16.615 7.525)
rect(cv "Metal5" 16.445 7.355 16.535 7.605)
rect(cv "Metal5" 16.45 7.44 16.53 8.8)
rect(cv "Via4" 16.455 8.725 16.525 8.795)
rect(cv "Metal4" 16.365 8.715 16.615 8.805)
rect(cv "Metal5" 16.445 8.635 16.535 8.885)
rect(cv "Via3" 16.775 7.445 16.845 7.515)
rect(cv "Metal3" 16.765 7.355 16.855 7.605)
rect(cv "Metal4" 16.685 7.435 16.935 7.525)
rect(cv "Via4" 16.775 7.445 16.845 7.515)
rect(cv "Metal4" 16.685 7.435 16.935 7.525)
rect(cv "Metal5" 16.765 7.355 16.855 7.605)
rect(cv "Metal5" 16.77 7.44 16.85 9.92)
rect(cv "Via4" 16.775 9.845 16.845 9.915)
rect(cv "Metal4" 16.685 9.835 16.935 9.925)
rect(cv "Metal5" 16.765 9.755 16.855 10.005)
rect(cv "Via3" 17.095 7.445 17.165 7.515)
rect(cv "Metal3" 17.085 7.355 17.175 7.605)
rect(cv "Metal4" 17.005 7.435 17.255 7.525)
rect(cv "Via4" 17.095 7.445 17.165 7.515)
rect(cv "Metal4" 17.005 7.435 17.255 7.525)
rect(cv "Metal5" 17.085 7.355 17.175 7.605)
rect(cv "Metal5" 17.09 7.44 17.17 10.56)
rect(cv "Via4" 17.095 10.485 17.165 10.555)
rect(cv "Metal4" 17.005 10.475 17.255 10.565)
rect(cv "Metal5" 17.085 10.395 17.175 10.645)
rect(cv "Via3" 17.415 7.445 17.485 7.515)
rect(cv "Metal3" 17.405 7.355 17.495 7.605)
rect(cv "Metal4" 17.325 7.435 17.575 7.525)
rect(cv "Via4" 17.415 7.445 17.485 7.515)
rect(cv "Metal4" 17.325 7.435 17.575 7.525)
rect(cv "Metal5" 17.405 7.355 17.495 7.605)
rect(cv "Metal5" 17.41 7.44 17.49 9.92)
rect(cv "Via4" 17.415 9.845 17.485 9.915)
rect(cv "Metal4" 17.325 9.835 17.575 9.925)
rect(cv "Metal5" 17.405 9.755 17.495 10.005)
rect(cv "Via3" 17.735 7.445 17.805 7.515)
rect(cv "Metal3" 17.725 7.355 17.815 7.605)
rect(cv "Metal4" 17.645 7.435 17.895 7.525)
rect(cv "Via4" 17.735 7.445 17.805 7.515)
rect(cv "Metal4" 17.645 7.435 17.895 7.525)
rect(cv "Metal5" 17.725 7.355 17.815 7.605)
rect(cv "Metal5" 17.73 7.44 17.81 10.08)
rect(cv "Via4" 17.735 10.005 17.805 10.075)
rect(cv "Metal4" 17.645 9.995 17.895 10.085)
rect(cv "Metal5" 17.725 9.915 17.815 10.165)
rect(cv "Via3" 23.465 3.845 23.535 3.915)
rect(cv "Metal3" 23.455 3.755 23.545 4.005)
rect(cv "Metal4" 23.375 3.835 23.625 3.925)
rect(cv "Via4" 23.465 3.845 23.535 3.915)
rect(cv "Metal4" 23.375 3.835 23.625 3.925)
rect(cv "Metal5" 23.455 3.755 23.545 4.005)
rect(cv "Metal5" 23.46 3.84 23.54 10.56)
rect(cv "Via4" 23.465 10.485 23.535 10.555)
rect(cv "Metal4" 23.375 10.475 23.625 10.565)
rect(cv "Metal5" 23.455 10.395 23.545 10.645)
rect(cv "Via3" 23.785 3.845 23.855 3.915)
rect(cv "Metal3" 23.775 3.755 23.865 4.005)
rect(cv "Metal4" 23.695 3.835 23.945 3.925)
rect(cv "Via4" 23.785 3.845 23.855 3.915)
rect(cv "Metal4" 23.695 3.835 23.945 3.925)
rect(cv "Metal5" 23.775 3.755 23.865 4.005)
rect(cv "Metal5" 23.78 3.84 23.86 10.72)
rect(cv "Via4" 23.785 10.645 23.855 10.715)
rect(cv "Metal4" 23.695 10.635 23.945 10.725)
rect(cv "Metal5" 23.775 10.555 23.865 10.805)
rect(cv "Via3" 24.105 3.845 24.175 3.915)
rect(cv "Metal3" 24.095 3.755 24.185 4.005)
rect(cv "Metal4" 24.015 3.835 24.265 3.925)
rect(cv "Via4" 24.105 3.845 24.175 3.915)
rect(cv "Metal4" 24.015 3.835 24.265 3.925)
rect(cv "Metal5" 24.095 3.755 24.185 4.005)
rect(cv "Metal5" 24.1 3.84 24.18 9.92)
rect(cv "Via4" 24.105 9.845 24.175 9.915)
rect(cv "Metal4" 24.015 9.835 24.265 9.925)
rect(cv "Metal5" 24.095 9.755 24.185 10.005)
rect(cv "Via3" 24.425 3.845 24.495 3.915)
rect(cv "Metal3" 24.415 3.755 24.505 4.005)
rect(cv "Metal4" 24.335 3.835 24.585 3.925)
rect(cv "Via4" 24.425 3.845 24.495 3.915)
rect(cv "Metal4" 24.335 3.835 24.585 3.925)
rect(cv "Metal5" 24.415 3.755 24.505 4.005)
rect(cv "Metal5" 24.42 3.84 24.5 10.08)
rect(cv "Via4" 24.425 10.005 24.495 10.075)
rect(cv "Metal4" 24.335 9.995 24.585 10.085)
rect(cv "Metal5" 24.415 9.915 24.505 10.165)
rect(cv "Via3" 27.095 7.445 27.165 7.515)
rect(cv "Metal3" 27.085 7.355 27.175 7.605)
rect(cv "Metal4" 27.005 7.435 27.255 7.525)
rect(cv "Via4" 27.095 7.445 27.165 7.515)
rect(cv "Metal4" 27.005 7.435 27.255 7.525)
rect(cv "Metal5" 27.085 7.355 27.175 7.605)
rect(cv "Metal5" 27.09 7.44 27.17 8.32)
rect(cv "Via4" 27.095 8.245 27.165 8.315)
rect(cv "Metal4" 27.005 8.235 27.255 8.325)
rect(cv "Metal5" 27.085 8.155 27.175 8.405)
rect(cv "Via3" 27.415 7.445 27.485 7.515)
rect(cv "Metal3" 27.405 7.355 27.495 7.605)
rect(cv "Metal4" 27.325 7.435 27.575 7.525)
rect(cv "Via4" 27.415 7.445 27.485 7.515)
rect(cv "Metal4" 27.325 7.435 27.575 7.525)
rect(cv "Metal5" 27.405 7.355 27.495 7.605)
rect(cv "Metal5" 27.41 7.44 27.49 10.24)
rect(cv "Via4" 27.415 10.165 27.485 10.235)
rect(cv "Metal4" 27.325 10.155 27.575 10.245)
rect(cv "Metal5" 27.405 10.075 27.495 10.325)
rect(cv "Via3" 27.735 7.445 27.805 7.515)
rect(cv "Metal3" 27.725 7.355 27.815 7.605)
rect(cv "Metal4" 27.645 7.435 27.895 7.525)
rect(cv "Via4" 27.735 7.445 27.805 7.515)
rect(cv "Metal4" 27.645 7.435 27.895 7.525)
rect(cv "Metal5" 27.725 7.355 27.815 7.605)
rect(cv "Metal5" 27.73 7.44 27.81 8)
rect(cv "Via4" 27.735 7.925 27.805 7.995)
rect(cv "Metal4" 27.645 7.915 27.895 8.005)
rect(cv "Metal5" 27.725 7.835 27.815 8.085)
rect(cv "Via3" 28.055 7.445 28.125 7.515)
rect(cv "Metal3" 28.045 7.355 28.135 7.605)
rect(cv "Metal4" 27.965 7.435 28.215 7.525)
rect(cv "Via4" 28.055 7.445 28.125 7.515)
rect(cv "Metal4" 27.965 7.435 28.215 7.525)
rect(cv "Metal5" 28.045 7.355 28.135 7.605)
rect(cv "Metal5" 28.05 7.44 28.13 10.88)
rect(cv "Via4" 28.055 10.805 28.125 10.875)
rect(cv "Metal4" 27.965 10.795 28.215 10.885)
rect(cv "Metal5" 28.045 10.715 28.135 10.965)
rect(cv "Via3" 28.375 7.445 28.445 7.515)
rect(cv "Metal3" 28.365 7.355 28.455 7.605)
rect(cv "Metal4" 28.285 7.435 28.535 7.525)
rect(cv "Via4" 28.375 7.445 28.445 7.515)
rect(cv "Metal4" 28.285 7.435 28.535 7.525)
rect(cv "Metal5" 28.365 7.355 28.455 7.605)
rect(cv "Metal5" 28.37 7.44 28.45 9.92)
rect(cv "Via4" 28.375 9.845 28.445 9.915)
rect(cv "Metal4" 28.285 9.835 28.535 9.925)
rect(cv "Metal5" 28.365 9.755 28.455 10.005)
rect(cv "Via3" 28.695 7.445 28.765 7.515)
rect(cv "Metal3" 28.685 7.355 28.775 7.605)
rect(cv "Metal4" 28.605 7.435 28.855 7.525)
rect(cv "Via4" 28.695 7.445 28.765 7.515)
rect(cv "Metal4" 28.605 7.435 28.855 7.525)
rect(cv "Metal5" 28.685 7.355 28.775 7.605)
rect(cv "Metal5" 28.69 7.44 28.77 10.08)
rect(cv "Via4" 28.695 10.005 28.765 10.075)
rect(cv "Metal4" 28.605 9.995 28.855 10.085)
rect(cv "Metal5" 28.685 9.915 28.775 10.165)
rect(cv "Via3" 34.425 7.445 34.495 7.515)
rect(cv "Metal3" 34.415 7.355 34.505 7.605)
rect(cv "Metal4" 34.335 7.435 34.585 7.525)
rect(cv "Via4" 34.425 7.445 34.495 7.515)
rect(cv "Metal4" 34.335 7.435 34.585 7.525)
rect(cv "Metal5" 34.415 7.355 34.505 7.605)
rect(cv "Metal5" 34.42 7.44 34.5 8.48)
rect(cv "Via4" 34.425 8.405 34.495 8.475)
rect(cv "Metal4" 34.335 8.395 34.585 8.485)
rect(cv "Metal5" 34.415 8.315 34.505 8.565)
rect(cv "Via3" 34.745 7.445 34.815 7.515)
rect(cv "Metal3" 34.735 7.355 34.825 7.605)
rect(cv "Metal4" 34.655 7.435 34.905 7.525)
rect(cv "Via4" 34.745 7.445 34.815 7.515)
rect(cv "Metal4" 34.655 7.435 34.905 7.525)
rect(cv "Metal5" 34.735 7.355 34.825 7.605)
rect(cv "Metal5" 34.74 7.44 34.82 10.4)
rect(cv "Via4" 34.745 10.325 34.815 10.395)
rect(cv "Metal4" 34.655 10.315 34.905 10.405)
rect(cv "Metal5" 34.735 10.235 34.825 10.485)
rect(cv "Via3" 35.065 7.445 35.135 7.515)
rect(cv "Metal3" 35.055 7.355 35.145 7.605)
rect(cv "Metal4" 34.975 7.435 35.225 7.525)
rect(cv "Via4" 35.065 7.445 35.135 7.515)
rect(cv "Metal4" 34.975 7.435 35.225 7.525)
rect(cv "Metal5" 35.055 7.355 35.145 7.605)
rect(cv "Metal5" 35.06 7.44 35.14 8)
rect(cv "Via4" 35.065 7.925 35.135 7.995)
rect(cv "Metal4" 34.975 7.915 35.225 8.005)
rect(cv "Metal5" 35.055 7.835 35.145 8.085)
rect(cv "Via3" 35.385 7.445 35.455 7.515)
rect(cv "Metal3" 35.375 7.355 35.465 7.605)
rect(cv "Metal4" 35.295 7.435 35.545 7.525)
rect(cv "Via4" 35.385 7.445 35.455 7.515)
rect(cv "Metal4" 35.295 7.435 35.545 7.525)
rect(cv "Metal5" 35.375 7.355 35.465 7.605)
rect(cv "Metal5" 35.38 7.44 35.46 11.04)
rect(cv "Via4" 35.385 10.965 35.455 11.035)
rect(cv "Metal4" 35.295 10.955 35.545 11.045)
rect(cv "Metal5" 35.375 10.875 35.465 11.125)
rect(cv "Via3" 35.705 7.445 35.775 7.515)
rect(cv "Metal3" 35.695 7.355 35.785 7.605)
rect(cv "Metal4" 35.615 7.435 35.865 7.525)
rect(cv "Via4" 35.705 7.445 35.775 7.515)
rect(cv "Metal4" 35.615 7.435 35.865 7.525)
rect(cv "Metal5" 35.695 7.355 35.785 7.605)
rect(cv "Metal5" 35.7 7.44 35.78 9.92)
rect(cv "Via4" 35.705 9.845 35.775 9.915)
rect(cv "Metal4" 35.615 9.835 35.865 9.925)
rect(cv "Metal5" 35.695 9.755 35.785 10.005)
rect(cv "Via3" 36.025 7.445 36.095 7.515)
rect(cv "Metal3" 36.015 7.355 36.105 7.605)
rect(cv "Metal4" 35.935 7.435 36.185 7.525)
rect(cv "Via4" 36.025 7.445 36.095 7.515)
rect(cv "Metal4" 35.935 7.435 36.185 7.525)
rect(cv "Metal5" 36.015 7.355 36.105 7.605)
rect(cv "Metal5" 36.02 7.44 36.1 10.08)
rect(cv "Via4" 36.025 10.005 36.095 10.075)
rect(cv "Metal4" 35.935 9.995 36.185 10.085)
rect(cv "Metal5" 36.015 9.915 36.105 10.165)
rect(cv "Via3" 41.755 7.445 41.825 7.515)
rect(cv "Metal3" 41.745 7.355 41.835 7.605)
rect(cv "Metal4" 41.665 7.435 41.915 7.525)
rect(cv "Via4" 41.755 7.445 41.825 7.515)
rect(cv "Metal4" 41.665 7.435 41.915 7.525)
rect(cv "Metal5" 41.745 7.355 41.835 7.605)
rect(cv "Metal5" 41.75 7.44 41.83 10.88)
rect(cv "Via4" 41.755 10.805 41.825 10.875)
rect(cv "Metal4" 41.665 10.795 41.915 10.885)
rect(cv "Metal5" 41.745 10.715 41.835 10.965)
rect(cv "Via3" 42.075 7.445 42.145 7.515)
rect(cv "Metal3" 42.065 7.355 42.155 7.605)
rect(cv "Metal4" 41.985 7.435 42.235 7.525)
rect(cv "Via4" 42.075 7.445 42.145 7.515)
rect(cv "Metal4" 41.985 7.435 42.235 7.525)
rect(cv "Metal5" 42.065 7.355 42.155 7.605)
rect(cv "Metal5" 42.07 7.44 42.15 10.72)
rect(cv "Via4" 42.075 10.645 42.145 10.715)
rect(cv "Metal4" 41.985 10.635 42.235 10.725)
rect(cv "Metal5" 42.065 10.555 42.155 10.805)
rect(cv "Via3" 42.395 7.445 42.465 7.515)
rect(cv "Metal3" 42.385 7.355 42.475 7.605)
rect(cv "Metal4" 42.305 7.435 42.555 7.525)
rect(cv "Via4" 42.395 7.445 42.465 7.515)
rect(cv "Metal4" 42.305 7.435 42.555 7.525)
rect(cv "Metal5" 42.385 7.355 42.475 7.605)
rect(cv "Metal5" 42.39 7.44 42.47 9.76)
rect(cv "Via4" 42.395 9.685 42.465 9.755)
rect(cv "Metal4" 42.305 9.675 42.555 9.765)
rect(cv "Metal5" 42.385 9.595 42.475 9.845)
rect(cv "Via3" 42.715 7.445 42.785 7.515)
rect(cv "Metal3" 42.705 7.355 42.795 7.605)
rect(cv "Metal4" 42.625 7.435 42.875 7.525)
rect(cv "Via4" 42.715 7.445 42.785 7.515)
rect(cv "Metal4" 42.625 7.435 42.875 7.525)
rect(cv "Metal5" 42.705 7.355 42.795 7.605)
rect(cv "Metal5" 42.71 7.44 42.79 8.96)
rect(cv "Via4" 42.715 8.885 42.785 8.955)
rect(cv "Metal4" 42.625 8.875 42.875 8.965)
rect(cv "Metal5" 42.705 8.795 42.795 9.045)
rect(cv "Via3" 43.035 7.445 43.105 7.515)
rect(cv "Metal3" 43.025 7.355 43.115 7.605)
rect(cv "Metal4" 42.945 7.435 43.195 7.525)
rect(cv "Via4" 43.035 7.445 43.105 7.515)
rect(cv "Metal4" 42.945 7.435 43.195 7.525)
rect(cv "Metal5" 43.025 7.355 43.115 7.605)
rect(cv "Metal5" 43.03 7.44 43.11 9.92)
rect(cv "Via4" 43.035 9.845 43.105 9.915)
rect(cv "Metal4" 42.945 9.835 43.195 9.925)
rect(cv "Metal5" 43.025 9.755 43.115 10.005)
rect(cv "Via3" 43.355 7.445 43.425 7.515)
rect(cv "Metal3" 43.345 7.355 43.435 7.605)
rect(cv "Metal4" 43.265 7.435 43.515 7.525)
rect(cv "Via4" 43.355 7.445 43.425 7.515)
rect(cv "Metal4" 43.265 7.435 43.515 7.525)
rect(cv "Metal5" 43.345 7.355 43.435 7.605)
rect(cv "Metal5" 43.35 7.44 43.43 10.08)
rect(cv "Via4" 43.355 10.005 43.425 10.075)
rect(cv "Metal4" 43.265 9.995 43.515 10.085)
rect(cv "Metal5" 43.345 9.915 43.435 10.165)
rect(cv "Via3" 49.085 7.445 49.155 7.515)
rect(cv "Metal3" 49.075 7.355 49.165 7.605)
rect(cv "Metal4" 48.995 7.435 49.245 7.525)
rect(cv "Via4" 49.085 7.445 49.155 7.515)
rect(cv "Metal4" 48.995 7.435 49.245 7.525)
rect(cv "Metal5" 49.075 7.355 49.165 7.605)
rect(cv "Metal5" 49.08 7.44 49.16 11.04)
rect(cv "Via4" 49.085 10.965 49.155 11.035)
rect(cv "Metal4" 48.995 10.955 49.245 11.045)
rect(cv "Metal5" 49.075 10.875 49.165 11.125)
rect(cv "Via3" 49.405 7.445 49.475 7.515)
rect(cv "Metal3" 49.395 7.355 49.485 7.605)
rect(cv "Metal4" 49.315 7.435 49.565 7.525)
rect(cv "Via4" 49.405 7.445 49.475 7.515)
rect(cv "Metal4" 49.315 7.435 49.565 7.525)
rect(cv "Metal5" 49.395 7.355 49.485 7.605)
rect(cv "Metal5" 49.4 7.44 49.48 10.72)
rect(cv "Via4" 49.405 10.645 49.475 10.715)
rect(cv "Metal4" 49.315 10.635 49.565 10.725)
rect(cv "Metal5" 49.395 10.555 49.485 10.805)
rect(cv "Via3" 49.725 7.445 49.795 7.515)
rect(cv "Metal3" 49.715 7.355 49.805 7.605)
rect(cv "Metal4" 49.635 7.435 49.885 7.525)
rect(cv "Via4" 49.725 7.445 49.795 7.515)
rect(cv "Metal4" 49.635 7.435 49.885 7.525)
rect(cv "Metal5" 49.715 7.355 49.805 7.605)
rect(cv "Metal5" 49.72 7.44 49.8 9.76)
rect(cv "Via4" 49.725 9.685 49.795 9.755)
rect(cv "Metal4" 49.635 9.675 49.885 9.765)
rect(cv "Metal5" 49.715 9.595 49.805 9.845)
rect(cv "Via3" 50.045 7.445 50.115 7.515)
rect(cv "Metal3" 50.035 7.355 50.125 7.605)
rect(cv "Metal4" 49.955 7.435 50.205 7.525)
rect(cv "Via4" 50.045 7.445 50.115 7.515)
rect(cv "Metal4" 49.955 7.435 50.205 7.525)
rect(cv "Metal5" 50.035 7.355 50.125 7.605)
rect(cv "Metal5" 50.04 7.44 50.12 9.28)
rect(cv "Via4" 50.045 9.205 50.115 9.275)
rect(cv "Metal4" 49.955 9.195 50.205 9.285)
rect(cv "Metal5" 50.035 9.115 50.125 9.365)
rect(cv "Via3" 50.365 7.445 50.435 7.515)
rect(cv "Metal3" 50.355 7.355 50.445 7.605)
rect(cv "Metal4" 50.275 7.435 50.525 7.525)
rect(cv "Via4" 50.365 7.445 50.435 7.515)
rect(cv "Metal4" 50.275 7.435 50.525 7.525)
rect(cv "Metal5" 50.355 7.355 50.445 7.605)
rect(cv "Metal5" 50.36 7.44 50.44 9.92)
rect(cv "Via4" 50.365 9.845 50.435 9.915)
rect(cv "Metal4" 50.275 9.835 50.525 9.925)
rect(cv "Metal5" 50.355 9.755 50.445 10.005)
rect(cv "Via3" 50.685 7.445 50.755 7.515)
rect(cv "Metal3" 50.675 7.355 50.765 7.605)
rect(cv "Metal4" 50.595 7.435 50.845 7.525)
rect(cv "Via4" 50.685 7.445 50.755 7.515)
rect(cv "Metal4" 50.595 7.435 50.845 7.525)
rect(cv "Metal5" 50.675 7.355 50.765 7.605)
rect(cv "Metal5" 50.68 7.44 50.76 10.08)
rect(cv "Via4" 50.685 10.005 50.755 10.075)
rect(cv "Metal4" 50.595 9.995 50.845 10.085)
rect(cv "Metal5" 50.675 9.915 50.765 10.165)
rect(cv "Via3" 56.415 3.845 56.485 3.915)
rect(cv "Metal3" 56.405 3.755 56.495 4.005)
rect(cv "Metal4" 56.325 3.835 56.575 3.925)
rect(cv "Via4" 56.415 3.845 56.485 3.915)
rect(cv "Metal4" 56.325 3.835 56.575 3.925)
rect(cv "Metal5" 56.405 3.755 56.495 4.005)
rect(cv "Metal5" 56.41 3.84 56.49 8.96)
rect(cv "Via4" 56.415 8.885 56.485 8.955)
rect(cv "Metal4" 56.325 8.875 56.575 8.965)
rect(cv "Metal5" 56.405 8.795 56.495 9.045)
rect(cv "Via3" 56.735 3.845 56.805 3.915)
rect(cv "Metal3" 56.725 3.755 56.815 4.005)
rect(cv "Metal4" 56.645 3.835 56.895 3.925)
rect(cv "Via4" 56.735 3.845 56.805 3.915)
rect(cv "Metal4" 56.645 3.835 56.895 3.925)
rect(cv "Metal5" 56.725 3.755 56.815 4.005)
rect(cv "Metal5" 56.73 3.84 56.81 9.12)
rect(cv "Via4" 56.735 9.045 56.805 9.115)
rect(cv "Metal4" 56.645 9.035 56.895 9.125)
rect(cv "Metal5" 56.725 8.955 56.815 9.205)
rect(cv "Via3" 57.055 3.845 57.125 3.915)
rect(cv "Metal3" 57.045 3.755 57.135 4.005)
rect(cv "Metal4" 56.965 3.835 57.215 3.925)
rect(cv "Via4" 57.055 3.845 57.125 3.915)
rect(cv "Metal4" 56.965 3.835 57.215 3.925)
rect(cv "Metal5" 57.045 3.755 57.135 4.005)
rect(cv "Metal5" 57.05 3.84 57.13 9.92)
rect(cv "Via4" 57.055 9.845 57.125 9.915)
rect(cv "Metal4" 56.965 9.835 57.215 9.925)
rect(cv "Metal5" 57.045 9.755 57.135 10.005)
rect(cv "Via3" 57.375 3.845 57.445 3.915)
rect(cv "Metal3" 57.365 3.755 57.455 4.005)
rect(cv "Metal4" 57.285 3.835 57.535 3.925)
rect(cv "Via4" 57.375 3.845 57.445 3.915)
rect(cv "Metal4" 57.285 3.835 57.535 3.925)
rect(cv "Metal5" 57.365 3.755 57.455 4.005)
rect(cv "Metal5" 57.37 3.84 57.45 10.08)
rect(cv "Via4" 57.375 10.005 57.445 10.075)
rect(cv "Metal4" 57.285 9.995 57.535 10.085)
rect(cv "Metal5" 57.365 9.915 57.455 10.165)
rect(cv "Via3" 60.045 3.845 60.115 3.915)
rect(cv "Metal3" 60.035 3.755 60.125 4.005)
rect(cv "Metal4" 59.955 3.835 60.205 3.925)
rect(cv "Via4" 60.045 3.845 60.115 3.915)
rect(cv "Metal4" 59.955 3.835 60.205 3.925)
rect(cv "Metal5" 60.035 3.755 60.125 4.005)
rect(cv "Metal5" 60.04 3.84 60.12 9.28)
rect(cv "Via4" 60.045 9.205 60.115 9.275)
rect(cv "Metal4" 59.955 9.195 60.205 9.285)
rect(cv "Metal5" 60.035 9.115 60.125 9.365)
rect(cv "Via3" 60.365 3.845 60.435 3.915)
rect(cv "Metal3" 60.355 3.755 60.445 4.005)
rect(cv "Metal4" 60.275 3.835 60.525 3.925)
rect(cv "Via4" 60.365 3.845 60.435 3.915)
rect(cv "Metal4" 60.275 3.835 60.525 3.925)
rect(cv "Metal5" 60.355 3.755 60.445 4.005)
rect(cv "Metal5" 60.36 3.84 60.44 9.44)
rect(cv "Via4" 60.365 9.365 60.435 9.435)
rect(cv "Metal4" 60.275 9.355 60.525 9.445)
rect(cv "Metal5" 60.355 9.275 60.445 9.525)
rect(cv "Via3" 60.685 3.845 60.755 3.915)
rect(cv "Metal3" 60.675 3.755 60.765 4.005)
rect(cv "Metal4" 60.595 3.835 60.845 3.925)
rect(cv "Via4" 60.685 3.845 60.755 3.915)
rect(cv "Metal4" 60.595 3.835 60.845 3.925)
rect(cv "Metal5" 60.675 3.755 60.765 4.005)
rect(cv "Metal5" 60.68 3.84 60.76 9.92)
rect(cv "Via4" 60.685 9.845 60.755 9.915)
rect(cv "Metal4" 60.595 9.835 60.845 9.925)
rect(cv "Metal5" 60.675 9.755 60.765 10.005)
rect(cv "Via3" 61.005 3.845 61.075 3.915)
rect(cv "Metal3" 60.995 3.755 61.085 4.005)
rect(cv "Metal4" 60.915 3.835 61.165 3.925)
rect(cv "Via4" 61.005 3.845 61.075 3.915)
rect(cv "Metal4" 60.915 3.835 61.165 3.925)
rect(cv "Metal5" 60.995 3.755 61.085 4.005)
rect(cv "Metal5" 61 3.84 61.08 10.08)
rect(cv "Via4" 61.005 10.005 61.075 10.075)
rect(cv "Metal4" 60.915 9.995 61.165 10.085)
rect(cv "Metal5" 60.995 9.915 61.085 10.165)
rect(cv "Via3" 63.675 7.445 63.745 7.515)
rect(cv "Metal3" 63.665 7.355 63.755 7.605)
rect(cv "Metal4" 63.585 7.435 63.835 7.525)
rect(cv "Via4" 63.675 7.445 63.745 7.515)
rect(cv "Metal4" 63.585 7.435 63.835 7.525)
rect(cv "Metal5" 63.665 7.355 63.755 7.605)
rect(cv "Metal5" 63.67 7.44 63.75 9.12)
rect(cv "Via4" 63.675 9.045 63.745 9.115)
rect(cv "Metal4" 63.585 9.035 63.835 9.125)
rect(cv "Metal5" 63.665 8.955 63.755 9.205)
rect(cv "Via3" 63.995 7.445 64.065 7.515)
rect(cv "Metal3" 63.985 7.355 64.075 7.605)
rect(cv "Metal4" 63.905 7.435 64.155 7.525)
rect(cv "Via4" 63.995 7.445 64.065 7.515)
rect(cv "Metal4" 63.905 7.435 64.155 7.525)
rect(cv "Metal5" 63.985 7.355 64.075 7.605)
rect(cv "Metal5" 63.99 7.44 64.07 9.44)
rect(cv "Via4" 63.995 9.365 64.065 9.435)
rect(cv "Metal4" 63.905 9.355 64.155 9.445)
rect(cv "Metal5" 63.985 9.275 64.075 9.525)
rect(cv "Via3" 64.315 7.445 64.385 7.515)
rect(cv "Metal3" 64.305 7.355 64.395 7.605)
rect(cv "Metal4" 64.225 7.435 64.475 7.525)
rect(cv "Via4" 64.315 7.445 64.385 7.515)
rect(cv "Metal4" 64.225 7.435 64.475 7.525)
rect(cv "Metal5" 64.305 7.355 64.395 7.605)
rect(cv "Metal5" 64.31 7.44 64.39 9.92)
rect(cv "Via4" 64.315 9.845 64.385 9.915)
rect(cv "Metal4" 64.225 9.835 64.475 9.925)
rect(cv "Metal5" 64.305 9.755 64.395 10.005)
rect(cv "Via3" 64.635 7.445 64.705 7.515)
rect(cv "Metal3" 64.625 7.355 64.715 7.605)
rect(cv "Metal4" 64.545 7.435 64.795 7.525)
rect(cv "Via4" 64.635 7.445 64.705 7.515)
rect(cv "Metal4" 64.545 7.435 64.795 7.525)
rect(cv "Metal5" 64.625 7.355 64.715 7.605)
rect(cv "Metal5" 64.63 7.44 64.71 11.2)
rect(cv "Via4" 64.635 11.125 64.705 11.195)
rect(cv "Metal4" 64.545 11.115 64.795 11.205)
rect(cv "Metal5" 64.625 11.035 64.715 11.285)
rect(cv "Via3" 64.955 7.445 65.025 7.515)
rect(cv "Metal3" 64.945 7.355 65.035 7.605)
rect(cv "Metal4" 64.865 7.435 65.115 7.525)
rect(cv "Via4" 64.955 7.445 65.025 7.515)
rect(cv "Metal4" 64.865 7.435 65.115 7.525)
rect(cv "Metal5" 64.945 7.355 65.035 7.605)
rect(cv "Metal5" 64.95 7.44 65.03 9.92)
rect(cv "Via4" 64.955 9.845 65.025 9.915)
rect(cv "Metal4" 64.865 9.835 65.115 9.925)
rect(cv "Metal5" 64.945 9.755 65.035 10.005)
rect(cv "Via3" 65.275 7.445 65.345 7.515)
rect(cv "Metal3" 65.265 7.355 65.355 7.605)
rect(cv "Metal4" 65.185 7.435 65.435 7.525)
rect(cv "Via4" 65.275 7.445 65.345 7.515)
rect(cv "Metal4" 65.185 7.435 65.435 7.525)
rect(cv "Metal5" 65.265 7.355 65.355 7.605)
rect(cv "Metal5" 65.27 7.44 65.35 10.08)
rect(cv "Via4" 65.275 10.005 65.345 10.075)
rect(cv "Metal4" 65.185 9.995 65.435 10.085)
rect(cv "Metal5" 65.265 9.915 65.355 10.165)
rect(cv "Via3" 71.005 3.845 71.075 3.915)
rect(cv "Metal3" 70.995 3.755 71.085 4.005)
rect(cv "Metal4" 70.915 3.835 71.165 3.925)
rect(cv "Via4" 71.005 3.845 71.075 3.915)
rect(cv "Metal4" 70.915 3.835 71.165 3.925)
rect(cv "Metal5" 70.995 3.755 71.085 4.005)
rect(cv "Metal5" 71 3.84 71.08 11.2)
rect(cv "Via4" 71.005 11.125 71.075 11.195)
rect(cv "Metal4" 70.915 11.115 71.165 11.205)
rect(cv "Metal5" 70.995 11.035 71.085 11.285)
rect(cv "Via3" 71.325 3.845 71.395 3.915)
rect(cv "Metal3" 71.315 3.755 71.405 4.005)
rect(cv "Metal4" 71.235 3.835 71.485 3.925)
rect(cv "Via4" 71.325 3.845 71.395 3.915)
rect(cv "Metal4" 71.235 3.835 71.485 3.925)
rect(cv "Metal5" 71.315 3.755 71.405 4.005)
rect(cv "Metal5" 71.32 3.84 71.4 9.6)
rect(cv "Via4" 71.325 9.525 71.395 9.595)
rect(cv "Metal4" 71.235 9.515 71.485 9.605)
rect(cv "Metal5" 71.315 9.435 71.405 9.685)
rect(cv "Via3" 71.645 3.845 71.715 3.915)
rect(cv "Metal3" 71.635 3.755 71.725 4.005)
rect(cv "Metal4" 71.555 3.835 71.805 3.925)
rect(cv "Via4" 71.645 3.845 71.715 3.915)
rect(cv "Metal4" 71.555 3.835 71.805 3.925)
rect(cv "Metal5" 71.635 3.755 71.725 4.005)
rect(cv "Metal5" 71.64 3.84 71.72 9.92)
rect(cv "Via4" 71.645 9.845 71.715 9.915)
rect(cv "Metal4" 71.555 9.835 71.805 9.925)
rect(cv "Metal5" 71.635 9.755 71.725 10.005)
rect(cv "Via3" 71.965 3.845 72.035 3.915)
rect(cv "Metal3" 71.955 3.755 72.045 4.005)
rect(cv "Metal4" 71.875 3.835 72.125 3.925)
rect(cv "Via4" 71.965 3.845 72.035 3.915)
rect(cv "Metal4" 71.875 3.835 72.125 3.925)
rect(cv "Metal5" 71.955 3.755 72.045 4.005)
rect(cv "Metal5" 71.96 3.84 72.04 10.08)
rect(cv "Via4" 71.965 10.005 72.035 10.075)
rect(cv "Metal4" 71.875 9.995 72.125 10.085)
rect(cv "Metal5" 71.955 9.915 72.045 10.165)
rect(cv "Metal4" 0.21 7.92 35.14 8)
rect(cv "Via3" 0.215 7.925 0.285 7.995)
rect(cv "Metal3" 0.205 7.835 0.295 8.085)
rect(cv "Metal4" 0.125 7.915 0.375 8.005)
rect(cv "Metal3" 0.18 7.89 0.32 11.65)
port(cv "CLK1" "Metal3" 0.25 11.58)
rect(cv "Metal4" 0.53 8.08 12.58 8.16)
rect(cv "Via3" 0.535 8.085 0.605 8.155)
rect(cv "Metal3" 0.525 7.995 0.615 8.245)
rect(cv "Metal4" 0.445 8.075 0.695 8.165)
rect(cv "Metal3" 0.5 8.05 0.64 11.65)
port(cv "CLK2" "Metal3" 0.57 11.58)
rect(cv "Metal4" 0.85 8.24 27.17 8.32)
rect(cv "Via3" 0.855 8.245 0.925 8.315)
rect(cv "Metal3" 0.845 8.155 0.935 8.405)
rect(cv "Metal4" 0.765 8.235 1.015 8.325)
rect(cv "Metal3" 0.82 8.21 0.96 11.65)
port(cv "WR" "Metal3" 0.89 11.58)
rect(cv "Metal4" 1.17 8.4 34.5 8.48)
rect(cv "Via3" 1.175 8.405 1.245 8.475)
rect(cv "Metal3" 1.165 8.315 1.255 8.565)
rect(cv "Metal4" 1.085 8.395 1.335 8.485)
rect(cv "Metal3" 1.14 8.37 1.28 11.65)
port(cv "RD" "Metal3" 1.21 11.58)
rect(cv "Metal4" 1.49 8.56 16.21 8.64)
rect(cv "Via3" 1.495 8.565 1.565 8.635)
rect(cv "Metal3" 1.485 8.475 1.575 8.725)
rect(cv "Metal4" 1.405 8.555 1.655 8.645)
rect(cv "Metal3" 1.46 8.53 1.6 11.65)
port(cv "C2" "Metal3" 1.53 11.58)
rect(cv "Metal4" 1.81 8.72 16.53 8.8)
rect(cv "Via3" 1.815 8.725 1.885 8.795)
rect(cv "Metal3" 1.805 8.635 1.895 8.885)
rect(cv "Metal4" 1.725 8.715 1.975 8.805)
rect(cv "Metal3" 1.78 8.69 1.92 11.65)
port(cv "C1" "Metal3" 1.85 11.58)
rect(cv "Metal4" 2.13 8.88 56.49 8.96)
rect(cv "Via3" 2.135 8.885 2.205 8.955)
rect(cv "Metal3" 2.125 8.795 2.215 9.045)
rect(cv "Metal4" 2.045 8.875 2.295 8.965)
rect(cv "Metal3" 2.1 8.85 2.24 11.65)
port(cv "WEN" "Metal3" 2.17 11.58)
rect(cv "Metal4" 2.45 9.04 63.75 9.12)
rect(cv "Via3" 2.455 9.045 2.525 9.115)
rect(cv "Metal3" 2.445 8.955 2.535 9.205)
rect(cv "Metal4" 2.365 9.035 2.615 9.125)
rect(cv "Metal3" 2.42 9.01 2.56 11.65)
port(cv "WENB" "Metal3" 2.49 11.58)
rect(cv "Metal4" 2.77 9.2 60.12 9.28)
rect(cv "Via3" 2.775 9.205 2.845 9.275)
rect(cv "Metal3" 2.765 9.115 2.855 9.365)
rect(cv "Metal4" 2.685 9.195 2.935 9.285)
rect(cv "Metal3" 2.74 9.17 2.88 11.65)
port(cv "REN" "Metal3" 2.81 11.58)
rect(cv "Metal4" 3.09 9.36 64.07 9.44)
rect(cv "Via3" 3.095 9.365 3.165 9.435)
rect(cv "Metal3" 3.085 9.275 3.175 9.525)
rect(cv "Metal4" 3.005 9.355 3.255 9.445)
rect(cv "Metal3" 3.06 9.33 3.2 11.65)
port(cv "RENB" "Metal3" 3.13 11.58)
rect(cv "Metal4" 3.41 9.52 71.4 9.6)
rect(cv "Via3" 3.415 9.525 3.485 9.595)
rect(cv "Metal3" 3.405 9.435 3.495 9.685)
rect(cv "Metal4" 3.325 9.515 3.575 9.605)
rect(cv "Metal3" 3.38 9.49 3.52 11.65)
port(cv "ROWEN" "Metal3" 3.45 11.58)
rect(cv "Metal4" 3.73 9.68 49.8 9.76)
rect(cv "Via3" 3.735 9.685 3.805 9.755)
rect(cv "Metal3" 3.725 9.595 3.815 9.845)
rect(cv "Metal4" 3.645 9.675 3.895 9.765)
rect(cv "Metal3" 3.7 9.65 3.84 11.65)
port(cv "PCB" "Metal3" 3.77 11.58)
rect(cv "Metal4" 4.05 9.84 71.72 9.92)
rect(cv "Via3" 4.055 9.845 4.125 9.915)
rect(cv "Metal3" 4.045 9.755 4.135 10.005)
rect(cv "Metal4" 3.965 9.835 4.215 9.925)
rect(cv "Metal3" 4.02 9.81 4.16 11.65)
port(cv "VDD" "Metal3" 4.09 11.58)
rect(cv "Metal4" 4.37 10 72.04 10.08)
rect(cv "Via3" 4.375 10.005 4.445 10.075)
rect(cv "Metal3" 4.365 9.915 4.455 10.165)
rect(cv "Metal4" 4.285 9.995 4.535 10.085)
rect(cv "Metal3" 4.34 9.97 4.48 11.65)
port(cv "GND" "Metal3" 4.41 11.58)
rect(cv "Metal4" 5.56 10.16 27.49 10.24)
rect(cv "Metal4" 9.19 10.32 34.82 10.4)
rect(cv "Metal4" 17.09 10.48 23.54 10.56)
rect(cv "Metal4" 23.78 10.64 49.48 10.72)
rect(cv "Metal4" 28.05 10.8 41.83 10.88)
rect(cv "Metal4" 35.38 10.96 49.16 11.04)
rect(cv "Metal4" 64.63 11.12 71.08 11.2)
rect(cv "prBoundary" 0.0 0.0 74.42 11.66)
dbSave(cv) printf("LAYOUT rw_control %L\n" cv~>bBox) dbClose(cv)
cv=dbOpenCellViewByType("sram_project" "write_driver" "layout" "maskLayout" "w")
dbCreateInst(cv dbOpenCellViewByType("sram_project" "inv" "layout" "" "r") "ID" list(2.79 0.35) "R0")
dbCreateInst(cv dbOpenCellViewByType("sram_project" "tg" "layout" "" "r") "W0" list(6.42 0.35) "R0")
dbCreateInst(cv dbOpenCellViewByType("sram_project" "tg" "layout" "" "r") "W1" list(10.69 0.35) "R0")
rect(cv "Via3" 3.005 3.845 3.075 3.915)
rect(cv "Metal3" 2.995 3.755 3.085 4.005)
rect(cv "Metal4" 2.915 3.835 3.165 3.925)
rect(cv "Via4" 3.005 3.845 3.075 3.915)
rect(cv "Metal4" 2.915 3.835 3.165 3.925)
rect(cv "Metal5" 2.995 3.755 3.085 4.005)
rect(cv "Metal5" 3 3.84 3.08 5.84)
rect(cv "Via4" 3.005 5.765 3.075 5.835)
rect(cv "Metal4" 2.915 5.755 3.165 5.845)
rect(cv "Metal5" 2.995 5.675 3.085 5.925)
rect(cv "Via3" 3.325 3.845 3.395 3.915)
rect(cv "Metal3" 3.315 3.755 3.405 4.005)
rect(cv "Metal4" 3.235 3.835 3.485 3.925)
rect(cv "Via4" 3.325 3.845 3.395 3.915)
rect(cv "Metal4" 3.235 3.835 3.485 3.925)
rect(cv "Metal5" 3.315 3.755 3.405 4.005)
rect(cv "Metal5" 3.32 3.84 3.4 6.96)
rect(cv "Via4" 3.325 6.885 3.395 6.955)
rect(cv "Metal4" 3.235 6.875 3.485 6.965)
rect(cv "Metal5" 3.315 6.795 3.405 7.045)
rect(cv "Via3" 3.645 3.845 3.715 3.915)
rect(cv "Metal3" 3.635 3.755 3.725 4.005)
rect(cv "Metal4" 3.555 3.835 3.805 3.925)
rect(cv "Via4" 3.645 3.845 3.715 3.915)
rect(cv "Metal4" 3.555 3.835 3.805 3.925)
rect(cv "Metal5" 3.635 3.755 3.725 4.005)
rect(cv "Metal5" 3.64 3.84 3.72 6.64)
rect(cv "Via4" 3.645 6.565 3.715 6.635)
rect(cv "Metal4" 3.555 6.555 3.805 6.645)
rect(cv "Metal5" 3.635 6.475 3.725 6.725)
rect(cv "Via3" 3.965 3.845 4.035 3.915)
rect(cv "Metal3" 3.955 3.755 4.045 4.005)
rect(cv "Metal4" 3.875 3.835 4.125 3.925)
rect(cv "Via4" 3.965 3.845 4.035 3.915)
rect(cv "Metal4" 3.875 3.835 4.125 3.925)
rect(cv "Metal5" 3.955 3.755 4.045 4.005)
rect(cv "Metal5" 3.96 3.84 4.04 6.8)
rect(cv "Via4" 3.965 6.725 4.035 6.795)
rect(cv "Metal4" 3.875 6.715 4.125 6.805)
rect(cv "Metal5" 3.955 6.635 4.045 6.885)
rect(cv "Via3" 6.635 5.285 6.705 5.355)
rect(cv "Metal3" 6.625 5.195 6.715 5.445)
rect(cv "Metal4" 6.545 5.275 6.795 5.365)
rect(cv "Via4" 6.635 5.285 6.705 5.355)
rect(cv "Metal4" 6.545 5.275 6.795 5.365)
rect(cv "Metal5" 6.625 5.195 6.715 5.445)
rect(cv "Metal5" 6.63 5.28 6.71 5.84)
rect(cv "Via4" 6.635 5.765 6.705 5.835)
rect(cv "Metal4" 6.545 5.755 6.795 5.845)
rect(cv "Metal5" 6.625 5.675 6.715 5.925)
rect(cv "Via3" 6.955 5.285 7.025 5.355)
rect(cv "Metal3" 6.945 5.195 7.035 5.445)
rect(cv "Metal4" 6.865 5.275 7.115 5.365)
rect(cv "Via4" 6.955 5.285 7.025 5.355)
rect(cv "Metal4" 6.865 5.275 7.115 5.365)
rect(cv "Metal5" 6.945 5.195 7.035 5.445)
rect(cv "Metal5" 6.95 5.28 7.03 6.32)
rect(cv "Via4" 6.955 6.245 7.025 6.315)
rect(cv "Metal4" 6.865 6.235 7.115 6.325)
rect(cv "Metal5" 6.945 6.155 7.035 6.405)
rect(cv "Via3" 7.275 5.285 7.345 5.355)
rect(cv "Metal3" 7.265 5.195 7.355 5.445)
rect(cv "Metal4" 7.185 5.275 7.435 5.365)
rect(cv "Via4" 7.275 5.285 7.345 5.355)
rect(cv "Metal4" 7.185 5.275 7.435 5.365)
rect(cv "Metal5" 7.265 5.195 7.355 5.445)
rect(cv "Metal5" 7.27 5.28 7.35 6)
rect(cv "Via4" 7.275 5.925 7.345 5.995)
rect(cv "Metal4" 7.185 5.915 7.435 6.005)
rect(cv "Metal5" 7.265 5.835 7.355 6.085)
rect(cv "Via3" 7.595 5.285 7.665 5.355)
rect(cv "Metal3" 7.585 5.195 7.675 5.445)
rect(cv "Metal4" 7.505 5.275 7.755 5.365)
rect(cv "Via4" 7.595 5.285 7.665 5.355)
rect(cv "Metal4" 7.505 5.275 7.755 5.365)
rect(cv "Metal5" 7.585 5.195 7.675 5.445)
rect(cv "Metal5" 7.59 5.28 7.67 6.16)
rect(cv "Via4" 7.595 6.085 7.665 6.155)
rect(cv "Metal4" 7.505 6.075 7.755 6.165)
rect(cv "Metal5" 7.585 5.995 7.675 6.245)
rect(cv "Via3" 7.915 5.285 7.985 5.355)
rect(cv "Metal3" 7.905 5.195 7.995 5.445)
rect(cv "Metal4" 7.825 5.275 8.075 5.365)
rect(cv "Via4" 7.915 5.285 7.985 5.355)
rect(cv "Metal4" 7.825 5.275 8.075 5.365)
rect(cv "Metal5" 7.905 5.195 7.995 5.445)
rect(cv "Metal5" 7.91 5.28 7.99 6.64)
rect(cv "Via4" 7.915 6.565 7.985 6.635)
rect(cv "Metal4" 7.825 6.555 8.075 6.645)
rect(cv "Metal5" 7.905 6.475 7.995 6.725)
rect(cv "Via3" 8.235 5.285 8.305 5.355)
rect(cv "Metal3" 8.225 5.195 8.315 5.445)
rect(cv "Metal4" 8.145 5.275 8.395 5.365)
rect(cv "Via4" 8.235 5.285 8.305 5.355)
rect(cv "Metal4" 8.145 5.275 8.395 5.365)
rect(cv "Metal5" 8.225 5.195 8.315 5.445)
rect(cv "Metal5" 8.23 5.28 8.31 6.8)
rect(cv "Via4" 8.235 6.725 8.305 6.795)
rect(cv "Metal4" 8.145 6.715 8.395 6.805)
rect(cv "Metal5" 8.225 6.635 8.315 6.885)
rect(cv "Via3" 10.905 5.285 10.975 5.355)
rect(cv "Metal3" 10.895 5.195 10.985 5.445)
rect(cv "Metal4" 10.815 5.275 11.065 5.365)
rect(cv "Via4" 10.905 5.285 10.975 5.355)
rect(cv "Metal4" 10.815 5.275 11.065 5.365)
rect(cv "Metal5" 10.895 5.195 10.985 5.445)
rect(cv "Metal5" 10.9 5.28 10.98 6.96)
rect(cv "Via4" 10.905 6.885 10.975 6.955)
rect(cv "Metal4" 10.815 6.875 11.065 6.965)
rect(cv "Metal5" 10.895 6.795 10.985 7.045)
rect(cv "Via3" 11.225 5.285 11.295 5.355)
rect(cv "Metal3" 11.215 5.195 11.305 5.445)
rect(cv "Metal4" 11.135 5.275 11.385 5.365)
rect(cv "Via4" 11.225 5.285 11.295 5.355)
rect(cv "Metal4" 11.135 5.275 11.385 5.365)
rect(cv "Metal5" 11.215 5.195 11.305 5.445)
rect(cv "Metal5" 11.22 5.28 11.3 6.48)
rect(cv "Via4" 11.225 6.405 11.295 6.475)
rect(cv "Metal4" 11.135 6.395 11.385 6.485)
rect(cv "Metal5" 11.215 6.315 11.305 6.565)
rect(cv "Via3" 11.545 5.285 11.615 5.355)
rect(cv "Metal3" 11.535 5.195 11.625 5.445)
rect(cv "Metal4" 11.455 5.275 11.705 5.365)
rect(cv "Via4" 11.545 5.285 11.615 5.355)
rect(cv "Metal4" 11.455 5.275 11.705 5.365)
rect(cv "Metal5" 11.535 5.195 11.625 5.445)
rect(cv "Metal5" 11.54 5.28 11.62 6)
rect(cv "Via4" 11.545 5.925 11.615 5.995)
rect(cv "Metal4" 11.455 5.915 11.705 6.005)
rect(cv "Metal5" 11.535 5.835 11.625 6.085)
rect(cv "Via3" 11.865 5.285 11.935 5.355)
rect(cv "Metal3" 11.855 5.195 11.945 5.445)
rect(cv "Metal4" 11.775 5.275 12.025 5.365)
rect(cv "Via4" 11.865 5.285 11.935 5.355)
rect(cv "Metal4" 11.775 5.275 12.025 5.365)
rect(cv "Metal5" 11.855 5.195 11.945 5.445)
rect(cv "Metal5" 11.86 5.28 11.94 6.16)
rect(cv "Via4" 11.865 6.085 11.935 6.155)
rect(cv "Metal4" 11.775 6.075 12.025 6.165)
rect(cv "Metal5" 11.855 5.995 11.945 6.245)
rect(cv "Via3" 12.185 5.285 12.255 5.355)
rect(cv "Metal3" 12.175 5.195 12.265 5.445)
rect(cv "Metal4" 12.095 5.275 12.345 5.365)
rect(cv "Via4" 12.185 5.285 12.255 5.355)
rect(cv "Metal4" 12.095 5.275 12.345 5.365)
rect(cv "Metal5" 12.175 5.195 12.265 5.445)
rect(cv "Metal5" 12.18 5.28 12.26 6.64)
rect(cv "Via4" 12.185 6.565 12.255 6.635)
rect(cv "Metal4" 12.095 6.555 12.345 6.645)
rect(cv "Metal5" 12.175 6.475 12.265 6.725)
rect(cv "Via3" 12.505 5.285 12.575 5.355)
rect(cv "Metal3" 12.495 5.195 12.585 5.445)
rect(cv "Metal4" 12.415 5.275 12.665 5.365)
rect(cv "Via4" 12.505 5.285 12.575 5.355)
rect(cv "Metal4" 12.415 5.275 12.665 5.365)
rect(cv "Metal5" 12.495 5.195 12.585 5.445)
rect(cv "Metal5" 12.5 5.28 12.58 6.8)
rect(cv "Via4" 12.505 6.725 12.575 6.795)
rect(cv "Metal4" 12.415 6.715 12.665 6.805)
rect(cv "Metal5" 12.495 6.635 12.585 6.885)
rect(cv "Metal4" 0.21 5.76 6.71 5.84)
rect(cv "Via3" 0.215 5.765 0.285 5.835)
rect(cv "Metal3" 0.205 5.675 0.295 5.925)
rect(cv "Metal4" 0.125 5.755 0.375 5.845)
rect(cv "Metal3" 0.18 5.73 0.32 7.41)
port(cv "DIN" "Metal3" 0.25 7.34)
rect(cv "Metal4" 0.53 5.92 11.62 6)
rect(cv "Via3" 0.535 5.925 0.605 5.995)
rect(cv "Metal3" 0.525 5.835 0.615 6.085)
rect(cv "Metal4" 0.445 5.915 0.695 6.005)
rect(cv "Metal3" 0.5 5.89 0.64 7.41)
port(cv "WEN" "Metal3" 0.57 7.34)
rect(cv "Metal4" 0.85 6.08 11.94 6.16)
rect(cv "Via3" 0.855 6.085 0.925 6.155)
rect(cv "Metal3" 0.845 5.995 0.935 6.245)
rect(cv "Metal4" 0.765 6.075 1.015 6.165)
rect(cv "Metal3" 0.82 6.05 0.96 7.41)
port(cv "WENB" "Metal3" 0.89 7.34)
rect(cv "Metal4" 1.17 6.24 7.03 6.32)
rect(cv "Via3" 1.175 6.245 1.245 6.315)
rect(cv "Metal3" 1.165 6.155 1.255 6.405)
rect(cv "Metal4" 1.085 6.235 1.335 6.325)
rect(cv "Metal3" 1.14 6.21 1.28 7.41)
port(cv "GBL" "Metal3" 1.21 7.34)
rect(cv "Metal4" 1.49 6.4 11.3 6.48)
rect(cv "Via3" 1.495 6.405 1.565 6.475)
rect(cv "Metal3" 1.485 6.315 1.575 6.565)
rect(cv "Metal4" 1.405 6.395 1.655 6.485)
rect(cv "Metal3" 1.46 6.37 1.6 7.41)
port(cv "GBLB" "Metal3" 1.53 7.34)
rect(cv "Metal4" 1.81 6.56 12.26 6.64)
rect(cv "Via3" 1.815 6.565 1.885 6.635)
rect(cv "Metal3" 1.805 6.475 1.895 6.725)
rect(cv "Metal4" 1.725 6.555 1.975 6.645)
rect(cv "Metal3" 1.78 6.53 1.92 7.41)
port(cv "VDD" "Metal3" 1.85 7.34)
rect(cv "Metal4" 2.13 6.72 12.58 6.8)
rect(cv "Via3" 2.135 6.725 2.205 6.795)
rect(cv "Metal3" 2.125 6.635 2.215 6.885)
rect(cv "Metal4" 2.045 6.715 2.295 6.805)
rect(cv "Metal3" 2.1 6.69 2.24 7.41)
port(cv "GND" "Metal3" 2.17 7.34)
rect(cv "Metal4" 3.32 6.88 10.98 6.96)
rect(cv "prBoundary" 0.0 0.0 14.96 7.42)
dbSave(cv) printf("LAYOUT write_driver %L\n" cv~>bBox) dbClose(cv)
cv=dbOpenCellViewByType("sram_project" "column_mux" "layout" "maskLayout" "w")
dbCreateInst(cv dbOpenCellViewByType("sram_project" "inv" "layout" "" "r") "I0" list(7.59 0.35) "R0")
dbCreateInst(cv dbOpenCellViewByType("sram_project" "tg" "layout" "" "r") "M0P" list(11.22 0.35) "R0")
dbCreateInst(cv dbOpenCellViewByType("sram_project" "tg" "layout" "" "r") "M0N" list(15.49 0.35) "R0")
dbCreateInst(cv dbOpenCellViewByType("sram_project" "inv" "layout" "" "r") "I1" list(19.76 0.35) "R0")
dbCreateInst(cv dbOpenCellViewByType("sram_project" "tg" "layout" "" "r") "M1P" list(23.39 0.35) "R0")
dbCreateInst(cv dbOpenCellViewByType("sram_project" "tg" "layout" "" "r") "M1N" list(27.66 0.35) "R0")
dbCreateInst(cv dbOpenCellViewByType("sram_project" "inv" "layout" "" "r") "I2" list(31.93 0.35) "R0")
dbCreateInst(cv dbOpenCellViewByType("sram_project" "tg" "layout" "" "r") "M2P" list(35.56 0.35) "R0")
dbCreateInst(cv dbOpenCellViewByType("sram_project" "tg" "layout" "" "r") "M2N" list(39.83 0.35) "R0")
dbCreateInst(cv dbOpenCellViewByType("sram_project" "inv" "layout" "" "r") "I3" list(44.1 0.35) "R0")
dbCreateInst(cv dbOpenCellViewByType("sram_project" "tg" "layout" "" "r") "M3P" list(47.73 0.35) "R0")
dbCreateInst(cv dbOpenCellViewByType("sram_project" "tg" "layout" "" "r") "M3N" list(52 0.35) "R0")
dbCreateInst(cv dbOpenCellViewByType("sram_project" "inv" "layout" "" "r") "I4" list(56.27 0.35) "R0")
dbCreateInst(cv dbOpenCellViewByType("sram_project" "tg" "layout" "" "r") "M4P" list(59.9 0.35) "R0")
dbCreateInst(cv dbOpenCellViewByType("sram_project" "tg" "layout" "" "r") "M4N" list(64.17 0.35) "R0")
dbCreateInst(cv dbOpenCellViewByType("sram_project" "inv" "layout" "" "r") "I5" list(68.44 0.35) "R0")
dbCreateInst(cv dbOpenCellViewByType("sram_project" "tg" "layout" "" "r") "M5P" list(72.07 0.35) "R0")
dbCreateInst(cv dbOpenCellViewByType("sram_project" "tg" "layout" "" "r") "M5N" list(76.34 0.35) "R0")
rect(cv "Via3" 7.805 3.845 7.875 3.915)
rect(cv "Metal3" 7.795 3.755 7.885 4.005)
rect(cv "Metal4" 7.715 3.835 7.965 3.925)
rect(cv "Via4" 7.805 3.845 7.875 3.915)
rect(cv "Metal4" 7.715 3.835 7.965 3.925)
rect(cv "Metal5" 7.795 3.755 7.885 4.005)
rect(cv "Metal5" 7.8 3.84 7.88 5.84)
rect(cv "Via4" 7.805 5.765 7.875 5.835)
rect(cv "Metal4" 7.715 5.755 7.965 5.845)
rect(cv "Metal5" 7.795 5.675 7.885 5.925)
rect(cv "Via3" 8.125 3.845 8.195 3.915)
rect(cv "Metal3" 8.115 3.755 8.205 4.005)
rect(cv "Metal4" 8.035 3.835 8.285 3.925)
rect(cv "Via4" 8.125 3.845 8.195 3.915)
rect(cv "Metal4" 8.035 3.835 8.285 3.925)
rect(cv "Metal5" 8.115 3.755 8.205 4.005)
rect(cv "Metal5" 8.12 3.84 8.2 9.36)
rect(cv "Via4" 8.125 9.285 8.195 9.355)
rect(cv "Metal4" 8.035 9.275 8.285 9.365)
rect(cv "Metal5" 8.115 9.195 8.205 9.445)
rect(cv "Via3" 8.445 3.845 8.515 3.915)
rect(cv "Metal3" 8.435 3.755 8.525 4.005)
rect(cv "Metal4" 8.355 3.835 8.605 3.925)
rect(cv "Via4" 8.445 3.845 8.515 3.915)
rect(cv "Metal4" 8.355 3.835 8.605 3.925)
rect(cv "Metal5" 8.435 3.755 8.525 4.005)
rect(cv "Metal5" 8.44 3.84 8.52 9.04)
rect(cv "Via4" 8.445 8.965 8.515 9.035)
rect(cv "Metal4" 8.355 8.955 8.605 9.045)
rect(cv "Metal5" 8.435 8.875 8.525 9.125)
rect(cv "Via3" 8.765 3.845 8.835 3.915)
rect(cv "Metal3" 8.755 3.755 8.845 4.005)
rect(cv "Metal4" 8.675 3.835 8.925 3.925)
rect(cv "Via4" 8.765 3.845 8.835 3.915)
rect(cv "Metal4" 8.675 3.835 8.925 3.925)
rect(cv "Metal5" 8.755 3.755 8.845 4.005)
rect(cv "Metal5" 8.76 3.84 8.84 9.2)
rect(cv "Via4" 8.765 9.125 8.835 9.195)
rect(cv "Metal4" 8.675 9.115 8.925 9.205)
rect(cv "Metal5" 8.755 9.035 8.845 9.285)
rect(cv "Via3" 11.435 5.285 11.505 5.355)
rect(cv "Metal3" 11.425 5.195 11.515 5.445)
rect(cv "Metal4" 11.345 5.275 11.595 5.365)
rect(cv "Via4" 11.435 5.285 11.505 5.355)
rect(cv "Metal4" 11.345 5.275 11.595 5.365)
rect(cv "Metal5" 11.425 5.195 11.515 5.445)
rect(cv "Metal5" 11.43 5.28 11.51 6.8)
rect(cv "Via4" 11.435 6.725 11.505 6.795)
rect(cv "Metal4" 11.345 6.715 11.595 6.805)
rect(cv "Metal5" 11.425 6.635 11.515 6.885)
rect(cv "Via3" 11.755 5.285 11.825 5.355)
rect(cv "Metal3" 11.745 5.195 11.835 5.445)
rect(cv "Metal4" 11.665 5.275 11.915 5.365)
rect(cv "Via4" 11.755 5.285 11.825 5.355)
rect(cv "Metal4" 11.665 5.275 11.915 5.365)
rect(cv "Metal5" 11.745 5.195 11.835 5.445)
rect(cv "Metal5" 11.75 5.28 11.83 8.72)
rect(cv "Via4" 11.755 8.645 11.825 8.715)
rect(cv "Metal4" 11.665 8.635 11.915 8.725)
rect(cv "Metal5" 11.745 8.555 11.835 8.805)
rect(cv "Via3" 12.075 5.285 12.145 5.355)
rect(cv "Metal3" 12.065 5.195 12.155 5.445)
rect(cv "Metal4" 11.985 5.275 12.235 5.365)
rect(cv "Via4" 12.075 5.285 12.145 5.355)
rect(cv "Metal4" 11.985 5.275 12.235 5.365)
rect(cv "Metal5" 12.065 5.195 12.155 5.445)
rect(cv "Metal5" 12.07 5.28 12.15 5.84)
rect(cv "Via4" 12.075 5.765 12.145 5.835)
rect(cv "Metal4" 11.985 5.755 12.235 5.845)
rect(cv "Metal5" 12.065 5.675 12.155 5.925)
rect(cv "Via3" 12.395 5.285 12.465 5.355)
rect(cv "Metal3" 12.385 5.195 12.475 5.445)
rect(cv "Metal4" 12.305 5.275 12.555 5.365)
rect(cv "Via4" 12.395 5.285 12.465 5.355)
rect(cv "Metal4" 12.305 5.275 12.555 5.365)
rect(cv "Metal5" 12.385 5.195 12.475 5.445)
rect(cv "Metal5" 12.39 5.28 12.47 9.36)
rect(cv "Via4" 12.395 9.285 12.465 9.355)
rect(cv "Metal4" 12.305 9.275 12.555 9.365)
rect(cv "Metal5" 12.385 9.195 12.475 9.445)
rect(cv "Via3" 12.715 5.285 12.785 5.355)
rect(cv "Metal3" 12.705 5.195 12.795 5.445)
rect(cv "Metal4" 12.625 5.275 12.875 5.365)
rect(cv "Via4" 12.715 5.285 12.785 5.355)
rect(cv "Metal4" 12.625 5.275 12.875 5.365)
rect(cv "Metal5" 12.705 5.195 12.795 5.445)
rect(cv "Metal5" 12.71 5.28 12.79 9.04)
rect(cv "Via4" 12.715 8.965 12.785 9.035)
rect(cv "Metal4" 12.625 8.955 12.875 9.045)
rect(cv "Metal5" 12.705 8.875 12.795 9.125)
rect(cv "Via3" 13.035 5.285 13.105 5.355)
rect(cv "Metal3" 13.025 5.195 13.115 5.445)
rect(cv "Metal4" 12.945 5.275 13.195 5.365)
rect(cv "Via4" 13.035 5.285 13.105 5.355)
rect(cv "Metal4" 12.945 5.275 13.195 5.365)
rect(cv "Metal5" 13.025 5.195 13.115 5.445)
rect(cv "Metal5" 13.03 5.28 13.11 9.2)
rect(cv "Via4" 13.035 9.125 13.105 9.195)
rect(cv "Metal4" 12.945 9.115 13.195 9.205)
rect(cv "Metal5" 13.025 9.035 13.115 9.285)
rect(cv "Via3" 15.705 5.285 15.775 5.355)
rect(cv "Metal3" 15.695 5.195 15.785 5.445)
rect(cv "Metal4" 15.615 5.275 15.865 5.365)
rect(cv "Via4" 15.705 5.285 15.775 5.355)
rect(cv "Metal4" 15.615 5.275 15.865 5.365)
rect(cv "Metal5" 15.695 5.195 15.785 5.445)
rect(cv "Metal5" 15.7 5.28 15.78 7.76)
rect(cv "Via4" 15.705 7.685 15.775 7.755)
rect(cv "Metal4" 15.615 7.675 15.865 7.765)
rect(cv "Metal5" 15.695 7.595 15.785 7.845)
rect(cv "Via3" 16.025 5.285 16.095 5.355)
rect(cv "Metal3" 16.015 5.195 16.105 5.445)
rect(cv "Metal4" 15.935 5.275 16.185 5.365)
rect(cv "Via4" 16.025 5.285 16.095 5.355)
rect(cv "Metal4" 15.935 5.275 16.185 5.365)
rect(cv "Metal5" 16.015 5.195 16.105 5.445)
rect(cv "Metal5" 16.02 5.28 16.1 8.88)
rect(cv "Via4" 16.025 8.805 16.095 8.875)
rect(cv "Metal4" 15.935 8.795 16.185 8.885)
rect(cv "Metal5" 16.015 8.715 16.105 8.965)
rect(cv "Via3" 16.345 5.285 16.415 5.355)
rect(cv "Metal3" 16.335 5.195 16.425 5.445)
rect(cv "Metal4" 16.255 5.275 16.505 5.365)
rect(cv "Via4" 16.345 5.285 16.415 5.355)
rect(cv "Metal4" 16.255 5.275 16.505 5.365)
rect(cv "Metal5" 16.335 5.195 16.425 5.445)
rect(cv "Metal5" 16.34 5.28 16.42 5.84)
rect(cv "Via4" 16.345 5.765 16.415 5.835)
rect(cv "Metal4" 16.255 5.755 16.505 5.845)
rect(cv "Metal5" 16.335 5.675 16.425 5.925)
rect(cv "Via3" 16.665 5.285 16.735 5.355)
rect(cv "Metal3" 16.655 5.195 16.745 5.445)
rect(cv "Metal4" 16.575 5.275 16.825 5.365)
rect(cv "Via4" 16.665 5.285 16.735 5.355)
rect(cv "Metal4" 16.575 5.275 16.825 5.365)
rect(cv "Metal5" 16.655 5.195 16.745 5.445)
rect(cv "Metal5" 16.66 5.28 16.74 9.36)
rect(cv "Via4" 16.665 9.285 16.735 9.355)
rect(cv "Metal4" 16.575 9.275 16.825 9.365)
rect(cv "Metal5" 16.655 9.195 16.745 9.445)
rect(cv "Via3" 16.985 5.285 17.055 5.355)
rect(cv "Metal3" 16.975 5.195 17.065 5.445)
rect(cv "Metal4" 16.895 5.275 17.145 5.365)
rect(cv "Via4" 16.985 5.285 17.055 5.355)
rect(cv "Metal4" 16.895 5.275 17.145 5.365)
rect(cv "Metal5" 16.975 5.195 17.065 5.445)
rect(cv "Metal5" 16.98 5.28 17.06 9.04)
rect(cv "Via4" 16.985 8.965 17.055 9.035)
rect(cv "Metal4" 16.895 8.955 17.145 9.045)
rect(cv "Metal5" 16.975 8.875 17.065 9.125)
rect(cv "Via3" 17.305 5.285 17.375 5.355)
rect(cv "Metal3" 17.295 5.195 17.385 5.445)
rect(cv "Metal4" 17.215 5.275 17.465 5.365)
rect(cv "Via4" 17.305 5.285 17.375 5.355)
rect(cv "Metal4" 17.215 5.275 17.465 5.365)
rect(cv "Metal5" 17.295 5.195 17.385 5.445)
rect(cv "Metal5" 17.3 5.28 17.38 9.2)
rect(cv "Via4" 17.305 9.125 17.375 9.195)
rect(cv "Metal4" 17.215 9.115 17.465 9.205)
rect(cv "Metal5" 17.295 9.035 17.385 9.285)
rect(cv "Via3" 19.975 3.845 20.045 3.915)
rect(cv "Metal3" 19.965 3.755 20.055 4.005)
rect(cv "Metal4" 19.885 3.835 20.135 3.925)
rect(cv "Via4" 19.975 3.845 20.045 3.915)
rect(cv "Metal4" 19.885 3.835 20.135 3.925)
rect(cv "Metal5" 19.965 3.755 20.055 4.005)
rect(cv "Metal5" 19.97 3.84 20.05 6)
rect(cv "Via4" 19.975 5.925 20.045 5.995)
rect(cv "Metal4" 19.885 5.915 20.135 6.005)
rect(cv "Metal5" 19.965 5.835 20.055 6.085)
rect(cv "Via3" 20.295 3.845 20.365 3.915)
rect(cv "Metal3" 20.285 3.755 20.375 4.005)
rect(cv "Metal4" 20.205 3.835 20.455 3.925)
rect(cv "Via4" 20.295 3.845 20.365 3.915)
rect(cv "Metal4" 20.205 3.835 20.455 3.925)
rect(cv "Metal5" 20.285 3.755 20.375 4.005)
rect(cv "Metal5" 20.29 3.84 20.37 9.52)
rect(cv "Via4" 20.295 9.445 20.365 9.515)
rect(cv "Metal4" 20.205 9.435 20.455 9.525)
rect(cv "Metal5" 20.285 9.355 20.375 9.605)
rect(cv "Via3" 20.615 3.845 20.685 3.915)
rect(cv "Metal3" 20.605 3.755 20.695 4.005)
rect(cv "Metal4" 20.525 3.835 20.775 3.925)
rect(cv "Via4" 20.615 3.845 20.685 3.915)
rect(cv "Metal4" 20.525 3.835 20.775 3.925)
rect(cv "Metal5" 20.605 3.755 20.695 4.005)
rect(cv "Metal5" 20.61 3.84 20.69 9.04)
rect(cv "Via4" 20.615 8.965 20.685 9.035)
rect(cv "Metal4" 20.525 8.955 20.775 9.045)
rect(cv "Metal5" 20.605 8.875 20.695 9.125)
rect(cv "Via3" 20.935 3.845 21.005 3.915)
rect(cv "Metal3" 20.925 3.755 21.015 4.005)
rect(cv "Metal4" 20.845 3.835 21.095 3.925)
rect(cv "Via4" 20.935 3.845 21.005 3.915)
rect(cv "Metal4" 20.845 3.835 21.095 3.925)
rect(cv "Metal5" 20.925 3.755 21.015 4.005)
rect(cv "Metal5" 20.93 3.84 21.01 9.2)
rect(cv "Via4" 20.935 9.125 21.005 9.195)
rect(cv "Metal4" 20.845 9.115 21.095 9.205)
rect(cv "Metal5" 20.925 9.035 21.015 9.285)
rect(cv "Via3" 23.605 5.285 23.675 5.355)
rect(cv "Metal3" 23.595 5.195 23.685 5.445)
rect(cv "Metal4" 23.515 5.275 23.765 5.365)
rect(cv "Via4" 23.605 5.285 23.675 5.355)
rect(cv "Metal4" 23.515 5.275 23.765 5.365)
rect(cv "Metal5" 23.595 5.195 23.685 5.445)
rect(cv "Metal5" 23.6 5.28 23.68 6.96)
rect(cv "Via4" 23.605 6.885 23.675 6.955)
rect(cv "Metal4" 23.515 6.875 23.765 6.965)
rect(cv "Metal5" 23.595 6.795 23.685 7.045)
rect(cv "Via3" 23.925 5.285 23.995 5.355)
rect(cv "Metal3" 23.915 5.195 24.005 5.445)
rect(cv "Metal4" 23.835 5.275 24.085 5.365)
rect(cv "Via4" 23.925 5.285 23.995 5.355)
rect(cv "Metal4" 23.835 5.275 24.085 5.365)
rect(cv "Metal5" 23.915 5.195 24.005 5.445)
rect(cv "Metal5" 23.92 5.28 24 8.72)
rect(cv "Via4" 23.925 8.645 23.995 8.715)
rect(cv "Metal4" 23.835 8.635 24.085 8.725)
rect(cv "Metal5" 23.915 8.555 24.005 8.805)
rect(cv "Via3" 24.245 5.285 24.315 5.355)
rect(cv "Metal3" 24.235 5.195 24.325 5.445)
rect(cv "Metal4" 24.155 5.275 24.405 5.365)
rect(cv "Via4" 24.245 5.285 24.315 5.355)
rect(cv "Metal4" 24.155 5.275 24.405 5.365)
rect(cv "Metal5" 24.235 5.195 24.325 5.445)
rect(cv "Metal5" 24.24 5.28 24.32 6)
rect(cv "Via4" 24.245 5.925 24.315 5.995)
rect(cv "Metal4" 24.155 5.915 24.405 6.005)
rect(cv "Metal5" 24.235 5.835 24.325 6.085)
rect(cv "Via3" 24.565 5.285 24.635 5.355)
rect(cv "Metal3" 24.555 5.195 24.645 5.445)
rect(cv "Metal4" 24.475 5.275 24.725 5.365)
rect(cv "Via4" 24.565 5.285 24.635 5.355)
rect(cv "Metal4" 24.475 5.275 24.725 5.365)
rect(cv "Metal5" 24.555 5.195 24.645 5.445)
rect(cv "Metal5" 24.56 5.28 24.64 9.52)
rect(cv "Via4" 24.565 9.445 24.635 9.515)
rect(cv "Metal4" 24.475 9.435 24.725 9.525)
rect(cv "Metal5" 24.555 9.355 24.645 9.605)
rect(cv "Via3" 24.885 5.285 24.955 5.355)
rect(cv "Metal3" 24.875 5.195 24.965 5.445)
rect(cv "Metal4" 24.795 5.275 25.045 5.365)
rect(cv "Via4" 24.885 5.285 24.955 5.355)
rect(cv "Metal4" 24.795 5.275 25.045 5.365)
rect(cv "Metal5" 24.875 5.195 24.965 5.445)
rect(cv "Metal5" 24.88 5.28 24.96 9.04)
rect(cv "Via4" 24.885 8.965 24.955 9.035)
rect(cv "Metal4" 24.795 8.955 25.045 9.045)
rect(cv "Metal5" 24.875 8.875 24.965 9.125)
rect(cv "Via3" 25.205 5.285 25.275 5.355)
rect(cv "Metal3" 25.195 5.195 25.285 5.445)
rect(cv "Metal4" 25.115 5.275 25.365 5.365)
rect(cv "Via4" 25.205 5.285 25.275 5.355)
rect(cv "Metal4" 25.115 5.275 25.365 5.365)
rect(cv "Metal5" 25.195 5.195 25.285 5.445)
rect(cv "Metal5" 25.2 5.28 25.28 9.2)
rect(cv "Via4" 25.205 9.125 25.275 9.195)
rect(cv "Metal4" 25.115 9.115 25.365 9.205)
rect(cv "Metal5" 25.195 9.035 25.285 9.285)
rect(cv "Via3" 27.875 5.285 27.945 5.355)
rect(cv "Metal3" 27.865 5.195 27.955 5.445)
rect(cv "Metal4" 27.785 5.275 28.035 5.365)
rect(cv "Via4" 27.875 5.285 27.945 5.355)
rect(cv "Metal4" 27.785 5.275 28.035 5.365)
rect(cv "Metal5" 27.865 5.195 27.955 5.445)
rect(cv "Metal5" 27.87 5.28 27.95 7.92)
rect(cv "Via4" 27.875 7.845 27.945 7.915)
rect(cv "Metal4" 27.785 7.835 28.035 7.925)
rect(cv "Metal5" 27.865 7.755 27.955 8.005)
rect(cv "Via3" 28.195 5.285 28.265 5.355)
rect(cv "Metal3" 28.185 5.195 28.275 5.445)
rect(cv "Metal4" 28.105 5.275 28.355 5.365)
rect(cv "Via4" 28.195 5.285 28.265 5.355)
rect(cv "Metal4" 28.105 5.275 28.355 5.365)
rect(cv "Metal5" 28.185 5.195 28.275 5.445)
rect(cv "Metal5" 28.19 5.28 28.27 8.88)
rect(cv "Via4" 28.195 8.805 28.265 8.875)
rect(cv "Metal4" 28.105 8.795 28.355 8.885)
rect(cv "Metal5" 28.185 8.715 28.275 8.965)
rect(cv "Via3" 28.515 5.285 28.585 5.355)
rect(cv "Metal3" 28.505 5.195 28.595 5.445)
rect(cv "Metal4" 28.425 5.275 28.675 5.365)
rect(cv "Via4" 28.515 5.285 28.585 5.355)
rect(cv "Metal4" 28.425 5.275 28.675 5.365)
rect(cv "Metal5" 28.505 5.195 28.595 5.445)
rect(cv "Metal5" 28.51 5.28 28.59 6)
rect(cv "Via4" 28.515 5.925 28.585 5.995)
rect(cv "Metal4" 28.425 5.915 28.675 6.005)
rect(cv "Metal5" 28.505 5.835 28.595 6.085)
rect(cv "Via3" 28.835 5.285 28.905 5.355)
rect(cv "Metal3" 28.825 5.195 28.915 5.445)
rect(cv "Metal4" 28.745 5.275 28.995 5.365)
rect(cv "Via4" 28.835 5.285 28.905 5.355)
rect(cv "Metal4" 28.745 5.275 28.995 5.365)
rect(cv "Metal5" 28.825 5.195 28.915 5.445)
rect(cv "Metal5" 28.83 5.28 28.91 9.52)
rect(cv "Via4" 28.835 9.445 28.905 9.515)
rect(cv "Metal4" 28.745 9.435 28.995 9.525)
rect(cv "Metal5" 28.825 9.355 28.915 9.605)
rect(cv "Via3" 29.155 5.285 29.225 5.355)
rect(cv "Metal3" 29.145 5.195 29.235 5.445)
rect(cv "Metal4" 29.065 5.275 29.315 5.365)
rect(cv "Via4" 29.155 5.285 29.225 5.355)
rect(cv "Metal4" 29.065 5.275 29.315 5.365)
rect(cv "Metal5" 29.145 5.195 29.235 5.445)
rect(cv "Metal5" 29.15 5.28 29.23 9.04)
rect(cv "Via4" 29.155 8.965 29.225 9.035)
rect(cv "Metal4" 29.065 8.955 29.315 9.045)
rect(cv "Metal5" 29.145 8.875 29.235 9.125)
rect(cv "Via3" 29.475 5.285 29.545 5.355)
rect(cv "Metal3" 29.465 5.195 29.555 5.445)
rect(cv "Metal4" 29.385 5.275 29.635 5.365)
rect(cv "Via4" 29.475 5.285 29.545 5.355)
rect(cv "Metal4" 29.385 5.275 29.635 5.365)
rect(cv "Metal5" 29.465 5.195 29.555 5.445)
rect(cv "Metal5" 29.47 5.28 29.55 9.2)
rect(cv "Via4" 29.475 9.125 29.545 9.195)
rect(cv "Metal4" 29.385 9.115 29.635 9.205)
rect(cv "Metal5" 29.465 9.035 29.555 9.285)
rect(cv "Via3" 32.145 3.845 32.215 3.915)
rect(cv "Metal3" 32.135 3.755 32.225 4.005)
rect(cv "Metal4" 32.055 3.835 32.305 3.925)
rect(cv "Via4" 32.145 3.845 32.215 3.915)
rect(cv "Metal4" 32.055 3.835 32.305 3.925)
rect(cv "Metal5" 32.135 3.755 32.225 4.005)
rect(cv "Metal5" 32.14 3.84 32.22 6.16)
rect(cv "Via4" 32.145 6.085 32.215 6.155)
rect(cv "Metal4" 32.055 6.075 32.305 6.165)
rect(cv "Metal5" 32.135 5.995 32.225 6.245)
rect(cv "Via3" 32.465 3.845 32.535 3.915)
rect(cv "Metal3" 32.455 3.755 32.545 4.005)
rect(cv "Metal4" 32.375 3.835 32.625 3.925)
rect(cv "Via4" 32.465 3.845 32.535 3.915)
rect(cv "Metal4" 32.375 3.835 32.625 3.925)
rect(cv "Metal5" 32.455 3.755 32.545 4.005)
rect(cv "Metal5" 32.46 3.84 32.54 9.68)
rect(cv "Via4" 32.465 9.605 32.535 9.675)
rect(cv "Metal4" 32.375 9.595 32.625 9.685)
rect(cv "Metal5" 32.455 9.515 32.545 9.765)
rect(cv "Via3" 32.785 3.845 32.855 3.915)
rect(cv "Metal3" 32.775 3.755 32.865 4.005)
rect(cv "Metal4" 32.695 3.835 32.945 3.925)
rect(cv "Via4" 32.785 3.845 32.855 3.915)
rect(cv "Metal4" 32.695 3.835 32.945 3.925)
rect(cv "Metal5" 32.775 3.755 32.865 4.005)
rect(cv "Metal5" 32.78 3.84 32.86 9.04)
rect(cv "Via4" 32.785 8.965 32.855 9.035)
rect(cv "Metal4" 32.695 8.955 32.945 9.045)
rect(cv "Metal5" 32.775 8.875 32.865 9.125)
rect(cv "Via3" 33.105 3.845 33.175 3.915)
rect(cv "Metal3" 33.095 3.755 33.185 4.005)
rect(cv "Metal4" 33.015 3.835 33.265 3.925)
rect(cv "Via4" 33.105 3.845 33.175 3.915)
rect(cv "Metal4" 33.015 3.835 33.265 3.925)
rect(cv "Metal5" 33.095 3.755 33.185 4.005)
rect(cv "Metal5" 33.1 3.84 33.18 9.2)
rect(cv "Via4" 33.105 9.125 33.175 9.195)
rect(cv "Metal4" 33.015 9.115 33.265 9.205)
rect(cv "Metal5" 33.095 9.035 33.185 9.285)
rect(cv "Via3" 35.775 5.285 35.845 5.355)
rect(cv "Metal3" 35.765 5.195 35.855 5.445)
rect(cv "Metal4" 35.685 5.275 35.935 5.365)
rect(cv "Via4" 35.775 5.285 35.845 5.355)
rect(cv "Metal4" 35.685 5.275 35.935 5.365)
rect(cv "Metal5" 35.765 5.195 35.855 5.445)
rect(cv "Metal5" 35.77 5.28 35.85 7.12)
rect(cv "Via4" 35.775 7.045 35.845 7.115)
rect(cv "Metal4" 35.685 7.035 35.935 7.125)
rect(cv "Metal5" 35.765 6.955 35.855 7.205)
rect(cv "Via3" 36.095 5.285 36.165 5.355)
rect(cv "Metal3" 36.085 5.195 36.175 5.445)
rect(cv "Metal4" 36.005 5.275 36.255 5.365)
rect(cv "Via4" 36.095 5.285 36.165 5.355)
rect(cv "Metal4" 36.005 5.275 36.255 5.365)
rect(cv "Metal5" 36.085 5.195 36.175 5.445)
rect(cv "Metal5" 36.09 5.28 36.17 8.72)
rect(cv "Via4" 36.095 8.645 36.165 8.715)
rect(cv "Metal4" 36.005 8.635 36.255 8.725)
rect(cv "Metal5" 36.085 8.555 36.175 8.805)
rect(cv "Via3" 36.415 5.285 36.485 5.355)
rect(cv "Metal3" 36.405 5.195 36.495 5.445)
rect(cv "Metal4" 36.325 5.275 36.575 5.365)
rect(cv "Via4" 36.415 5.285 36.485 5.355)
rect(cv "Metal4" 36.325 5.275 36.575 5.365)
rect(cv "Metal5" 36.405 5.195 36.495 5.445)
rect(cv "Metal5" 36.41 5.28 36.49 6.16)
rect(cv "Via4" 36.415 6.085 36.485 6.155)
rect(cv "Metal4" 36.325 6.075 36.575 6.165)
rect(cv "Metal5" 36.405 5.995 36.495 6.245)
rect(cv "Via3" 36.735 5.285 36.805 5.355)
rect(cv "Metal3" 36.725 5.195 36.815 5.445)
rect(cv "Metal4" 36.645 5.275 36.895 5.365)
rect(cv "Via4" 36.735 5.285 36.805 5.355)
rect(cv "Metal4" 36.645 5.275 36.895 5.365)
rect(cv "Metal5" 36.725 5.195 36.815 5.445)
rect(cv "Metal5" 36.73 5.28 36.81 9.68)
rect(cv "Via4" 36.735 9.605 36.805 9.675)
rect(cv "Metal4" 36.645 9.595 36.895 9.685)
rect(cv "Metal5" 36.725 9.515 36.815 9.765)
rect(cv "Via3" 37.055 5.285 37.125 5.355)
rect(cv "Metal3" 37.045 5.195 37.135 5.445)
rect(cv "Metal4" 36.965 5.275 37.215 5.365)
rect(cv "Via4" 37.055 5.285 37.125 5.355)
rect(cv "Metal4" 36.965 5.275 37.215 5.365)
rect(cv "Metal5" 37.045 5.195 37.135 5.445)
rect(cv "Metal5" 37.05 5.28 37.13 9.04)
rect(cv "Via4" 37.055 8.965 37.125 9.035)
rect(cv "Metal4" 36.965 8.955 37.215 9.045)
rect(cv "Metal5" 37.045 8.875 37.135 9.125)
rect(cv "Via3" 37.375 5.285 37.445 5.355)
rect(cv "Metal3" 37.365 5.195 37.455 5.445)
rect(cv "Metal4" 37.285 5.275 37.535 5.365)
rect(cv "Via4" 37.375 5.285 37.445 5.355)
rect(cv "Metal4" 37.285 5.275 37.535 5.365)
rect(cv "Metal5" 37.365 5.195 37.455 5.445)
rect(cv "Metal5" 37.37 5.28 37.45 9.2)
rect(cv "Via4" 37.375 9.125 37.445 9.195)
rect(cv "Metal4" 37.285 9.115 37.535 9.205)
rect(cv "Metal5" 37.365 9.035 37.455 9.285)
rect(cv "Via3" 40.045 5.285 40.115 5.355)
rect(cv "Metal3" 40.035 5.195 40.125 5.445)
rect(cv "Metal4" 39.955 5.275 40.205 5.365)
rect(cv "Via4" 40.045 5.285 40.115 5.355)
rect(cv "Metal4" 39.955 5.275 40.205 5.365)
rect(cv "Metal5" 40.035 5.195 40.125 5.445)
rect(cv "Metal5" 40.04 5.28 40.12 8.08)
rect(cv "Via4" 40.045 8.005 40.115 8.075)
rect(cv "Metal4" 39.955 7.995 40.205 8.085)
rect(cv "Metal5" 40.035 7.915 40.125 8.165)
rect(cv "Via3" 40.365 5.285 40.435 5.355)
rect(cv "Metal3" 40.355 5.195 40.445 5.445)
rect(cv "Metal4" 40.275 5.275 40.525 5.365)
rect(cv "Via4" 40.365 5.285 40.435 5.355)
rect(cv "Metal4" 40.275 5.275 40.525 5.365)
rect(cv "Metal5" 40.355 5.195 40.445 5.445)
rect(cv "Metal5" 40.36 5.28 40.44 8.88)
rect(cv "Via4" 40.365 8.805 40.435 8.875)
rect(cv "Metal4" 40.275 8.795 40.525 8.885)
rect(cv "Metal5" 40.355 8.715 40.445 8.965)
rect(cv "Via3" 40.685 5.285 40.755 5.355)
rect(cv "Metal3" 40.675 5.195 40.765 5.445)
rect(cv "Metal4" 40.595 5.275 40.845 5.365)
rect(cv "Via4" 40.685 5.285 40.755 5.355)
rect(cv "Metal4" 40.595 5.275 40.845 5.365)
rect(cv "Metal5" 40.675 5.195 40.765 5.445)
rect(cv "Metal5" 40.68 5.28 40.76 6.16)
rect(cv "Via4" 40.685 6.085 40.755 6.155)
rect(cv "Metal4" 40.595 6.075 40.845 6.165)
rect(cv "Metal5" 40.675 5.995 40.765 6.245)
rect(cv "Via3" 41.005 5.285 41.075 5.355)
rect(cv "Metal3" 40.995 5.195 41.085 5.445)
rect(cv "Metal4" 40.915 5.275 41.165 5.365)
rect(cv "Via4" 41.005 5.285 41.075 5.355)
rect(cv "Metal4" 40.915 5.275 41.165 5.365)
rect(cv "Metal5" 40.995 5.195 41.085 5.445)
rect(cv "Metal5" 41 5.28 41.08 9.68)
rect(cv "Via4" 41.005 9.605 41.075 9.675)
rect(cv "Metal4" 40.915 9.595 41.165 9.685)
rect(cv "Metal5" 40.995 9.515 41.085 9.765)
rect(cv "Via3" 41.325 5.285 41.395 5.355)
rect(cv "Metal3" 41.315 5.195 41.405 5.445)
rect(cv "Metal4" 41.235 5.275 41.485 5.365)
rect(cv "Via4" 41.325 5.285 41.395 5.355)
rect(cv "Metal4" 41.235 5.275 41.485 5.365)
rect(cv "Metal5" 41.315 5.195 41.405 5.445)
rect(cv "Metal5" 41.32 5.28 41.4 9.04)
rect(cv "Via4" 41.325 8.965 41.395 9.035)
rect(cv "Metal4" 41.235 8.955 41.485 9.045)
rect(cv "Metal5" 41.315 8.875 41.405 9.125)
rect(cv "Via3" 41.645 5.285 41.715 5.355)
rect(cv "Metal3" 41.635 5.195 41.725 5.445)
rect(cv "Metal4" 41.555 5.275 41.805 5.365)
rect(cv "Via4" 41.645 5.285 41.715 5.355)
rect(cv "Metal4" 41.555 5.275 41.805 5.365)
rect(cv "Metal5" 41.635 5.195 41.725 5.445)
rect(cv "Metal5" 41.64 5.28 41.72 9.2)
rect(cv "Via4" 41.645 9.125 41.715 9.195)
rect(cv "Metal4" 41.555 9.115 41.805 9.205)
rect(cv "Metal5" 41.635 9.035 41.725 9.285)
rect(cv "Via3" 44.315 3.845 44.385 3.915)
rect(cv "Metal3" 44.305 3.755 44.395 4.005)
rect(cv "Metal4" 44.225 3.835 44.475 3.925)
rect(cv "Via4" 44.315 3.845 44.385 3.915)
rect(cv "Metal4" 44.225 3.835 44.475 3.925)
rect(cv "Metal5" 44.305 3.755 44.395 4.005)
rect(cv "Metal5" 44.31 3.84 44.39 6.32)
rect(cv "Via4" 44.315 6.245 44.385 6.315)
rect(cv "Metal4" 44.225 6.235 44.475 6.325)
rect(cv "Metal5" 44.305 6.155 44.395 6.405)
rect(cv "Via3" 44.635 3.845 44.705 3.915)
rect(cv "Metal3" 44.625 3.755 44.715 4.005)
rect(cv "Metal4" 44.545 3.835 44.795 3.925)
rect(cv "Via4" 44.635 3.845 44.705 3.915)
rect(cv "Metal4" 44.545 3.835 44.795 3.925)
rect(cv "Metal5" 44.625 3.755 44.715 4.005)
rect(cv "Metal5" 44.63 3.84 44.71 9.84)
rect(cv "Via4" 44.635 9.765 44.705 9.835)
rect(cv "Metal4" 44.545 9.755 44.795 9.845)
rect(cv "Metal5" 44.625 9.675 44.715 9.925)
rect(cv "Via3" 44.955 3.845 45.025 3.915)
rect(cv "Metal3" 44.945 3.755 45.035 4.005)
rect(cv "Metal4" 44.865 3.835 45.115 3.925)
rect(cv "Via4" 44.955 3.845 45.025 3.915)
rect(cv "Metal4" 44.865 3.835 45.115 3.925)
rect(cv "Metal5" 44.945 3.755 45.035 4.005)
rect(cv "Metal5" 44.95 3.84 45.03 9.04)
rect(cv "Via4" 44.955 8.965 45.025 9.035)
rect(cv "Metal4" 44.865 8.955 45.115 9.045)
rect(cv "Metal5" 44.945 8.875 45.035 9.125)
rect(cv "Via3" 45.275 3.845 45.345 3.915)
rect(cv "Metal3" 45.265 3.755 45.355 4.005)
rect(cv "Metal4" 45.185 3.835 45.435 3.925)
rect(cv "Via4" 45.275 3.845 45.345 3.915)
rect(cv "Metal4" 45.185 3.835 45.435 3.925)
rect(cv "Metal5" 45.265 3.755 45.355 4.005)
rect(cv "Metal5" 45.27 3.84 45.35 9.2)
rect(cv "Via4" 45.275 9.125 45.345 9.195)
rect(cv "Metal4" 45.185 9.115 45.435 9.205)
rect(cv "Metal5" 45.265 9.035 45.355 9.285)
rect(cv "Via3" 47.945 5.285 48.015 5.355)
rect(cv "Metal3" 47.935 5.195 48.025 5.445)
rect(cv "Metal4" 47.855 5.275 48.105 5.365)
rect(cv "Via4" 47.945 5.285 48.015 5.355)
rect(cv "Metal4" 47.855 5.275 48.105 5.365)
rect(cv "Metal5" 47.935 5.195 48.025 5.445)
rect(cv "Metal5" 47.94 5.28 48.02 7.28)
rect(cv "Via4" 47.945 7.205 48.015 7.275)
rect(cv "Metal4" 47.855 7.195 48.105 7.285)
rect(cv "Metal5" 47.935 7.115 48.025 7.365)
rect(cv "Via3" 48.265 5.285 48.335 5.355)
rect(cv "Metal3" 48.255 5.195 48.345 5.445)
rect(cv "Metal4" 48.175 5.275 48.425 5.365)
rect(cv "Via4" 48.265 5.285 48.335 5.355)
rect(cv "Metal4" 48.175 5.275 48.425 5.365)
rect(cv "Metal5" 48.255 5.195 48.345 5.445)
rect(cv "Metal5" 48.26 5.28 48.34 8.72)
rect(cv "Via4" 48.265 8.645 48.335 8.715)
rect(cv "Metal4" 48.175 8.635 48.425 8.725)
rect(cv "Metal5" 48.255 8.555 48.345 8.805)
rect(cv "Via3" 48.585 5.285 48.655 5.355)
rect(cv "Metal3" 48.575 5.195 48.665 5.445)
rect(cv "Metal4" 48.495 5.275 48.745 5.365)
rect(cv "Via4" 48.585 5.285 48.655 5.355)
rect(cv "Metal4" 48.495 5.275 48.745 5.365)
rect(cv "Metal5" 48.575 5.195 48.665 5.445)
rect(cv "Metal5" 48.58 5.28 48.66 6.32)
rect(cv "Via4" 48.585 6.245 48.655 6.315)
rect(cv "Metal4" 48.495 6.235 48.745 6.325)
rect(cv "Metal5" 48.575 6.155 48.665 6.405)
rect(cv "Via3" 48.905 5.285 48.975 5.355)
rect(cv "Metal3" 48.895 5.195 48.985 5.445)
rect(cv "Metal4" 48.815 5.275 49.065 5.365)
rect(cv "Via4" 48.905 5.285 48.975 5.355)
rect(cv "Metal4" 48.815 5.275 49.065 5.365)
rect(cv "Metal5" 48.895 5.195 48.985 5.445)
rect(cv "Metal5" 48.9 5.28 48.98 9.84)
rect(cv "Via4" 48.905 9.765 48.975 9.835)
rect(cv "Metal4" 48.815 9.755 49.065 9.845)
rect(cv "Metal5" 48.895 9.675 48.985 9.925)
rect(cv "Via3" 49.225 5.285 49.295 5.355)
rect(cv "Metal3" 49.215 5.195 49.305 5.445)
rect(cv "Metal4" 49.135 5.275 49.385 5.365)
rect(cv "Via4" 49.225 5.285 49.295 5.355)
rect(cv "Metal4" 49.135 5.275 49.385 5.365)
rect(cv "Metal5" 49.215 5.195 49.305 5.445)
rect(cv "Metal5" 49.22 5.28 49.3 9.04)
rect(cv "Via4" 49.225 8.965 49.295 9.035)
rect(cv "Metal4" 49.135 8.955 49.385 9.045)
rect(cv "Metal5" 49.215 8.875 49.305 9.125)
rect(cv "Via3" 49.545 5.285 49.615 5.355)
rect(cv "Metal3" 49.535 5.195 49.625 5.445)
rect(cv "Metal4" 49.455 5.275 49.705 5.365)
rect(cv "Via4" 49.545 5.285 49.615 5.355)
rect(cv "Metal4" 49.455 5.275 49.705 5.365)
rect(cv "Metal5" 49.535 5.195 49.625 5.445)
rect(cv "Metal5" 49.54 5.28 49.62 9.2)
rect(cv "Via4" 49.545 9.125 49.615 9.195)
rect(cv "Metal4" 49.455 9.115 49.705 9.205)
rect(cv "Metal5" 49.535 9.035 49.625 9.285)
rect(cv "Via3" 52.215 5.285 52.285 5.355)
rect(cv "Metal3" 52.205 5.195 52.295 5.445)
rect(cv "Metal4" 52.125 5.275 52.375 5.365)
rect(cv "Via4" 52.215 5.285 52.285 5.355)
rect(cv "Metal4" 52.125 5.275 52.375 5.365)
rect(cv "Metal5" 52.205 5.195 52.295 5.445)
rect(cv "Metal5" 52.21 5.28 52.29 8.24)
rect(cv "Via4" 52.215 8.165 52.285 8.235)
rect(cv "Metal4" 52.125 8.155 52.375 8.245)
rect(cv "Metal5" 52.205 8.075 52.295 8.325)
rect(cv "Via3" 52.535 5.285 52.605 5.355)
rect(cv "Metal3" 52.525 5.195 52.615 5.445)
rect(cv "Metal4" 52.445 5.275 52.695 5.365)
rect(cv "Via4" 52.535 5.285 52.605 5.355)
rect(cv "Metal4" 52.445 5.275 52.695 5.365)
rect(cv "Metal5" 52.525 5.195 52.615 5.445)
rect(cv "Metal5" 52.53 5.28 52.61 8.88)
rect(cv "Via4" 52.535 8.805 52.605 8.875)
rect(cv "Metal4" 52.445 8.795 52.695 8.885)
rect(cv "Metal5" 52.525 8.715 52.615 8.965)
rect(cv "Via3" 52.855 5.285 52.925 5.355)
rect(cv "Metal3" 52.845 5.195 52.935 5.445)
rect(cv "Metal4" 52.765 5.275 53.015 5.365)
rect(cv "Via4" 52.855 5.285 52.925 5.355)
rect(cv "Metal4" 52.765 5.275 53.015 5.365)
rect(cv "Metal5" 52.845 5.195 52.935 5.445)
rect(cv "Metal5" 52.85 5.28 52.93 6.32)
rect(cv "Via4" 52.855 6.245 52.925 6.315)
rect(cv "Metal4" 52.765 6.235 53.015 6.325)
rect(cv "Metal5" 52.845 6.155 52.935 6.405)
rect(cv "Via3" 53.175 5.285 53.245 5.355)
rect(cv "Metal3" 53.165 5.195 53.255 5.445)
rect(cv "Metal4" 53.085 5.275 53.335 5.365)
rect(cv "Via4" 53.175 5.285 53.245 5.355)
rect(cv "Metal4" 53.085 5.275 53.335 5.365)
rect(cv "Metal5" 53.165 5.195 53.255 5.445)
rect(cv "Metal5" 53.17 5.28 53.25 9.84)
rect(cv "Via4" 53.175 9.765 53.245 9.835)
rect(cv "Metal4" 53.085 9.755 53.335 9.845)
rect(cv "Metal5" 53.165 9.675 53.255 9.925)
rect(cv "Via3" 53.495 5.285 53.565 5.355)
rect(cv "Metal3" 53.485 5.195 53.575 5.445)
rect(cv "Metal4" 53.405 5.275 53.655 5.365)
rect(cv "Via4" 53.495 5.285 53.565 5.355)
rect(cv "Metal4" 53.405 5.275 53.655 5.365)
rect(cv "Metal5" 53.485 5.195 53.575 5.445)
rect(cv "Metal5" 53.49 5.28 53.57 9.04)
rect(cv "Via4" 53.495 8.965 53.565 9.035)
rect(cv "Metal4" 53.405 8.955 53.655 9.045)
rect(cv "Metal5" 53.485 8.875 53.575 9.125)
rect(cv "Via3" 53.815 5.285 53.885 5.355)
rect(cv "Metal3" 53.805 5.195 53.895 5.445)
rect(cv "Metal4" 53.725 5.275 53.975 5.365)
rect(cv "Via4" 53.815 5.285 53.885 5.355)
rect(cv "Metal4" 53.725 5.275 53.975 5.365)
rect(cv "Metal5" 53.805 5.195 53.895 5.445)
rect(cv "Metal5" 53.81 5.28 53.89 9.2)
rect(cv "Via4" 53.815 9.125 53.885 9.195)
rect(cv "Metal4" 53.725 9.115 53.975 9.205)
rect(cv "Metal5" 53.805 9.035 53.895 9.285)
rect(cv "Via3" 56.485 3.845 56.555 3.915)
rect(cv "Metal3" 56.475 3.755 56.565 4.005)
rect(cv "Metal4" 56.395 3.835 56.645 3.925)
rect(cv "Via4" 56.485 3.845 56.555 3.915)
rect(cv "Metal4" 56.395 3.835 56.645 3.925)
rect(cv "Metal5" 56.475 3.755 56.565 4.005)
rect(cv "Metal5" 56.48 3.84 56.56 6.48)
rect(cv "Via4" 56.485 6.405 56.555 6.475)
rect(cv "Metal4" 56.395 6.395 56.645 6.485)
rect(cv "Metal5" 56.475 6.315 56.565 6.565)
rect(cv "Via3" 56.805 3.845 56.875 3.915)
rect(cv "Metal3" 56.795 3.755 56.885 4.005)
rect(cv "Metal4" 56.715 3.835 56.965 3.925)
rect(cv "Via4" 56.805 3.845 56.875 3.915)
rect(cv "Metal4" 56.715 3.835 56.965 3.925)
rect(cv "Metal5" 56.795 3.755 56.885 4.005)
rect(cv "Metal5" 56.8 3.84 56.88 10)
rect(cv "Via4" 56.805 9.925 56.875 9.995)
rect(cv "Metal4" 56.715 9.915 56.965 10.005)
rect(cv "Metal5" 56.795 9.835 56.885 10.085)
rect(cv "Via3" 57.125 3.845 57.195 3.915)
rect(cv "Metal3" 57.115 3.755 57.205 4.005)
rect(cv "Metal4" 57.035 3.835 57.285 3.925)
rect(cv "Via4" 57.125 3.845 57.195 3.915)
rect(cv "Metal4" 57.035 3.835 57.285 3.925)
rect(cv "Metal5" 57.115 3.755 57.205 4.005)
rect(cv "Metal5" 57.12 3.84 57.2 9.04)
rect(cv "Via4" 57.125 8.965 57.195 9.035)
rect(cv "Metal4" 57.035 8.955 57.285 9.045)
rect(cv "Metal5" 57.115 8.875 57.205 9.125)
rect(cv "Via3" 57.445 3.845 57.515 3.915)
rect(cv "Metal3" 57.435 3.755 57.525 4.005)
rect(cv "Metal4" 57.355 3.835 57.605 3.925)
rect(cv "Via4" 57.445 3.845 57.515 3.915)
rect(cv "Metal4" 57.355 3.835 57.605 3.925)
rect(cv "Metal5" 57.435 3.755 57.525 4.005)
rect(cv "Metal5" 57.44 3.84 57.52 9.2)
rect(cv "Via4" 57.445 9.125 57.515 9.195)
rect(cv "Metal4" 57.355 9.115 57.605 9.205)
rect(cv "Metal5" 57.435 9.035 57.525 9.285)
rect(cv "Via3" 60.115 5.285 60.185 5.355)
rect(cv "Metal3" 60.105 5.195 60.195 5.445)
rect(cv "Metal4" 60.025 5.275 60.275 5.365)
rect(cv "Via4" 60.115 5.285 60.185 5.355)
rect(cv "Metal4" 60.025 5.275 60.275 5.365)
rect(cv "Metal5" 60.105 5.195 60.195 5.445)
rect(cv "Metal5" 60.11 5.28 60.19 7.44)
rect(cv "Via4" 60.115 7.365 60.185 7.435)
rect(cv "Metal4" 60.025 7.355 60.275 7.445)
rect(cv "Metal5" 60.105 7.275 60.195 7.525)
rect(cv "Via3" 60.435 5.285 60.505 5.355)
rect(cv "Metal3" 60.425 5.195 60.515 5.445)
rect(cv "Metal4" 60.345 5.275 60.595 5.365)
rect(cv "Via4" 60.435 5.285 60.505 5.355)
rect(cv "Metal4" 60.345 5.275 60.595 5.365)
rect(cv "Metal5" 60.425 5.195 60.515 5.445)
rect(cv "Metal5" 60.43 5.28 60.51 8.72)
rect(cv "Via4" 60.435 8.645 60.505 8.715)
rect(cv "Metal4" 60.345 8.635 60.595 8.725)
rect(cv "Metal5" 60.425 8.555 60.515 8.805)
rect(cv "Via3" 60.755 5.285 60.825 5.355)
rect(cv "Metal3" 60.745 5.195 60.835 5.445)
rect(cv "Metal4" 60.665 5.275 60.915 5.365)
rect(cv "Via4" 60.755 5.285 60.825 5.355)
rect(cv "Metal4" 60.665 5.275 60.915 5.365)
rect(cv "Metal5" 60.745 5.195 60.835 5.445)
rect(cv "Metal5" 60.75 5.28 60.83 6.48)
rect(cv "Via4" 60.755 6.405 60.825 6.475)
rect(cv "Metal4" 60.665 6.395 60.915 6.485)
rect(cv "Metal5" 60.745 6.315 60.835 6.565)
rect(cv "Via3" 61.075 5.285 61.145 5.355)
rect(cv "Metal3" 61.065 5.195 61.155 5.445)
rect(cv "Metal4" 60.985 5.275 61.235 5.365)
rect(cv "Via4" 61.075 5.285 61.145 5.355)
rect(cv "Metal4" 60.985 5.275 61.235 5.365)
rect(cv "Metal5" 61.065 5.195 61.155 5.445)
rect(cv "Metal5" 61.07 5.28 61.15 10)
rect(cv "Via4" 61.075 9.925 61.145 9.995)
rect(cv "Metal4" 60.985 9.915 61.235 10.005)
rect(cv "Metal5" 61.065 9.835 61.155 10.085)
rect(cv "Via3" 61.395 5.285 61.465 5.355)
rect(cv "Metal3" 61.385 5.195 61.475 5.445)
rect(cv "Metal4" 61.305 5.275 61.555 5.365)
rect(cv "Via4" 61.395 5.285 61.465 5.355)
rect(cv "Metal4" 61.305 5.275 61.555 5.365)
rect(cv "Metal5" 61.385 5.195 61.475 5.445)
rect(cv "Metal5" 61.39 5.28 61.47 9.04)
rect(cv "Via4" 61.395 8.965 61.465 9.035)
rect(cv "Metal4" 61.305 8.955 61.555 9.045)
rect(cv "Metal5" 61.385 8.875 61.475 9.125)
rect(cv "Via3" 61.715 5.285 61.785 5.355)
rect(cv "Metal3" 61.705 5.195 61.795 5.445)
rect(cv "Metal4" 61.625 5.275 61.875 5.365)
rect(cv "Via4" 61.715 5.285 61.785 5.355)
rect(cv "Metal4" 61.625 5.275 61.875 5.365)
rect(cv "Metal5" 61.705 5.195 61.795 5.445)
rect(cv "Metal5" 61.71 5.28 61.79 9.2)
rect(cv "Via4" 61.715 9.125 61.785 9.195)
rect(cv "Metal4" 61.625 9.115 61.875 9.205)
rect(cv "Metal5" 61.705 9.035 61.795 9.285)
rect(cv "Via3" 64.385 5.285 64.455 5.355)
rect(cv "Metal3" 64.375 5.195 64.465 5.445)
rect(cv "Metal4" 64.295 5.275 64.545 5.365)
rect(cv "Via4" 64.385 5.285 64.455 5.355)
rect(cv "Metal4" 64.295 5.275 64.545 5.365)
rect(cv "Metal5" 64.375 5.195 64.465 5.445)
rect(cv "Metal5" 64.38 5.28 64.46 8.4)
rect(cv "Via4" 64.385 8.325 64.455 8.395)
rect(cv "Metal4" 64.295 8.315 64.545 8.405)
rect(cv "Metal5" 64.375 8.235 64.465 8.485)
rect(cv "Via3" 64.705 5.285 64.775 5.355)
rect(cv "Metal3" 64.695 5.195 64.785 5.445)
rect(cv "Metal4" 64.615 5.275 64.865 5.365)
rect(cv "Via4" 64.705 5.285 64.775 5.355)
rect(cv "Metal4" 64.615 5.275 64.865 5.365)
rect(cv "Metal5" 64.695 5.195 64.785 5.445)
rect(cv "Metal5" 64.7 5.28 64.78 8.88)
rect(cv "Via4" 64.705 8.805 64.775 8.875)
rect(cv "Metal4" 64.615 8.795 64.865 8.885)
rect(cv "Metal5" 64.695 8.715 64.785 8.965)
rect(cv "Via3" 65.025 5.285 65.095 5.355)
rect(cv "Metal3" 65.015 5.195 65.105 5.445)
rect(cv "Metal4" 64.935 5.275 65.185 5.365)
rect(cv "Via4" 65.025 5.285 65.095 5.355)
rect(cv "Metal4" 64.935 5.275 65.185 5.365)
rect(cv "Metal5" 65.015 5.195 65.105 5.445)
rect(cv "Metal5" 65.02 5.28 65.1 6.48)
rect(cv "Via4" 65.025 6.405 65.095 6.475)
rect(cv "Metal4" 64.935 6.395 65.185 6.485)
rect(cv "Metal5" 65.015 6.315 65.105 6.565)
rect(cv "Via3" 65.345 5.285 65.415 5.355)
rect(cv "Metal3" 65.335 5.195 65.425 5.445)
rect(cv "Metal4" 65.255 5.275 65.505 5.365)
rect(cv "Via4" 65.345 5.285 65.415 5.355)
rect(cv "Metal4" 65.255 5.275 65.505 5.365)
rect(cv "Metal5" 65.335 5.195 65.425 5.445)
rect(cv "Metal5" 65.34 5.28 65.42 10)
rect(cv "Via4" 65.345 9.925 65.415 9.995)
rect(cv "Metal4" 65.255 9.915 65.505 10.005)
rect(cv "Metal5" 65.335 9.835 65.425 10.085)
rect(cv "Via3" 65.665 5.285 65.735 5.355)
rect(cv "Metal3" 65.655 5.195 65.745 5.445)
rect(cv "Metal4" 65.575 5.275 65.825 5.365)
rect(cv "Via4" 65.665 5.285 65.735 5.355)
rect(cv "Metal4" 65.575 5.275 65.825 5.365)
rect(cv "Metal5" 65.655 5.195 65.745 5.445)
rect(cv "Metal5" 65.66 5.28 65.74 9.04)
rect(cv "Via4" 65.665 8.965 65.735 9.035)
rect(cv "Metal4" 65.575 8.955 65.825 9.045)
rect(cv "Metal5" 65.655 8.875 65.745 9.125)
rect(cv "Via3" 65.985 5.285 66.055 5.355)
rect(cv "Metal3" 65.975 5.195 66.065 5.445)
rect(cv "Metal4" 65.895 5.275 66.145 5.365)
rect(cv "Via4" 65.985 5.285 66.055 5.355)
rect(cv "Metal4" 65.895 5.275 66.145 5.365)
rect(cv "Metal5" 65.975 5.195 66.065 5.445)
rect(cv "Metal5" 65.98 5.28 66.06 9.2)
rect(cv "Via4" 65.985 9.125 66.055 9.195)
rect(cv "Metal4" 65.895 9.115 66.145 9.205)
rect(cv "Metal5" 65.975 9.035 66.065 9.285)
rect(cv "Via3" 68.655 3.845 68.725 3.915)
rect(cv "Metal3" 68.645 3.755 68.735 4.005)
rect(cv "Metal4" 68.565 3.835 68.815 3.925)
rect(cv "Via4" 68.655 3.845 68.725 3.915)
rect(cv "Metal4" 68.565 3.835 68.815 3.925)
rect(cv "Metal5" 68.645 3.755 68.735 4.005)
rect(cv "Metal5" 68.65 3.84 68.73 6.64)
rect(cv "Via4" 68.655 6.565 68.725 6.635)
rect(cv "Metal4" 68.565 6.555 68.815 6.645)
rect(cv "Metal5" 68.645 6.475 68.735 6.725)
rect(cv "Via3" 68.975 3.845 69.045 3.915)
rect(cv "Metal3" 68.965 3.755 69.055 4.005)
rect(cv "Metal4" 68.885 3.835 69.135 3.925)
rect(cv "Via4" 68.975 3.845 69.045 3.915)
rect(cv "Metal4" 68.885 3.835 69.135 3.925)
rect(cv "Metal5" 68.965 3.755 69.055 4.005)
rect(cv "Metal5" 68.97 3.84 69.05 10.16)
rect(cv "Via4" 68.975 10.085 69.045 10.155)
rect(cv "Metal4" 68.885 10.075 69.135 10.165)
rect(cv "Metal5" 68.965 9.995 69.055 10.245)
rect(cv "Via3" 69.295 3.845 69.365 3.915)
rect(cv "Metal3" 69.285 3.755 69.375 4.005)
rect(cv "Metal4" 69.205 3.835 69.455 3.925)
rect(cv "Via4" 69.295 3.845 69.365 3.915)
rect(cv "Metal4" 69.205 3.835 69.455 3.925)
rect(cv "Metal5" 69.285 3.755 69.375 4.005)
rect(cv "Metal5" 69.29 3.84 69.37 9.04)
rect(cv "Via4" 69.295 8.965 69.365 9.035)
rect(cv "Metal4" 69.205 8.955 69.455 9.045)
rect(cv "Metal5" 69.285 8.875 69.375 9.125)
rect(cv "Via3" 69.615 3.845 69.685 3.915)
rect(cv "Metal3" 69.605 3.755 69.695 4.005)
rect(cv "Metal4" 69.525 3.835 69.775 3.925)
rect(cv "Via4" 69.615 3.845 69.685 3.915)
rect(cv "Metal4" 69.525 3.835 69.775 3.925)
rect(cv "Metal5" 69.605 3.755 69.695 4.005)
rect(cv "Metal5" 69.61 3.84 69.69 9.2)
rect(cv "Via4" 69.615 9.125 69.685 9.195)
rect(cv "Metal4" 69.525 9.115 69.775 9.205)
rect(cv "Metal5" 69.605 9.035 69.695 9.285)
rect(cv "Via3" 72.285 5.285 72.355 5.355)
rect(cv "Metal3" 72.275 5.195 72.365 5.445)
rect(cv "Metal4" 72.195 5.275 72.445 5.365)
rect(cv "Via4" 72.285 5.285 72.355 5.355)
rect(cv "Metal4" 72.195 5.275 72.445 5.365)
rect(cv "Metal5" 72.275 5.195 72.365 5.445)
rect(cv "Metal5" 72.28 5.28 72.36 7.6)
rect(cv "Via4" 72.285 7.525 72.355 7.595)
rect(cv "Metal4" 72.195 7.515 72.445 7.605)
rect(cv "Metal5" 72.275 7.435 72.365 7.685)
rect(cv "Via3" 72.605 5.285 72.675 5.355)
rect(cv "Metal3" 72.595 5.195 72.685 5.445)
rect(cv "Metal4" 72.515 5.275 72.765 5.365)
rect(cv "Via4" 72.605 5.285 72.675 5.355)
rect(cv "Metal4" 72.515 5.275 72.765 5.365)
rect(cv "Metal5" 72.595 5.195 72.685 5.445)
rect(cv "Metal5" 72.6 5.28 72.68 8.72)
rect(cv "Via4" 72.605 8.645 72.675 8.715)
rect(cv "Metal4" 72.515 8.635 72.765 8.725)
rect(cv "Metal5" 72.595 8.555 72.685 8.805)
rect(cv "Via3" 72.925 5.285 72.995 5.355)
rect(cv "Metal3" 72.915 5.195 73.005 5.445)
rect(cv "Metal4" 72.835 5.275 73.085 5.365)
rect(cv "Via4" 72.925 5.285 72.995 5.355)
rect(cv "Metal4" 72.835 5.275 73.085 5.365)
rect(cv "Metal5" 72.915 5.195 73.005 5.445)
rect(cv "Metal5" 72.92 5.28 73 6.64)
rect(cv "Via4" 72.925 6.565 72.995 6.635)
rect(cv "Metal4" 72.835 6.555 73.085 6.645)
rect(cv "Metal5" 72.915 6.475 73.005 6.725)
rect(cv "Via3" 73.245 5.285 73.315 5.355)
rect(cv "Metal3" 73.235 5.195 73.325 5.445)
rect(cv "Metal4" 73.155 5.275 73.405 5.365)
rect(cv "Via4" 73.245 5.285 73.315 5.355)
rect(cv "Metal4" 73.155 5.275 73.405 5.365)
rect(cv "Metal5" 73.235 5.195 73.325 5.445)
rect(cv "Metal5" 73.24 5.28 73.32 10.16)
rect(cv "Via4" 73.245 10.085 73.315 10.155)
rect(cv "Metal4" 73.155 10.075 73.405 10.165)
rect(cv "Metal5" 73.235 9.995 73.325 10.245)
rect(cv "Via3" 73.565 5.285 73.635 5.355)
rect(cv "Metal3" 73.555 5.195 73.645 5.445)
rect(cv "Metal4" 73.475 5.275 73.725 5.365)
rect(cv "Via4" 73.565 5.285 73.635 5.355)
rect(cv "Metal4" 73.475 5.275 73.725 5.365)
rect(cv "Metal5" 73.555 5.195 73.645 5.445)
rect(cv "Metal5" 73.56 5.28 73.64 9.04)
rect(cv "Via4" 73.565 8.965 73.635 9.035)
rect(cv "Metal4" 73.475 8.955 73.725 9.045)
rect(cv "Metal5" 73.555 8.875 73.645 9.125)
rect(cv "Via3" 73.885 5.285 73.955 5.355)
rect(cv "Metal3" 73.875 5.195 73.965 5.445)
rect(cv "Metal4" 73.795 5.275 74.045 5.365)
rect(cv "Via4" 73.885 5.285 73.955 5.355)
rect(cv "Metal4" 73.795 5.275 74.045 5.365)
rect(cv "Metal5" 73.875 5.195 73.965 5.445)
rect(cv "Metal5" 73.88 5.28 73.96 9.2)
rect(cv "Via4" 73.885 9.125 73.955 9.195)
rect(cv "Metal4" 73.795 9.115 74.045 9.205)
rect(cv "Metal5" 73.875 9.035 73.965 9.285)
rect(cv "Via3" 76.555 5.285 76.625 5.355)
rect(cv "Metal3" 76.545 5.195 76.635 5.445)
rect(cv "Metal4" 76.465 5.275 76.715 5.365)
rect(cv "Via4" 76.555 5.285 76.625 5.355)
rect(cv "Metal4" 76.465 5.275 76.715 5.365)
rect(cv "Metal5" 76.545 5.195 76.635 5.445)
rect(cv "Metal5" 76.55 5.28 76.63 8.56)
rect(cv "Via4" 76.555 8.485 76.625 8.555)
rect(cv "Metal4" 76.465 8.475 76.715 8.565)
rect(cv "Metal5" 76.545 8.395 76.635 8.645)
rect(cv "Via3" 76.875 5.285 76.945 5.355)
rect(cv "Metal3" 76.865 5.195 76.955 5.445)
rect(cv "Metal4" 76.785 5.275 77.035 5.365)
rect(cv "Via4" 76.875 5.285 76.945 5.355)
rect(cv "Metal4" 76.785 5.275 77.035 5.365)
rect(cv "Metal5" 76.865 5.195 76.955 5.445)
rect(cv "Metal5" 76.87 5.28 76.95 8.88)
rect(cv "Via4" 76.875 8.805 76.945 8.875)
rect(cv "Metal4" 76.785 8.795 77.035 8.885)
rect(cv "Metal5" 76.865 8.715 76.955 8.965)
rect(cv "Via3" 77.195 5.285 77.265 5.355)
rect(cv "Metal3" 77.185 5.195 77.275 5.445)
rect(cv "Metal4" 77.105 5.275 77.355 5.365)
rect(cv "Via4" 77.195 5.285 77.265 5.355)
rect(cv "Metal4" 77.105 5.275 77.355 5.365)
rect(cv "Metal5" 77.185 5.195 77.275 5.445)
rect(cv "Metal5" 77.19 5.28 77.27 6.64)
rect(cv "Via4" 77.195 6.565 77.265 6.635)
rect(cv "Metal4" 77.105 6.555 77.355 6.645)
rect(cv "Metal5" 77.185 6.475 77.275 6.725)
rect(cv "Via3" 77.515 5.285 77.585 5.355)
rect(cv "Metal3" 77.505 5.195 77.595 5.445)
rect(cv "Metal4" 77.425 5.275 77.675 5.365)
rect(cv "Via4" 77.515 5.285 77.585 5.355)
rect(cv "Metal4" 77.425 5.275 77.675 5.365)
rect(cv "Metal5" 77.505 5.195 77.595 5.445)
rect(cv "Metal5" 77.51 5.28 77.59 10.16)
rect(cv "Via4" 77.515 10.085 77.585 10.155)
rect(cv "Metal4" 77.425 10.075 77.675 10.165)
rect(cv "Metal5" 77.505 9.995 77.595 10.245)
rect(cv "Via3" 77.835 5.285 77.905 5.355)
rect(cv "Metal3" 77.825 5.195 77.915 5.445)
rect(cv "Metal4" 77.745 5.275 77.995 5.365)
rect(cv "Via4" 77.835 5.285 77.905 5.355)
rect(cv "Metal4" 77.745 5.275 77.995 5.365)
rect(cv "Metal5" 77.825 5.195 77.915 5.445)
rect(cv "Metal5" 77.83 5.28 77.91 9.04)
rect(cv "Via4" 77.835 8.965 77.905 9.035)
rect(cv "Metal4" 77.745 8.955 77.995 9.045)
rect(cv "Metal5" 77.825 8.875 77.915 9.125)
rect(cv "Via3" 78.155 5.285 78.225 5.355)
rect(cv "Metal3" 78.145 5.195 78.235 5.445)
rect(cv "Metal4" 78.065 5.275 78.315 5.365)
rect(cv "Via4" 78.155 5.285 78.225 5.355)
rect(cv "Metal4" 78.065 5.275 78.315 5.365)
rect(cv "Metal5" 78.145 5.195 78.235 5.445)
rect(cv "Metal5" 78.15 5.28 78.23 9.2)
rect(cv "Via4" 78.155 9.125 78.225 9.195)
rect(cv "Metal4" 78.065 9.115 78.315 9.205)
rect(cv "Metal5" 78.145 9.035 78.235 9.285)
rect(cv "Metal4" 0.21 5.76 16.42 5.84)
rect(cv "Via3" 0.215 5.765 0.285 5.835)
rect(cv "Metal3" 0.205 5.675 0.295 5.925)
rect(cv "Metal4" 0.125 5.755 0.375 5.845)
rect(cv "Metal3" 0.18 5.73 0.32 10.61)
port(cv "CS0" "Metal3" 0.25 10.54)
rect(cv "Metal4" 0.53 5.92 28.59 6)
rect(cv "Via3" 0.535 5.925 0.605 5.995)
rect(cv "Metal3" 0.525 5.835 0.615 6.085)
rect(cv "Metal4" 0.445 5.915 0.695 6.005)
rect(cv "Metal3" 0.5 5.89 0.64 10.61)
port(cv "CS1" "Metal3" 0.57 10.54)
rect(cv "Metal4" 0.85 6.08 40.76 6.16)
rect(cv "Via3" 0.855 6.085 0.925 6.155)
rect(cv "Metal3" 0.845 5.995 0.935 6.245)
rect(cv "Metal4" 0.765 6.075 1.015 6.165)
rect(cv "Metal3" 0.82 6.05 0.96 10.61)
port(cv "CS2" "Metal3" 0.89 10.54)
rect(cv "Metal4" 1.17 6.24 52.93 6.32)
rect(cv "Via3" 1.175 6.245 1.245 6.315)
rect(cv "Metal3" 1.165 6.155 1.255 6.405)
rect(cv "Metal4" 1.085 6.235 1.335 6.325)
rect(cv "Metal3" 1.14 6.21 1.28 10.61)
port(cv "CS3" "Metal3" 1.21 10.54)
rect(cv "Metal4" 1.49 6.4 65.1 6.48)
rect(cv "Via3" 1.495 6.405 1.565 6.475)
rect(cv "Metal3" 1.485 6.315 1.575 6.565)
rect(cv "Metal4" 1.405 6.395 1.655 6.485)
rect(cv "Metal3" 1.46 6.37 1.6 10.61)
port(cv "CS4" "Metal3" 1.53 10.54)
rect(cv "Metal4" 1.81 6.56 77.27 6.64)
rect(cv "Via3" 1.815 6.565 1.885 6.635)
rect(cv "Metal3" 1.805 6.475 1.895 6.725)
rect(cv "Metal4" 1.725 6.555 1.975 6.645)
rect(cv "Metal3" 1.78 6.53 1.92 10.61)
port(cv "CS5" "Metal3" 1.85 10.54)
rect(cv "Metal4" 2.13 6.72 11.51 6.8)
rect(cv "Via3" 2.135 6.725 2.205 6.795)
rect(cv "Metal3" 2.125 6.635 2.215 6.885)
rect(cv "Metal4" 2.045 6.715 2.295 6.805)
rect(cv "Metal3" 2.1 6.69 2.24 10.61)
port(cv "BL0" "Metal3" 2.17 10.54)
rect(cv "Metal4" 2.45 6.88 23.68 6.96)
rect(cv "Via3" 2.455 6.885 2.525 6.955)
rect(cv "Metal3" 2.445 6.795 2.535 7.045)
rect(cv "Metal4" 2.365 6.875 2.615 6.965)
rect(cv "Metal3" 2.42 6.85 2.56 10.61)
port(cv "BL1" "Metal3" 2.49 10.54)
rect(cv "Metal4" 2.77 7.04 35.85 7.12)
rect(cv "Via3" 2.775 7.045 2.845 7.115)
rect(cv "Metal3" 2.765 6.955 2.855 7.205)
rect(cv "Metal4" 2.685 7.035 2.935 7.125)
rect(cv "Metal3" 2.74 7.01 2.88 10.61)
port(cv "BL2" "Metal3" 2.81 10.54)
rect(cv "Metal4" 3.09 7.2 48.02 7.28)
rect(cv "Via3" 3.095 7.205 3.165 7.275)
rect(cv "Metal3" 3.085 7.115 3.175 7.365)
rect(cv "Metal4" 3.005 7.195 3.255 7.285)
rect(cv "Metal3" 3.06 7.17 3.2 10.61)
port(cv "BL3" "Metal3" 3.13 10.54)
rect(cv "Metal4" 3.41 7.36 60.19 7.44)
rect(cv "Via3" 3.415 7.365 3.485 7.435)
rect(cv "Metal3" 3.405 7.275 3.495 7.525)
rect(cv "Metal4" 3.325 7.355 3.575 7.445)
rect(cv "Metal3" 3.38 7.33 3.52 10.61)
port(cv "BL4" "Metal3" 3.45 10.54)
rect(cv "Metal4" 3.73 7.52 72.36 7.6)
rect(cv "Via3" 3.735 7.525 3.805 7.595)
rect(cv "Metal3" 3.725 7.435 3.815 7.685)
rect(cv "Metal4" 3.645 7.515 3.895 7.605)
rect(cv "Metal3" 3.7 7.49 3.84 10.61)
port(cv "BL5" "Metal3" 3.77 10.54)
rect(cv "Metal4" 4.05 7.68 15.78 7.76)
rect(cv "Via3" 4.055 7.685 4.125 7.755)
rect(cv "Metal3" 4.045 7.595 4.135 7.845)
rect(cv "Metal4" 3.965 7.675 4.215 7.765)
rect(cv "Metal3" 4.02 7.65 4.16 10.61)
port(cv "BLB0" "Metal3" 4.09 10.54)
rect(cv "Metal4" 4.37 7.84 27.95 7.92)
rect(cv "Via3" 4.375 7.845 4.445 7.915)
rect(cv "Metal3" 4.365 7.755 4.455 8.005)
rect(cv "Metal4" 4.285 7.835 4.535 7.925)
rect(cv "Metal3" 4.34 7.81 4.48 10.61)
port(cv "BLB1" "Metal3" 4.41 10.54)
rect(cv "Metal4" 4.69 8 40.12 8.08)
rect(cv "Via3" 4.695 8.005 4.765 8.075)
rect(cv "Metal3" 4.685 7.915 4.775 8.165)
rect(cv "Metal4" 4.605 7.995 4.855 8.085)
rect(cv "Metal3" 4.66 7.97 4.8 10.61)
port(cv "BLB2" "Metal3" 4.73 10.54)
rect(cv "Metal4" 5.01 8.16 52.29 8.24)
rect(cv "Via3" 5.015 8.165 5.085 8.235)
rect(cv "Metal3" 5.005 8.075 5.095 8.325)
rect(cv "Metal4" 4.925 8.155 5.175 8.245)
rect(cv "Metal3" 4.98 8.13 5.12 10.61)
port(cv "BLB3" "Metal3" 5.05 10.54)
rect(cv "Metal4" 5.33 8.32 64.46 8.4)
rect(cv "Via3" 5.335 8.325 5.405 8.395)
rect(cv "Metal3" 5.325 8.235 5.415 8.485)
rect(cv "Metal4" 5.245 8.315 5.495 8.405)
rect(cv "Metal3" 5.3 8.29 5.44 10.61)
port(cv "BLB4" "Metal3" 5.37 10.54)
rect(cv "Metal4" 5.65 8.48 76.63 8.56)
rect(cv "Via3" 5.655 8.485 5.725 8.555)
rect(cv "Metal3" 5.645 8.395 5.735 8.645)
rect(cv "Metal4" 5.565 8.475 5.815 8.565)
rect(cv "Metal3" 5.62 8.45 5.76 10.61)
port(cv "BLB5" "Metal3" 5.69 10.54)
rect(cv "Metal4" 5.97 8.64 72.68 8.72)
rect(cv "Via3" 5.975 8.645 6.045 8.715)
rect(cv "Metal3" 5.965 8.555 6.055 8.805)
rect(cv "Metal4" 5.885 8.635 6.135 8.725)
rect(cv "Metal3" 5.94 8.61 6.08 10.61)
port(cv "GBL" "Metal3" 6.01 10.54)
rect(cv "Metal4" 6.29 8.8 76.95 8.88)
rect(cv "Via3" 6.295 8.805 6.365 8.875)
rect(cv "Metal3" 6.285 8.715 6.375 8.965)
rect(cv "Metal4" 6.205 8.795 6.455 8.885)
rect(cv "Metal3" 6.26 8.77 6.4 10.61)
port(cv "GBLB" "Metal3" 6.33 10.54)
rect(cv "Metal4" 6.61 8.96 77.91 9.04)
rect(cv "Via3" 6.615 8.965 6.685 9.035)
rect(cv "Metal3" 6.605 8.875 6.695 9.125)
rect(cv "Metal4" 6.525 8.955 6.775 9.045)
rect(cv "Metal3" 6.58 8.93 6.72 10.61)
port(cv "VDD" "Metal3" 6.65 10.54)
rect(cv "Metal4" 6.93 9.12 78.23 9.2)
rect(cv "Via3" 6.935 9.125 7.005 9.195)
rect(cv "Metal3" 6.925 9.035 7.015 9.285)
rect(cv "Metal4" 6.845 9.115 7.095 9.205)
rect(cv "Metal3" 6.9 9.09 7.04 10.61)
port(cv "GND" "Metal3" 6.97 10.54)
rect(cv "Metal4" 8.12 9.28 16.74 9.36)
rect(cv "Metal4" 20.29 9.44 28.91 9.52)
rect(cv "Metal4" 32.46 9.6 41.08 9.68)
rect(cv "Metal4" 44.63 9.76 53.25 9.84)
rect(cv "Metal4" 56.8 9.92 65.42 10)
rect(cv "Metal4" 68.97 10.08 77.59 10.16)
rect(cv "prBoundary" 0.0 0.0 80.61 10.62)
dbSave(cv) printf("LAYOUT column_mux %L\n" cv~>bBox) dbClose(cv)
cv=dbOpenCellViewByType("sram_project" "precharge" "layout" "maskLayout" "w")
dbCreateInst(cv dbOpenCellViewByType("sram_project" "precharge_unit" "layout" "" "r") "P0" list(5.35 0.35) "R0")
dbCreateInst(cv dbOpenCellViewByType("sram_project" "precharge_unit" "layout" "" "r") "P1" list(10.7 0.35) "R0")
dbCreateInst(cv dbOpenCellViewByType("sram_project" "precharge_unit" "layout" "" "r") "P2" list(16.05 0.35) "R0")
dbCreateInst(cv dbOpenCellViewByType("sram_project" "precharge_unit" "layout" "" "r") "P3" list(21.4 0.35) "R0")
dbCreateInst(cv dbOpenCellViewByType("sram_project" "precharge_unit" "layout" "" "r") "P4" list(26.75 0.35) "R0")
dbCreateInst(cv dbOpenCellViewByType("sram_project" "precharge_unit" "layout" "" "r") "P5" list(32.1 0.35) "R0")
rect(cv "Via3" 5.565 4.685 5.635 4.755)
rect(cv "Metal3" 5.555 4.595 5.645 4.845)
rect(cv "Metal4" 5.475 4.675 5.725 4.765)
rect(cv "Via4" 5.565 4.685 5.635 4.755)
rect(cv "Metal4" 5.475 4.675 5.725 4.765)
rect(cv "Metal5" 5.555 4.595 5.645 4.845)
rect(cv "Metal5" 5.56 4.68 5.64 5.24)
rect(cv "Via4" 5.565 5.165 5.635 5.235)
rect(cv "Metal4" 5.475 5.155 5.725 5.245)
rect(cv "Metal5" 5.555 5.075 5.645 5.325)
rect(cv "Via3" 5.885 4.685 5.955 4.755)
rect(cv "Metal3" 5.875 4.595 5.965 4.845)
rect(cv "Metal4" 5.795 4.675 6.045 4.765)
rect(cv "Via4" 5.885 4.685 5.955 4.755)
rect(cv "Metal4" 5.795 4.675 6.045 4.765)
rect(cv "Metal5" 5.875 4.595 5.965 4.845)
rect(cv "Metal5" 5.88 4.68 5.96 6.2)
rect(cv "Via4" 5.885 6.125 5.955 6.195)
rect(cv "Metal4" 5.795 6.115 6.045 6.205)
rect(cv "Metal5" 5.875 6.035 5.965 6.285)
rect(cv "Via3" 6.205 4.685 6.275 4.755)
rect(cv "Metal3" 6.195 4.595 6.285 4.845)
rect(cv "Metal4" 6.115 4.675 6.365 4.765)
rect(cv "Via4" 6.205 4.685 6.275 4.755)
rect(cv "Metal4" 6.115 4.675 6.365 4.765)
rect(cv "Metal5" 6.195 4.595 6.285 4.845)
rect(cv "Metal5" 6.2 4.68 6.28 7.16)
rect(cv "Via4" 6.205 7.085 6.275 7.155)
rect(cv "Metal4" 6.115 7.075 6.365 7.165)
rect(cv "Metal5" 6.195 6.995 6.285 7.245)
rect(cv "Via3" 6.525 4.685 6.595 4.755)
rect(cv "Metal3" 6.515 4.595 6.605 4.845)
rect(cv "Metal4" 6.435 4.675 6.685 4.765)
rect(cv "Via4" 6.525 4.685 6.595 4.755)
rect(cv "Metal4" 6.435 4.675 6.685 4.765)
rect(cv "Metal5" 6.515 4.595 6.605 4.845)
rect(cv "Metal5" 6.52 4.68 6.6 7.32)
rect(cv "Via4" 6.525 7.245 6.595 7.315)
rect(cv "Metal4" 6.435 7.235 6.685 7.325)
rect(cv "Metal5" 6.515 7.155 6.605 7.405)
rect(cv "Via3" 6.845 4.685 6.915 4.755)
rect(cv "Metal3" 6.835 4.595 6.925 4.845)
rect(cv "Metal4" 6.755 4.675 7.005 4.765)
rect(cv "Via4" 6.845 4.685 6.915 4.755)
rect(cv "Metal4" 6.755 4.675 7.005 4.765)
rect(cv "Metal5" 6.835 4.595 6.925 4.845)
rect(cv "Metal5" 6.84 4.68 6.92 7.48)
rect(cv "Via4" 6.845 7.405 6.915 7.475)
rect(cv "Metal4" 6.755 7.395 7.005 7.485)
rect(cv "Metal5" 6.835 7.315 6.925 7.565)
rect(cv "Via3" 10.915 4.685 10.985 4.755)
rect(cv "Metal3" 10.905 4.595 10.995 4.845)
rect(cv "Metal4" 10.825 4.675 11.075 4.765)
rect(cv "Via4" 10.915 4.685 10.985 4.755)
rect(cv "Metal4" 10.825 4.675 11.075 4.765)
rect(cv "Metal5" 10.905 4.595 10.995 4.845)
rect(cv "Metal5" 10.91 4.68 10.99 5.4)
rect(cv "Via4" 10.915 5.325 10.985 5.395)
rect(cv "Metal4" 10.825 5.315 11.075 5.405)
rect(cv "Metal5" 10.905 5.235 10.995 5.485)
rect(cv "Via3" 11.235 4.685 11.305 4.755)
rect(cv "Metal3" 11.225 4.595 11.315 4.845)
rect(cv "Metal4" 11.145 4.675 11.395 4.765)
rect(cv "Via4" 11.235 4.685 11.305 4.755)
rect(cv "Metal4" 11.145 4.675 11.395 4.765)
rect(cv "Metal5" 11.225 4.595 11.315 4.845)
rect(cv "Metal5" 11.23 4.68 11.31 6.36)
rect(cv "Via4" 11.235 6.285 11.305 6.355)
rect(cv "Metal4" 11.145 6.275 11.395 6.365)
rect(cv "Metal5" 11.225 6.195 11.315 6.445)
rect(cv "Via3" 11.555 4.685 11.625 4.755)
rect(cv "Metal3" 11.545 4.595 11.635 4.845)
rect(cv "Metal4" 11.465 4.675 11.715 4.765)
rect(cv "Via4" 11.555 4.685 11.625 4.755)
rect(cv "Metal4" 11.465 4.675 11.715 4.765)
rect(cv "Metal5" 11.545 4.595 11.635 4.845)
rect(cv "Metal5" 11.55 4.68 11.63 7.16)
rect(cv "Via4" 11.555 7.085 11.625 7.155)
rect(cv "Metal4" 11.465 7.075 11.715 7.165)
rect(cv "Metal5" 11.545 6.995 11.635 7.245)
rect(cv "Via3" 11.875 4.685 11.945 4.755)
rect(cv "Metal3" 11.865 4.595 11.955 4.845)
rect(cv "Metal4" 11.785 4.675 12.035 4.765)
rect(cv "Via4" 11.875 4.685 11.945 4.755)
rect(cv "Metal4" 11.785 4.675 12.035 4.765)
rect(cv "Metal5" 11.865 4.595 11.955 4.845)
rect(cv "Metal5" 11.87 4.68 11.95 7.32)
rect(cv "Via4" 11.875 7.245 11.945 7.315)
rect(cv "Metal4" 11.785 7.235 12.035 7.325)
rect(cv "Metal5" 11.865 7.155 11.955 7.405)
rect(cv "Via3" 12.195 4.685 12.265 4.755)
rect(cv "Metal3" 12.185 4.595 12.275 4.845)
rect(cv "Metal4" 12.105 4.675 12.355 4.765)
rect(cv "Via4" 12.195 4.685 12.265 4.755)
rect(cv "Metal4" 12.105 4.675 12.355 4.765)
rect(cv "Metal5" 12.185 4.595 12.275 4.845)
rect(cv "Metal5" 12.19 4.68 12.27 7.48)
rect(cv "Via4" 12.195 7.405 12.265 7.475)
rect(cv "Metal4" 12.105 7.395 12.355 7.485)
rect(cv "Metal5" 12.185 7.315 12.275 7.565)
rect(cv "Via3" 16.265 4.685 16.335 4.755)
rect(cv "Metal3" 16.255 4.595 16.345 4.845)
rect(cv "Metal4" 16.175 4.675 16.425 4.765)
rect(cv "Via4" 16.265 4.685 16.335 4.755)
rect(cv "Metal4" 16.175 4.675 16.425 4.765)
rect(cv "Metal5" 16.255 4.595 16.345 4.845)
rect(cv "Metal5" 16.26 4.68 16.34 5.56)
rect(cv "Via4" 16.265 5.485 16.335 5.555)
rect(cv "Metal4" 16.175 5.475 16.425 5.565)
rect(cv "Metal5" 16.255 5.395 16.345 5.645)
rect(cv "Via3" 16.585 4.685 16.655 4.755)
rect(cv "Metal3" 16.575 4.595 16.665 4.845)
rect(cv "Metal4" 16.495 4.675 16.745 4.765)
rect(cv "Via4" 16.585 4.685 16.655 4.755)
rect(cv "Metal4" 16.495 4.675 16.745 4.765)
rect(cv "Metal5" 16.575 4.595 16.665 4.845)
rect(cv "Metal5" 16.58 4.68 16.66 6.52)
rect(cv "Via4" 16.585 6.445 16.655 6.515)
rect(cv "Metal4" 16.495 6.435 16.745 6.525)
rect(cv "Metal5" 16.575 6.355 16.665 6.605)
rect(cv "Via3" 16.905 4.685 16.975 4.755)
rect(cv "Metal3" 16.895 4.595 16.985 4.845)
rect(cv "Metal4" 16.815 4.675 17.065 4.765)
rect(cv "Via4" 16.905 4.685 16.975 4.755)
rect(cv "Metal4" 16.815 4.675 17.065 4.765)
rect(cv "Metal5" 16.895 4.595 16.985 4.845)
rect(cv "Metal5" 16.9 4.68 16.98 7.16)
rect(cv "Via4" 16.905 7.085 16.975 7.155)
rect(cv "Metal4" 16.815 7.075 17.065 7.165)
rect(cv "Metal5" 16.895 6.995 16.985 7.245)
rect(cv "Via3" 17.225 4.685 17.295 4.755)
rect(cv "Metal3" 17.215 4.595 17.305 4.845)
rect(cv "Metal4" 17.135 4.675 17.385 4.765)
rect(cv "Via4" 17.225 4.685 17.295 4.755)
rect(cv "Metal4" 17.135 4.675 17.385 4.765)
rect(cv "Metal5" 17.215 4.595 17.305 4.845)
rect(cv "Metal5" 17.22 4.68 17.3 7.32)
rect(cv "Via4" 17.225 7.245 17.295 7.315)
rect(cv "Metal4" 17.135 7.235 17.385 7.325)
rect(cv "Metal5" 17.215 7.155 17.305 7.405)
rect(cv "Via3" 17.545 4.685 17.615 4.755)
rect(cv "Metal3" 17.535 4.595 17.625 4.845)
rect(cv "Metal4" 17.455 4.675 17.705 4.765)
rect(cv "Via4" 17.545 4.685 17.615 4.755)
rect(cv "Metal4" 17.455 4.675 17.705 4.765)
rect(cv "Metal5" 17.535 4.595 17.625 4.845)
rect(cv "Metal5" 17.54 4.68 17.62 7.48)
rect(cv "Via4" 17.545 7.405 17.615 7.475)
rect(cv "Metal4" 17.455 7.395 17.705 7.485)
rect(cv "Metal5" 17.535 7.315 17.625 7.565)
rect(cv "Via3" 21.615 4.685 21.685 4.755)
rect(cv "Metal3" 21.605 4.595 21.695 4.845)
rect(cv "Metal4" 21.525 4.675 21.775 4.765)
rect(cv "Via4" 21.615 4.685 21.685 4.755)
rect(cv "Metal4" 21.525 4.675 21.775 4.765)
rect(cv "Metal5" 21.605 4.595 21.695 4.845)
rect(cv "Metal5" 21.61 4.68 21.69 5.72)
rect(cv "Via4" 21.615 5.645 21.685 5.715)
rect(cv "Metal4" 21.525 5.635 21.775 5.725)
rect(cv "Metal5" 21.605 5.555 21.695 5.805)
rect(cv "Via3" 21.935 4.685 22.005 4.755)
rect(cv "Metal3" 21.925 4.595 22.015 4.845)
rect(cv "Metal4" 21.845 4.675 22.095 4.765)
rect(cv "Via4" 21.935 4.685 22.005 4.755)
rect(cv "Metal4" 21.845 4.675 22.095 4.765)
rect(cv "Metal5" 21.925 4.595 22.015 4.845)
rect(cv "Metal5" 21.93 4.68 22.01 6.68)
rect(cv "Via4" 21.935 6.605 22.005 6.675)
rect(cv "Metal4" 21.845 6.595 22.095 6.685)
rect(cv "Metal5" 21.925 6.515 22.015 6.765)
rect(cv "Via3" 22.255 4.685 22.325 4.755)
rect(cv "Metal3" 22.245 4.595 22.335 4.845)
rect(cv "Metal4" 22.165 4.675 22.415 4.765)
rect(cv "Via4" 22.255 4.685 22.325 4.755)
rect(cv "Metal4" 22.165 4.675 22.415 4.765)
rect(cv "Metal5" 22.245 4.595 22.335 4.845)
rect(cv "Metal5" 22.25 4.68 22.33 7.16)
rect(cv "Via4" 22.255 7.085 22.325 7.155)
rect(cv "Metal4" 22.165 7.075 22.415 7.165)
rect(cv "Metal5" 22.245 6.995 22.335 7.245)
rect(cv "Via3" 22.575 4.685 22.645 4.755)
rect(cv "Metal3" 22.565 4.595 22.655 4.845)
rect(cv "Metal4" 22.485 4.675 22.735 4.765)
rect(cv "Via4" 22.575 4.685 22.645 4.755)
rect(cv "Metal4" 22.485 4.675 22.735 4.765)
rect(cv "Metal5" 22.565 4.595 22.655 4.845)
rect(cv "Metal5" 22.57 4.68 22.65 7.32)
rect(cv "Via4" 22.575 7.245 22.645 7.315)
rect(cv "Metal4" 22.485 7.235 22.735 7.325)
rect(cv "Metal5" 22.565 7.155 22.655 7.405)
rect(cv "Via3" 22.895 4.685 22.965 4.755)
rect(cv "Metal3" 22.885 4.595 22.975 4.845)
rect(cv "Metal4" 22.805 4.675 23.055 4.765)
rect(cv "Via4" 22.895 4.685 22.965 4.755)
rect(cv "Metal4" 22.805 4.675 23.055 4.765)
rect(cv "Metal5" 22.885 4.595 22.975 4.845)
rect(cv "Metal5" 22.89 4.68 22.97 7.48)
rect(cv "Via4" 22.895 7.405 22.965 7.475)
rect(cv "Metal4" 22.805 7.395 23.055 7.485)
rect(cv "Metal5" 22.885 7.315 22.975 7.565)
rect(cv "Via3" 26.965 4.685 27.035 4.755)
rect(cv "Metal3" 26.955 4.595 27.045 4.845)
rect(cv "Metal4" 26.875 4.675 27.125 4.765)
rect(cv "Via4" 26.965 4.685 27.035 4.755)
rect(cv "Metal4" 26.875 4.675 27.125 4.765)
rect(cv "Metal5" 26.955 4.595 27.045 4.845)
rect(cv "Metal5" 26.96 4.68 27.04 5.88)
rect(cv "Via4" 26.965 5.805 27.035 5.875)
rect(cv "Metal4" 26.875 5.795 27.125 5.885)
rect(cv "Metal5" 26.955 5.715 27.045 5.965)
rect(cv "Via3" 27.285 4.685 27.355 4.755)
rect(cv "Metal3" 27.275 4.595 27.365 4.845)
rect(cv "Metal4" 27.195 4.675 27.445 4.765)
rect(cv "Via4" 27.285 4.685 27.355 4.755)
rect(cv "Metal4" 27.195 4.675 27.445 4.765)
rect(cv "Metal5" 27.275 4.595 27.365 4.845)
rect(cv "Metal5" 27.28 4.68 27.36 6.84)
rect(cv "Via4" 27.285 6.765 27.355 6.835)
rect(cv "Metal4" 27.195 6.755 27.445 6.845)
rect(cv "Metal5" 27.275 6.675 27.365 6.925)
rect(cv "Via3" 27.605 4.685 27.675 4.755)
rect(cv "Metal3" 27.595 4.595 27.685 4.845)
rect(cv "Metal4" 27.515 4.675 27.765 4.765)
rect(cv "Via4" 27.605 4.685 27.675 4.755)
rect(cv "Metal4" 27.515 4.675 27.765 4.765)
rect(cv "Metal5" 27.595 4.595 27.685 4.845)
rect(cv "Metal5" 27.6 4.68 27.68 7.16)
rect(cv "Via4" 27.605 7.085 27.675 7.155)
rect(cv "Metal4" 27.515 7.075 27.765 7.165)
rect(cv "Metal5" 27.595 6.995 27.685 7.245)
rect(cv "Via3" 27.925 4.685 27.995 4.755)
rect(cv "Metal3" 27.915 4.595 28.005 4.845)
rect(cv "Metal4" 27.835 4.675 28.085 4.765)
rect(cv "Via4" 27.925 4.685 27.995 4.755)
rect(cv "Metal4" 27.835 4.675 28.085 4.765)
rect(cv "Metal5" 27.915 4.595 28.005 4.845)
rect(cv "Metal5" 27.92 4.68 28 7.32)
rect(cv "Via4" 27.925 7.245 27.995 7.315)
rect(cv "Metal4" 27.835 7.235 28.085 7.325)
rect(cv "Metal5" 27.915 7.155 28.005 7.405)
rect(cv "Via3" 28.245 4.685 28.315 4.755)
rect(cv "Metal3" 28.235 4.595 28.325 4.845)
rect(cv "Metal4" 28.155 4.675 28.405 4.765)
rect(cv "Via4" 28.245 4.685 28.315 4.755)
rect(cv "Metal4" 28.155 4.675 28.405 4.765)
rect(cv "Metal5" 28.235 4.595 28.325 4.845)
rect(cv "Metal5" 28.24 4.68 28.32 7.48)
rect(cv "Via4" 28.245 7.405 28.315 7.475)
rect(cv "Metal4" 28.155 7.395 28.405 7.485)
rect(cv "Metal5" 28.235 7.315 28.325 7.565)
rect(cv "Via3" 32.315 4.685 32.385 4.755)
rect(cv "Metal3" 32.305 4.595 32.395 4.845)
rect(cv "Metal4" 32.225 4.675 32.475 4.765)
rect(cv "Via4" 32.315 4.685 32.385 4.755)
rect(cv "Metal4" 32.225 4.675 32.475 4.765)
rect(cv "Metal5" 32.305 4.595 32.395 4.845)
rect(cv "Metal5" 32.31 4.68 32.39 6.04)
rect(cv "Via4" 32.315 5.965 32.385 6.035)
rect(cv "Metal4" 32.225 5.955 32.475 6.045)
rect(cv "Metal5" 32.305 5.875 32.395 6.125)
rect(cv "Via3" 32.635 4.685 32.705 4.755)
rect(cv "Metal3" 32.625 4.595 32.715 4.845)
rect(cv "Metal4" 32.545 4.675 32.795 4.765)
rect(cv "Via4" 32.635 4.685 32.705 4.755)
rect(cv "Metal4" 32.545 4.675 32.795 4.765)
rect(cv "Metal5" 32.625 4.595 32.715 4.845)
rect(cv "Metal5" 32.63 4.68 32.71 7)
rect(cv "Via4" 32.635 6.925 32.705 6.995)
rect(cv "Metal4" 32.545 6.915 32.795 7.005)
rect(cv "Metal5" 32.625 6.835 32.715 7.085)
rect(cv "Via3" 32.955 4.685 33.025 4.755)
rect(cv "Metal3" 32.945 4.595 33.035 4.845)
rect(cv "Metal4" 32.865 4.675 33.115 4.765)
rect(cv "Via4" 32.955 4.685 33.025 4.755)
rect(cv "Metal4" 32.865 4.675 33.115 4.765)
rect(cv "Metal5" 32.945 4.595 33.035 4.845)
rect(cv "Metal5" 32.95 4.68 33.03 7.16)
rect(cv "Via4" 32.955 7.085 33.025 7.155)
rect(cv "Metal4" 32.865 7.075 33.115 7.165)
rect(cv "Metal5" 32.945 6.995 33.035 7.245)
rect(cv "Via3" 33.275 4.685 33.345 4.755)
rect(cv "Metal3" 33.265 4.595 33.355 4.845)
rect(cv "Metal4" 33.185 4.675 33.435 4.765)
rect(cv "Via4" 33.275 4.685 33.345 4.755)
rect(cv "Metal4" 33.185 4.675 33.435 4.765)
rect(cv "Metal5" 33.265 4.595 33.355 4.845)
rect(cv "Metal5" 33.27 4.68 33.35 7.32)
rect(cv "Via4" 33.275 7.245 33.345 7.315)
rect(cv "Metal4" 33.185 7.235 33.435 7.325)
rect(cv "Metal5" 33.265 7.155 33.355 7.405)
rect(cv "Via3" 33.595 4.685 33.665 4.755)
rect(cv "Metal3" 33.585 4.595 33.675 4.845)
rect(cv "Metal4" 33.505 4.675 33.755 4.765)
rect(cv "Via4" 33.595 4.685 33.665 4.755)
rect(cv "Metal4" 33.505 4.675 33.755 4.765)
rect(cv "Metal5" 33.585 4.595 33.675 4.845)
rect(cv "Metal5" 33.59 4.68 33.67 7.48)
rect(cv "Via4" 33.595 7.405 33.665 7.475)
rect(cv "Metal4" 33.505 7.395 33.755 7.485)
rect(cv "Metal5" 33.585 7.315 33.675 7.565)
rect(cv "Metal4" 0.21 5.16 5.64 5.24)
rect(cv "Via3" 0.215 5.165 0.285 5.235)
rect(cv "Metal3" 0.205 5.075 0.295 5.325)
rect(cv "Metal4" 0.125 5.155 0.375 5.245)
rect(cv "Metal3" 0.18 5.13 0.32 7.93)
port(cv "BL0" "Metal3" 0.25 7.86)
rect(cv "Metal4" 0.53 5.32 10.99 5.4)
rect(cv "Via3" 0.535 5.325 0.605 5.395)
rect(cv "Metal3" 0.525 5.235 0.615 5.485)
rect(cv "Metal4" 0.445 5.315 0.695 5.405)
rect(cv "Metal3" 0.5 5.29 0.64 7.93)
port(cv "BL1" "Metal3" 0.57 7.86)
rect(cv "Metal4" 0.85 5.48 16.34 5.56)
rect(cv "Via3" 0.855 5.485 0.925 5.555)
rect(cv "Metal3" 0.845 5.395 0.935 5.645)
rect(cv "Metal4" 0.765 5.475 1.015 5.565)
rect(cv "Metal3" 0.82 5.45 0.96 7.93)
port(cv "BL2" "Metal3" 0.89 7.86)
rect(cv "Metal4" 1.17 5.64 21.69 5.72)
rect(cv "Via3" 1.175 5.645 1.245 5.715)
rect(cv "Metal3" 1.165 5.555 1.255 5.805)
rect(cv "Metal4" 1.085 5.635 1.335 5.725)
rect(cv "Metal3" 1.14 5.61 1.28 7.93)
port(cv "BL3" "Metal3" 1.21 7.86)
rect(cv "Metal4" 1.49 5.8 27.04 5.88)
rect(cv "Via3" 1.495 5.805 1.565 5.875)
rect(cv "Metal3" 1.485 5.715 1.575 5.965)
rect(cv "Metal4" 1.405 5.795 1.655 5.885)
rect(cv "Metal3" 1.46 5.77 1.6 7.93)
port(cv "BL4" "Metal3" 1.53 7.86)
rect(cv "Metal4" 1.81 5.96 32.39 6.04)
rect(cv "Via3" 1.815 5.965 1.885 6.035)
rect(cv "Metal3" 1.805 5.875 1.895 6.125)
rect(cv "Metal4" 1.725 5.955 1.975 6.045)
rect(cv "Metal3" 1.78 5.93 1.92 7.93)
port(cv "BL5" "Metal3" 1.85 7.86)
rect(cv "Metal4" 2.13 6.12 5.96 6.2)
rect(cv "Via3" 2.135 6.125 2.205 6.195)
rect(cv "Metal3" 2.125 6.035 2.215 6.285)
rect(cv "Metal4" 2.045 6.115 2.295 6.205)
rect(cv "Metal3" 2.1 6.09 2.24 7.93)
port(cv "BLB0" "Metal3" 2.17 7.86)
rect(cv "Metal4" 2.45 6.28 11.31 6.36)
rect(cv "Via3" 2.455 6.285 2.525 6.355)
rect(cv "Metal3" 2.445 6.195 2.535 6.445)
rect(cv "Metal4" 2.365 6.275 2.615 6.365)
rect(cv "Metal3" 2.42 6.25 2.56 7.93)
port(cv "BLB1" "Metal3" 2.49 7.86)
rect(cv "Metal4" 2.77 6.44 16.66 6.52)
rect(cv "Via3" 2.775 6.445 2.845 6.515)
rect(cv "Metal3" 2.765 6.355 2.855 6.605)
rect(cv "Metal4" 2.685 6.435 2.935 6.525)
rect(cv "Metal3" 2.74 6.41 2.88 7.93)
port(cv "BLB2" "Metal3" 2.81 7.86)
rect(cv "Metal4" 3.09 6.6 22.01 6.68)
rect(cv "Via3" 3.095 6.605 3.165 6.675)
rect(cv "Metal3" 3.085 6.515 3.175 6.765)
rect(cv "Metal4" 3.005 6.595 3.255 6.685)
rect(cv "Metal3" 3.06 6.57 3.2 7.93)
port(cv "BLB3" "Metal3" 3.13 7.86)
rect(cv "Metal4" 3.41 6.76 27.36 6.84)
rect(cv "Via3" 3.415 6.765 3.485 6.835)
rect(cv "Metal3" 3.405 6.675 3.495 6.925)
rect(cv "Metal4" 3.325 6.755 3.575 6.845)
rect(cv "Metal3" 3.38 6.73 3.52 7.93)
port(cv "BLB4" "Metal3" 3.45 7.86)
rect(cv "Metal4" 3.73 6.92 32.71 7)
rect(cv "Via3" 3.735 6.925 3.805 6.995)
rect(cv "Metal3" 3.725 6.835 3.815 7.085)
rect(cv "Metal4" 3.645 6.915 3.895 7.005)
rect(cv "Metal3" 3.7 6.89 3.84 7.93)
port(cv "BLB5" "Metal3" 3.77 7.86)
rect(cv "Metal4" 4.05 7.08 33.03 7.16)
rect(cv "Via3" 4.055 7.085 4.125 7.155)
rect(cv "Metal3" 4.045 6.995 4.135 7.245)
rect(cv "Metal4" 3.965 7.075 4.215 7.165)
rect(cv "Metal3" 4.02 7.05 4.16 7.93)
port(cv "PCB" "Metal3" 4.09 7.86)
rect(cv "Metal4" 4.37 7.24 33.35 7.32)
rect(cv "Via3" 4.375 7.245 4.445 7.315)
rect(cv "Metal3" 4.365 7.155 4.455 7.405)
rect(cv "Metal4" 4.285 7.235 4.535 7.325)
rect(cv "Metal3" 4.34 7.21 4.48 7.93)
port(cv "VDD" "Metal3" 4.41 7.86)
rect(cv "Metal4" 4.69 7.4 33.67 7.48)
rect(cv "Via3" 4.695 7.405 4.765 7.475)
rect(cv "Metal3" 4.685 7.315 4.775 7.565)
rect(cv "Metal4" 4.605 7.395 4.855 7.485)
rect(cv "Metal3" 4.66 7.37 4.8 7.93)
port(cv "GND" "Metal3" 4.73 7.86)
rect(cv "prBoundary" 0.0 0.0 37.45 7.94)
dbSave(cv) printf("LAYOUT precharge %L\n" cv~>bBox) dbClose(cv)
cv=dbOpenCellViewByType("sram_project" "sram_4x6" "layout" "maskLayout" "w")
dbCreateInst(cv dbOpenCellViewByType("sram_project" "column_mux" "layout" "" "r") "MUX" list(4.8 0.35) "R0")
dbCreateInst(cv dbOpenCellViewByType("sram_project" "precharge" "layout" "" "r") "PRE" list(86.08 0.35) "R0")
dbCreateInst(cv dbOpenCellViewByType("sram_project" "sense_amp" "layout" "" "r") "SENSE" list(124.16 0.35) "R0")
dbCreateInst(cv dbOpenCellViewByType("sram_project" "rw_control" "layout" "" "r") "CTRL" list(11.84 11.52) "R0")
dbCreateInst(cv dbOpenCellViewByType("sram_project" "bit_array" "layout" "" "r") "MEM" list(90.88 11.52) "R0")
dbCreateInst(cv dbOpenCellViewByType("sram_project" "read_latch" "layout" "" "r") "LATCH" list(111.68 11.52) "R0")
dbCreateInst(cv dbOpenCellViewByType("sram_project" "column_decoder" "layout" "" "r") "COL" list(16.32 23.73) "R0")
dbCreateInst(cv dbOpenCellViewByType("sram_project" "row_decoder" "layout" "" "r") "ROW" list(75.84 23.73) "R0")
dbCreateInst(cv dbOpenCellViewByType("sram_project" "write_driver" "layout" "" "r") "WRITE" list(116.48 23.73) "R0")
rect(cv "Via3" 5.015 10.855 5.085 10.925)
rect(cv "Metal3" 5.005 10.765 5.095 11.015)
rect(cv "Metal4" 4.925 10.845 5.175 10.935)
rect(cv "Via4" 5.015 10.855 5.085 10.925)
rect(cv "Metal4" 4.925 10.845 5.175 10.935)
rect(cv "Metal5" 5.005 10.765 5.095 11.015)
rect(cv "Via5" 5.015 10.855 5.085 10.925)
rect(cv "Metal5" 5.005 10.765 5.095 11.015)
rect(cv "Metal6" 4.925 10.845 5.175 10.935)
rect(cv "Via6" 5.015 10.855 5.085 10.925)
rect(cv "Metal6" 4.925 10.845 5.175 10.935)
rect(cv "Metal7" 5.005 10.765 5.095 11.015)
rect(cv "Metal7" 5.01 10.85 5.09 38.39)
rect(cv "Via6" 5.015 38.315 5.085 38.385)
rect(cv "Metal6" 4.925 38.305 5.175 38.395)
rect(cv "Metal7" 5.005 38.225 5.095 38.475)
rect(cv "Via3" 5.335 10.855 5.405 10.925)
rect(cv "Metal3" 5.325 10.765 5.415 11.015)
rect(cv "Metal4" 5.245 10.845 5.495 10.935)
rect(cv "Via4" 5.335 10.855 5.405 10.925)
rect(cv "Metal4" 5.245 10.845 5.495 10.935)
rect(cv "Metal5" 5.325 10.765 5.415 11.015)
rect(cv "Via5" 5.335 10.855 5.405 10.925)
rect(cv "Metal5" 5.325 10.765 5.415 11.015)
rect(cv "Metal6" 5.245 10.845 5.495 10.935)
rect(cv "Via6" 5.335 10.855 5.405 10.925)
rect(cv "Metal6" 5.245 10.845 5.495 10.935)
rect(cv "Metal7" 5.325 10.765 5.415 11.015)
rect(cv "Metal7" 5.33 10.85 5.41 38.55)
rect(cv "Via6" 5.335 38.475 5.405 38.545)
rect(cv "Metal6" 5.245 38.465 5.495 38.555)
rect(cv "Metal7" 5.325 38.385 5.415 38.635)
rect(cv "Via3" 5.655 10.855 5.725 10.925)
rect(cv "Metal3" 5.645 10.765 5.735 11.015)
rect(cv "Metal4" 5.565 10.845 5.815 10.935)
rect(cv "Via4" 5.655 10.855 5.725 10.925)
rect(cv "Metal4" 5.565 10.845 5.815 10.935)
rect(cv "Metal5" 5.645 10.765 5.735 11.015)
rect(cv "Via5" 5.655 10.855 5.725 10.925)
rect(cv "Metal5" 5.645 10.765 5.735 11.015)
rect(cv "Metal6" 5.565 10.845 5.815 10.935)
rect(cv "Via6" 5.655 10.855 5.725 10.925)
rect(cv "Metal6" 5.565 10.845 5.815 10.935)
rect(cv "Metal7" 5.645 10.765 5.735 11.015)
rect(cv "Metal7" 5.65 10.85 5.73 38.71)
rect(cv "Via6" 5.655 38.635 5.725 38.705)
rect(cv "Metal6" 5.565 38.625 5.815 38.715)
rect(cv "Metal7" 5.645 38.545 5.735 38.795)
rect(cv "Via3" 5.975 10.855 6.045 10.925)
rect(cv "Metal3" 5.965 10.765 6.055 11.015)
rect(cv "Metal4" 5.885 10.845 6.135 10.935)
rect(cv "Via4" 5.975 10.855 6.045 10.925)
rect(cv "Metal4" 5.885 10.845 6.135 10.935)
rect(cv "Metal5" 5.965 10.765 6.055 11.015)
rect(cv "Via5" 5.975 10.855 6.045 10.925)
rect(cv "Metal5" 5.965 10.765 6.055 11.015)
rect(cv "Metal6" 5.885 10.845 6.135 10.935)
rect(cv "Via6" 5.975 10.855 6.045 10.925)
rect(cv "Metal6" 5.885 10.845 6.135 10.935)
rect(cv "Metal7" 5.965 10.765 6.055 11.015)
rect(cv "Metal7" 5.97 10.85 6.05 38.87)
rect(cv "Via6" 5.975 38.795 6.045 38.865)
rect(cv "Metal6" 5.885 38.785 6.135 38.875)
rect(cv "Metal7" 5.965 38.705 6.055 38.955)
rect(cv "Via3" 6.295 10.855 6.365 10.925)
rect(cv "Metal3" 6.285 10.765 6.375 11.015)
rect(cv "Metal4" 6.205 10.845 6.455 10.935)
rect(cv "Via4" 6.295 10.855 6.365 10.925)
rect(cv "Metal4" 6.205 10.845 6.455 10.935)
rect(cv "Metal5" 6.285 10.765 6.375 11.015)
rect(cv "Via5" 6.295 10.855 6.365 10.925)
rect(cv "Metal5" 6.285 10.765 6.375 11.015)
rect(cv "Metal6" 6.205 10.845 6.455 10.935)
rect(cv "Via6" 6.295 10.855 6.365 10.925)
rect(cv "Metal6" 6.205 10.845 6.455 10.935)
rect(cv "Metal7" 6.285 10.765 6.375 11.015)
rect(cv "Metal7" 6.29 10.85 6.37 39.03)
rect(cv "Via6" 6.295 38.955 6.365 39.025)
rect(cv "Metal6" 6.205 38.945 6.455 39.035)
rect(cv "Metal7" 6.285 38.865 6.375 39.115)
rect(cv "Via3" 6.615 10.855 6.685 10.925)
rect(cv "Metal3" 6.605 10.765 6.695 11.015)
rect(cv "Metal4" 6.525 10.845 6.775 10.935)
rect(cv "Via4" 6.615 10.855 6.685 10.925)
rect(cv "Metal4" 6.525 10.845 6.775 10.935)
rect(cv "Metal5" 6.605 10.765 6.695 11.015)
rect(cv "Via5" 6.615 10.855 6.685 10.925)
rect(cv "Metal5" 6.605 10.765 6.695 11.015)
rect(cv "Metal6" 6.525 10.845 6.775 10.935)
rect(cv "Via6" 6.615 10.855 6.685 10.925)
rect(cv "Metal6" 6.525 10.845 6.775 10.935)
rect(cv "Metal7" 6.605 10.765 6.695 11.015)
rect(cv "Metal7" 6.61 10.85 6.69 39.19)
rect(cv "Via6" 6.615 39.115 6.685 39.185)
rect(cv "Metal6" 6.525 39.105 6.775 39.195)
rect(cv "Metal7" 6.605 39.025 6.695 39.275)
rect(cv "Via3" 6.935 10.855 7.005 10.925)
rect(cv "Metal3" 6.925 10.765 7.015 11.015)
rect(cv "Metal4" 6.845 10.845 7.095 10.935)
rect(cv "Via4" 6.935 10.855 7.005 10.925)
rect(cv "Metal4" 6.845 10.845 7.095 10.935)
rect(cv "Metal5" 6.925 10.765 7.015 11.015)
rect(cv "Via5" 6.935 10.855 7.005 10.925)
rect(cv "Metal5" 6.925 10.765 7.015 11.015)
rect(cv "Metal6" 6.845 10.845 7.095 10.935)
rect(cv "Via6" 6.935 10.855 7.005 10.925)
rect(cv "Metal6" 6.845 10.845 7.095 10.935)
rect(cv "Metal7" 6.925 10.765 7.015 11.015)
rect(cv "Metal7" 6.93 10.85 7.01 39.35)
rect(cv "Via6" 6.935 39.275 7.005 39.345)
rect(cv "Metal6" 6.845 39.265 7.095 39.355)
rect(cv "Metal7" 6.925 39.185 7.015 39.435)
rect(cv "Via3" 7.255 10.855 7.325 10.925)
rect(cv "Metal3" 7.245 10.765 7.335 11.015)
rect(cv "Metal4" 7.165 10.845 7.415 10.935)
rect(cv "Via4" 7.255 10.855 7.325 10.925)
rect(cv "Metal4" 7.165 10.845 7.415 10.935)
rect(cv "Metal5" 7.245 10.765 7.335 11.015)
rect(cv "Via5" 7.255 10.855 7.325 10.925)
rect(cv "Metal5" 7.245 10.765 7.335 11.015)
rect(cv "Metal6" 7.165 10.845 7.415 10.935)
rect(cv "Via6" 7.255 10.855 7.325 10.925)
rect(cv "Metal6" 7.165 10.845 7.415 10.935)
rect(cv "Metal7" 7.245 10.765 7.335 11.015)
rect(cv "Metal7" 7.25 10.85 7.33 39.51)
rect(cv "Via6" 7.255 39.435 7.325 39.505)
rect(cv "Metal6" 7.165 39.425 7.415 39.515)
rect(cv "Metal7" 7.245 39.345 7.335 39.595)
rect(cv "Via3" 7.575 10.855 7.645 10.925)
rect(cv "Metal3" 7.565 10.765 7.655 11.015)
rect(cv "Metal4" 7.485 10.845 7.735 10.935)
rect(cv "Via4" 7.575 10.855 7.645 10.925)
rect(cv "Metal4" 7.485 10.845 7.735 10.935)
rect(cv "Metal5" 7.565 10.765 7.655 11.015)
rect(cv "Via5" 7.575 10.855 7.645 10.925)
rect(cv "Metal5" 7.565 10.765 7.655 11.015)
rect(cv "Metal6" 7.485 10.845 7.735 10.935)
rect(cv "Via6" 7.575 10.855 7.645 10.925)
rect(cv "Metal6" 7.485 10.845 7.735 10.935)
rect(cv "Metal7" 7.565 10.765 7.655 11.015)
rect(cv "Metal7" 7.57 10.85 7.65 39.67)
rect(cv "Via6" 7.575 39.595 7.645 39.665)
rect(cv "Metal6" 7.485 39.585 7.735 39.675)
rect(cv "Metal7" 7.565 39.505 7.655 39.755)
rect(cv "Via3" 7.895 10.855 7.965 10.925)
rect(cv "Metal3" 7.885 10.765 7.975 11.015)
rect(cv "Metal4" 7.805 10.845 8.055 10.935)
rect(cv "Via4" 7.895 10.855 7.965 10.925)
rect(cv "Metal4" 7.805 10.845 8.055 10.935)
rect(cv "Metal5" 7.885 10.765 7.975 11.015)
rect(cv "Via5" 7.895 10.855 7.965 10.925)
rect(cv "Metal5" 7.885 10.765 7.975 11.015)
rect(cv "Metal6" 7.805 10.845 8.055 10.935)
rect(cv "Via6" 7.895 10.855 7.965 10.925)
rect(cv "Metal6" 7.805 10.845 8.055 10.935)
rect(cv "Metal7" 7.885 10.765 7.975 11.015)
rect(cv "Metal7" 7.89 10.85 7.97 39.83)
rect(cv "Via6" 7.895 39.755 7.965 39.825)
rect(cv "Metal6" 7.805 39.745 8.055 39.835)
rect(cv "Metal7" 7.885 39.665 7.975 39.915)
rect(cv "Via3" 8.215 10.855 8.285 10.925)
rect(cv "Metal3" 8.205 10.765 8.295 11.015)
rect(cv "Metal4" 8.125 10.845 8.375 10.935)
rect(cv "Via4" 8.215 10.855 8.285 10.925)
rect(cv "Metal4" 8.125 10.845 8.375 10.935)
rect(cv "Metal5" 8.205 10.765 8.295 11.015)
rect(cv "Via5" 8.215 10.855 8.285 10.925)
rect(cv "Metal5" 8.205 10.765 8.295 11.015)
rect(cv "Metal6" 8.125 10.845 8.375 10.935)
rect(cv "Via6" 8.215 10.855 8.285 10.925)
rect(cv "Metal6" 8.125 10.845 8.375 10.935)
rect(cv "Metal7" 8.205 10.765 8.295 11.015)
rect(cv "Metal7" 8.21 10.85 8.29 39.99)
rect(cv "Via6" 8.215 39.915 8.285 39.985)
rect(cv "Metal6" 8.125 39.905 8.375 39.995)
rect(cv "Metal7" 8.205 39.825 8.295 40.075)
rect(cv "Via3" 8.535 10.855 8.605 10.925)
rect(cv "Metal3" 8.525 10.765 8.615 11.015)
rect(cv "Metal4" 8.445 10.845 8.695 10.935)
rect(cv "Via4" 8.535 10.855 8.605 10.925)
rect(cv "Metal4" 8.445 10.845 8.695 10.935)
rect(cv "Metal5" 8.525 10.765 8.615 11.015)
rect(cv "Via5" 8.535 10.855 8.605 10.925)
rect(cv "Metal5" 8.525 10.765 8.615 11.015)
rect(cv "Metal6" 8.445 10.845 8.695 10.935)
rect(cv "Via6" 8.535 10.855 8.605 10.925)
rect(cv "Metal6" 8.445 10.845 8.695 10.935)
rect(cv "Metal7" 8.525 10.765 8.615 11.015)
rect(cv "Metal7" 8.53 10.85 8.61 40.15)
rect(cv "Via6" 8.535 40.075 8.605 40.145)
rect(cv "Metal6" 8.445 40.065 8.695 40.155)
rect(cv "Metal7" 8.525 39.985 8.615 40.235)
rect(cv "Via3" 8.855 10.855 8.925 10.925)
rect(cv "Metal3" 8.845 10.765 8.935 11.015)
rect(cv "Metal4" 8.765 10.845 9.015 10.935)
rect(cv "Via4" 8.855 10.855 8.925 10.925)
rect(cv "Metal4" 8.765 10.845 9.015 10.935)
rect(cv "Metal5" 8.845 10.765 8.935 11.015)
rect(cv "Via5" 8.855 10.855 8.925 10.925)
rect(cv "Metal5" 8.845 10.765 8.935 11.015)
rect(cv "Metal6" 8.765 10.845 9.015 10.935)
rect(cv "Via6" 8.855 10.855 8.925 10.925)
rect(cv "Metal6" 8.765 10.845 9.015 10.935)
rect(cv "Metal7" 8.845 10.765 8.935 11.015)
rect(cv "Metal7" 8.85 10.85 8.93 40.31)
rect(cv "Via6" 8.855 40.235 8.925 40.305)
rect(cv "Metal6" 8.765 40.225 9.015 40.315)
rect(cv "Metal7" 8.845 40.145 8.935 40.395)
rect(cv "Via3" 9.175 10.855 9.245 10.925)
rect(cv "Metal3" 9.165 10.765 9.255 11.015)
rect(cv "Metal4" 9.085 10.845 9.335 10.935)
rect(cv "Via4" 9.175 10.855 9.245 10.925)
rect(cv "Metal4" 9.085 10.845 9.335 10.935)
rect(cv "Metal5" 9.165 10.765 9.255 11.015)
rect(cv "Via5" 9.175 10.855 9.245 10.925)
rect(cv "Metal5" 9.165 10.765 9.255 11.015)
rect(cv "Metal6" 9.085 10.845 9.335 10.935)
rect(cv "Via6" 9.175 10.855 9.245 10.925)
rect(cv "Metal6" 9.085 10.845 9.335 10.935)
rect(cv "Metal7" 9.165 10.765 9.255 11.015)
rect(cv "Metal7" 9.17 10.85 9.25 40.47)
rect(cv "Via6" 9.175 40.395 9.245 40.465)
rect(cv "Metal6" 9.085 40.385 9.335 40.475)
rect(cv "Metal7" 9.165 40.305 9.255 40.555)
rect(cv "Via3" 9.495 10.855 9.565 10.925)
rect(cv "Metal3" 9.485 10.765 9.575 11.015)
rect(cv "Metal4" 9.405 10.845 9.655 10.935)
rect(cv "Via4" 9.495 10.855 9.565 10.925)
rect(cv "Metal4" 9.405 10.845 9.655 10.935)
rect(cv "Metal5" 9.485 10.765 9.575 11.015)
rect(cv "Via5" 9.495 10.855 9.565 10.925)
rect(cv "Metal5" 9.485 10.765 9.575 11.015)
rect(cv "Metal6" 9.405 10.845 9.655 10.935)
rect(cv "Via6" 9.495 10.855 9.565 10.925)
rect(cv "Metal6" 9.405 10.845 9.655 10.935)
rect(cv "Metal7" 9.485 10.765 9.575 11.015)
rect(cv "Metal7" 9.49 10.85 9.57 40.63)
rect(cv "Via6" 9.495 40.555 9.565 40.625)
rect(cv "Metal6" 9.405 40.545 9.655 40.635)
rect(cv "Metal7" 9.485 40.465 9.575 40.715)
rect(cv "Via3" 9.815 10.855 9.885 10.925)
rect(cv "Metal3" 9.805 10.765 9.895 11.015)
rect(cv "Metal4" 9.725 10.845 9.975 10.935)
rect(cv "Via4" 9.815 10.855 9.885 10.925)
rect(cv "Metal4" 9.725 10.845 9.975 10.935)
rect(cv "Metal5" 9.805 10.765 9.895 11.015)
rect(cv "Via5" 9.815 10.855 9.885 10.925)
rect(cv "Metal5" 9.805 10.765 9.895 11.015)
rect(cv "Metal6" 9.725 10.845 9.975 10.935)
rect(cv "Via6" 9.815 10.855 9.885 10.925)
rect(cv "Metal6" 9.725 10.845 9.975 10.935)
rect(cv "Metal7" 9.805 10.765 9.895 11.015)
rect(cv "Metal7" 9.81 10.85 9.89 40.79)
rect(cv "Via6" 9.815 40.715 9.885 40.785)
rect(cv "Metal6" 9.725 40.705 9.975 40.795)
rect(cv "Metal7" 9.805 40.625 9.895 40.875)
rect(cv "Via3" 10.135 10.855 10.205 10.925)
rect(cv "Metal3" 10.125 10.765 10.215 11.015)
rect(cv "Metal4" 10.045 10.845 10.295 10.935)
rect(cv "Via4" 10.135 10.855 10.205 10.925)
rect(cv "Metal4" 10.045 10.845 10.295 10.935)
rect(cv "Metal5" 10.125 10.765 10.215 11.015)
rect(cv "Via5" 10.135 10.855 10.205 10.925)
rect(cv "Metal5" 10.125 10.765 10.215 11.015)
rect(cv "Metal6" 10.045 10.845 10.295 10.935)
rect(cv "Via6" 10.135 10.855 10.205 10.925)
rect(cv "Metal6" 10.045 10.845 10.295 10.935)
rect(cv "Metal7" 10.125 10.765 10.215 11.015)
rect(cv "Metal7" 10.13 10.85 10.21 40.95)
rect(cv "Via6" 10.135 40.875 10.205 40.945)
rect(cv "Metal6" 10.045 40.865 10.295 40.955)
rect(cv "Metal7" 10.125 40.785 10.215 41.035)
rect(cv "Via3" 10.455 10.855 10.525 10.925)
rect(cv "Metal3" 10.445 10.765 10.535 11.015)
rect(cv "Metal4" 10.365 10.845 10.615 10.935)
rect(cv "Via4" 10.455 10.855 10.525 10.925)
rect(cv "Metal4" 10.365 10.845 10.615 10.935)
rect(cv "Metal5" 10.445 10.765 10.535 11.015)
rect(cv "Via5" 10.455 10.855 10.525 10.925)
rect(cv "Metal5" 10.445 10.765 10.535 11.015)
rect(cv "Metal6" 10.365 10.845 10.615 10.935)
rect(cv "Via6" 10.455 10.855 10.525 10.925)
rect(cv "Metal6" 10.365 10.845 10.615 10.935)
rect(cv "Metal7" 10.445 10.765 10.535 11.015)
rect(cv "Metal7" 10.45 10.85 10.53 41.11)
rect(cv "Via6" 10.455 41.035 10.525 41.105)
rect(cv "Metal6" 10.365 41.025 10.615 41.115)
rect(cv "Metal7" 10.445 40.945 10.535 41.195)
rect(cv "Via3" 10.775 10.855 10.845 10.925)
rect(cv "Metal3" 10.765 10.765 10.855 11.015)
rect(cv "Metal4" 10.685 10.845 10.935 10.935)
rect(cv "Via4" 10.775 10.855 10.845 10.925)
rect(cv "Metal4" 10.685 10.845 10.935 10.935)
rect(cv "Metal5" 10.765 10.765 10.855 11.015)
rect(cv "Via5" 10.775 10.855 10.845 10.925)
rect(cv "Metal5" 10.765 10.765 10.855 11.015)
rect(cv "Metal6" 10.685 10.845 10.935 10.935)
rect(cv "Via6" 10.775 10.855 10.845 10.925)
rect(cv "Metal6" 10.685 10.845 10.935 10.935)
rect(cv "Metal7" 10.765 10.765 10.855 11.015)
rect(cv "Metal7" 10.77 10.85 10.85 41.27)
rect(cv "Via6" 10.775 41.195 10.845 41.265)
rect(cv "Metal6" 10.685 41.185 10.935 41.275)
rect(cv "Metal7" 10.765 41.105 10.855 41.355)
rect(cv "Via3" 11.095 10.855 11.165 10.925)
rect(cv "Metal3" 11.085 10.765 11.175 11.015)
rect(cv "Metal4" 11.005 10.845 11.255 10.935)
rect(cv "Via4" 11.095 10.855 11.165 10.925)
rect(cv "Metal4" 11.005 10.845 11.255 10.935)
rect(cv "Metal5" 11.085 10.765 11.175 11.015)
rect(cv "Via5" 11.095 10.855 11.165 10.925)
rect(cv "Metal5" 11.085 10.765 11.175 11.015)
rect(cv "Metal6" 11.005 10.845 11.255 10.935)
rect(cv "Via6" 11.095 10.855 11.165 10.925)
rect(cv "Metal6" 11.005 10.845 11.255 10.935)
rect(cv "Metal7" 11.085 10.765 11.175 11.015)
rect(cv "Metal7" 11.09 10.85 11.17 41.43)
rect(cv "Via6" 11.095 41.355 11.165 41.425)
rect(cv "Metal6" 11.005 41.345 11.255 41.435)
rect(cv "Metal7" 11.085 41.265 11.175 41.515)
rect(cv "Via3" 11.415 10.855 11.485 10.925)
rect(cv "Metal3" 11.405 10.765 11.495 11.015)
rect(cv "Metal4" 11.325 10.845 11.575 10.935)
rect(cv "Via4" 11.415 10.855 11.485 10.925)
rect(cv "Metal4" 11.325 10.845 11.575 10.935)
rect(cv "Metal5" 11.405 10.765 11.495 11.015)
rect(cv "Via5" 11.415 10.855 11.485 10.925)
rect(cv "Metal5" 11.405 10.765 11.495 11.015)
rect(cv "Metal6" 11.325 10.845 11.575 10.935)
rect(cv "Via6" 11.415 10.855 11.485 10.925)
rect(cv "Metal6" 11.325 10.845 11.575 10.935)
rect(cv "Metal7" 11.405 10.765 11.495 11.015)
rect(cv "Metal7" 11.41 10.85 11.49 36.47)
rect(cv "Via6" 11.415 36.395 11.485 36.465)
rect(cv "Metal6" 11.325 36.385 11.575 36.475)
rect(cv "Metal7" 11.405 36.305 11.495 36.555)
rect(cv "Via3" 11.735 10.855 11.805 10.925)
rect(cv "Metal3" 11.725 10.765 11.815 11.015)
rect(cv "Metal4" 11.645 10.845 11.895 10.935)
rect(cv "Via4" 11.735 10.855 11.805 10.925)
rect(cv "Metal4" 11.645 10.845 11.895 10.935)
rect(cv "Metal5" 11.725 10.765 11.815 11.015)
rect(cv "Via5" 11.735 10.855 11.805 10.925)
rect(cv "Metal5" 11.725 10.765 11.815 11.015)
rect(cv "Metal6" 11.645 10.845 11.895 10.935)
rect(cv "Via6" 11.735 10.855 11.805 10.925)
rect(cv "Metal6" 11.645 10.845 11.895 10.935)
rect(cv "Metal7" 11.725 10.765 11.815 11.015)
rect(cv "Metal7" 11.73 10.85 11.81 36.63)
rect(cv "Via6" 11.735 36.555 11.805 36.625)
rect(cv "Metal6" 11.645 36.545 11.895 36.635)
rect(cv "Metal7" 11.725 36.465 11.815 36.715)
rect(cv "Via3" 86.295 8.175 86.365 8.245)
rect(cv "Metal3" 86.285 8.085 86.375 8.335)
rect(cv "Metal4" 86.205 8.165 86.455 8.255)
rect(cv "Via4" 86.295 8.175 86.365 8.245)
rect(cv "Metal4" 86.205 8.165 86.455 8.255)
rect(cv "Metal5" 86.285 8.085 86.375 8.335)
rect(cv "Via5" 86.295 8.175 86.365 8.245)
rect(cv "Metal5" 86.285 8.085 86.375 8.335)
rect(cv "Metal6" 86.205 8.165 86.455 8.255)
rect(cv "Via6" 86.295 8.175 86.365 8.245)
rect(cv "Metal6" 86.205 8.165 86.455 8.255)
rect(cv "Metal7" 86.285 8.085 86.375 8.335)
rect(cv "Metal7" 86.29 8.17 86.37 39.35)
rect(cv "Via6" 86.295 39.275 86.365 39.345)
rect(cv "Metal6" 86.205 39.265 86.455 39.355)
rect(cv "Metal7" 86.285 39.185 86.375 39.435)
rect(cv "Via3" 86.615 8.175 86.685 8.245)
rect(cv "Metal3" 86.605 8.085 86.695 8.335)
rect(cv "Metal4" 86.525 8.165 86.775 8.255)
rect(cv "Via4" 86.615 8.175 86.685 8.245)
rect(cv "Metal4" 86.525 8.165 86.775 8.255)
rect(cv "Metal5" 86.605 8.085 86.695 8.335)
rect(cv "Via5" 86.615 8.175 86.685 8.245)
rect(cv "Metal5" 86.605 8.085 86.695 8.335)
rect(cv "Metal6" 86.525 8.165 86.775 8.255)
rect(cv "Via6" 86.615 8.175 86.685 8.245)
rect(cv "Metal6" 86.525 8.165 86.775 8.255)
rect(cv "Metal7" 86.605 8.085 86.695 8.335)
rect(cv "Metal7" 86.61 8.17 86.69 39.51)
rect(cv "Via6" 86.615 39.435 86.685 39.505)
rect(cv "Metal6" 86.525 39.425 86.775 39.515)
rect(cv "Metal7" 86.605 39.345 86.695 39.595)
rect(cv "Via3" 86.935 8.175 87.005 8.245)
rect(cv "Metal3" 86.925 8.085 87.015 8.335)
rect(cv "Metal4" 86.845 8.165 87.095 8.255)
rect(cv "Via4" 86.935 8.175 87.005 8.245)
rect(cv "Metal4" 86.845 8.165 87.095 8.255)
rect(cv "Metal5" 86.925 8.085 87.015 8.335)
rect(cv "Via5" 86.935 8.175 87.005 8.245)
rect(cv "Metal5" 86.925 8.085 87.015 8.335)
rect(cv "Metal6" 86.845 8.165 87.095 8.255)
rect(cv "Via6" 86.935 8.175 87.005 8.245)
rect(cv "Metal6" 86.845 8.165 87.095 8.255)
rect(cv "Metal7" 86.925 8.085 87.015 8.335)
rect(cv "Metal7" 86.93 8.17 87.01 39.67)
rect(cv "Via6" 86.935 39.595 87.005 39.665)
rect(cv "Metal6" 86.845 39.585 87.095 39.675)
rect(cv "Metal7" 86.925 39.505 87.015 39.755)
rect(cv "Via3" 87.255 8.175 87.325 8.245)
rect(cv "Metal3" 87.245 8.085 87.335 8.335)
rect(cv "Metal4" 87.165 8.165 87.415 8.255)
rect(cv "Via4" 87.255 8.175 87.325 8.245)
rect(cv "Metal4" 87.165 8.165 87.415 8.255)
rect(cv "Metal5" 87.245 8.085 87.335 8.335)
rect(cv "Via5" 87.255 8.175 87.325 8.245)
rect(cv "Metal5" 87.245 8.085 87.335 8.335)
rect(cv "Metal6" 87.165 8.165 87.415 8.255)
rect(cv "Via6" 87.255 8.175 87.325 8.245)
rect(cv "Metal6" 87.165 8.165 87.415 8.255)
rect(cv "Metal7" 87.245 8.085 87.335 8.335)
rect(cv "Metal7" 87.25 8.17 87.33 39.83)
rect(cv "Via6" 87.255 39.755 87.325 39.825)
rect(cv "Metal6" 87.165 39.745 87.415 39.835)
rect(cv "Metal7" 87.245 39.665 87.335 39.915)
rect(cv "Via3" 87.575 8.175 87.645 8.245)
rect(cv "Metal3" 87.565 8.085 87.655 8.335)
rect(cv "Metal4" 87.485 8.165 87.735 8.255)
rect(cv "Via4" 87.575 8.175 87.645 8.245)
rect(cv "Metal4" 87.485 8.165 87.735 8.255)
rect(cv "Metal5" 87.565 8.085 87.655 8.335)
rect(cv "Via5" 87.575 8.175 87.645 8.245)
rect(cv "Metal5" 87.565 8.085 87.655 8.335)
rect(cv "Metal6" 87.485 8.165 87.735 8.255)
rect(cv "Via6" 87.575 8.175 87.645 8.245)
rect(cv "Metal6" 87.485 8.165 87.735 8.255)
rect(cv "Metal7" 87.565 8.085 87.655 8.335)
rect(cv "Metal7" 87.57 8.17 87.65 39.99)
rect(cv "Via6" 87.575 39.915 87.645 39.985)
rect(cv "Metal6" 87.485 39.905 87.735 39.995)
rect(cv "Metal7" 87.565 39.825 87.655 40.075)
rect(cv "Via3" 87.895 8.175 87.965 8.245)
rect(cv "Metal3" 87.885 8.085 87.975 8.335)
rect(cv "Metal4" 87.805 8.165 88.055 8.255)
rect(cv "Via4" 87.895 8.175 87.965 8.245)
rect(cv "Metal4" 87.805 8.165 88.055 8.255)
rect(cv "Metal5" 87.885 8.085 87.975 8.335)
rect(cv "Via5" 87.895 8.175 87.965 8.245)
rect(cv "Metal5" 87.885 8.085 87.975 8.335)
rect(cv "Metal6" 87.805 8.165 88.055 8.255)
rect(cv "Via6" 87.895 8.175 87.965 8.245)
rect(cv "Metal6" 87.805 8.165 88.055 8.255)
rect(cv "Metal7" 87.885 8.085 87.975 8.335)
rect(cv "Metal7" 87.89 8.17 87.97 40.15)
rect(cv "Via6" 87.895 40.075 87.965 40.145)
rect(cv "Metal6" 87.805 40.065 88.055 40.155)
rect(cv "Metal7" 87.885 39.985 87.975 40.235)
rect(cv "Via3" 88.215 8.175 88.285 8.245)
rect(cv "Metal3" 88.205 8.085 88.295 8.335)
rect(cv "Metal4" 88.125 8.165 88.375 8.255)
rect(cv "Via4" 88.215 8.175 88.285 8.245)
rect(cv "Metal4" 88.125 8.165 88.375 8.255)
rect(cv "Metal5" 88.205 8.085 88.295 8.335)
rect(cv "Via5" 88.215 8.175 88.285 8.245)
rect(cv "Metal5" 88.205 8.085 88.295 8.335)
rect(cv "Metal6" 88.125 8.165 88.375 8.255)
rect(cv "Via6" 88.215 8.175 88.285 8.245)
rect(cv "Metal6" 88.125 8.165 88.375 8.255)
rect(cv "Metal7" 88.205 8.085 88.295 8.335)
rect(cv "Metal7" 88.21 8.17 88.29 40.31)
rect(cv "Via6" 88.215 40.235 88.285 40.305)
rect(cv "Metal6" 88.125 40.225 88.375 40.315)
rect(cv "Metal7" 88.205 40.145 88.295 40.395)
rect(cv "Via3" 88.535 8.175 88.605 8.245)
rect(cv "Metal3" 88.525 8.085 88.615 8.335)
rect(cv "Metal4" 88.445 8.165 88.695 8.255)
rect(cv "Via4" 88.535 8.175 88.605 8.245)
rect(cv "Metal4" 88.445 8.165 88.695 8.255)
rect(cv "Metal5" 88.525 8.085 88.615 8.335)
rect(cv "Via5" 88.535 8.175 88.605 8.245)
rect(cv "Metal5" 88.525 8.085 88.615 8.335)
rect(cv "Metal6" 88.445 8.165 88.695 8.255)
rect(cv "Via6" 88.535 8.175 88.605 8.245)
rect(cv "Metal6" 88.445 8.165 88.695 8.255)
rect(cv "Metal7" 88.525 8.085 88.615 8.335)
rect(cv "Metal7" 88.53 8.17 88.61 40.47)
rect(cv "Via6" 88.535 40.395 88.605 40.465)
rect(cv "Metal6" 88.445 40.385 88.695 40.475)
rect(cv "Metal7" 88.525 40.305 88.615 40.555)
rect(cv "Via3" 88.855 8.175 88.925 8.245)
rect(cv "Metal3" 88.845 8.085 88.935 8.335)
rect(cv "Metal4" 88.765 8.165 89.015 8.255)
rect(cv "Via4" 88.855 8.175 88.925 8.245)
rect(cv "Metal4" 88.765 8.165 89.015 8.255)
rect(cv "Metal5" 88.845 8.085 88.935 8.335)
rect(cv "Via5" 88.855 8.175 88.925 8.245)
rect(cv "Metal5" 88.845 8.085 88.935 8.335)
rect(cv "Metal6" 88.765 8.165 89.015 8.255)
rect(cv "Via6" 88.855 8.175 88.925 8.245)
rect(cv "Metal6" 88.765 8.165 89.015 8.255)
rect(cv "Metal7" 88.845 8.085 88.935 8.335)
rect(cv "Metal7" 88.85 8.17 88.93 40.63)
rect(cv "Via6" 88.855 40.555 88.925 40.625)
rect(cv "Metal6" 88.765 40.545 89.015 40.635)
rect(cv "Metal7" 88.845 40.465 88.935 40.715)
rect(cv "Via3" 89.175 8.175 89.245 8.245)
rect(cv "Metal3" 89.165 8.085 89.255 8.335)
rect(cv "Metal4" 89.085 8.165 89.335 8.255)
rect(cv "Via4" 89.175 8.175 89.245 8.245)
rect(cv "Metal4" 89.085 8.165 89.335 8.255)
rect(cv "Metal5" 89.165 8.085 89.255 8.335)
rect(cv "Via5" 89.175 8.175 89.245 8.245)
rect(cv "Metal5" 89.165 8.085 89.255 8.335)
rect(cv "Metal6" 89.085 8.165 89.335 8.255)
rect(cv "Via6" 89.175 8.175 89.245 8.245)
rect(cv "Metal6" 89.085 8.165 89.335 8.255)
rect(cv "Metal7" 89.165 8.085 89.255 8.335)
rect(cv "Metal7" 89.17 8.17 89.25 40.79)
rect(cv "Via6" 89.175 40.715 89.245 40.785)
rect(cv "Metal6" 89.085 40.705 89.335 40.795)
rect(cv "Metal7" 89.165 40.625 89.255 40.875)
rect(cv "Via3" 89.495 8.175 89.565 8.245)
rect(cv "Metal3" 89.485 8.085 89.575 8.335)
rect(cv "Metal4" 89.405 8.165 89.655 8.255)
rect(cv "Via4" 89.495 8.175 89.565 8.245)
rect(cv "Metal4" 89.405 8.165 89.655 8.255)
rect(cv "Metal5" 89.485 8.085 89.575 8.335)
rect(cv "Via5" 89.495 8.175 89.565 8.245)
rect(cv "Metal5" 89.485 8.085 89.575 8.335)
rect(cv "Metal6" 89.405 8.165 89.655 8.255)
rect(cv "Via6" 89.495 8.175 89.565 8.245)
rect(cv "Metal6" 89.405 8.165 89.655 8.255)
rect(cv "Metal7" 89.485 8.085 89.575 8.335)
rect(cv "Metal7" 89.49 8.17 89.57 40.95)
rect(cv "Via6" 89.495 40.875 89.565 40.945)
rect(cv "Metal6" 89.405 40.865 89.655 40.955)
rect(cv "Metal7" 89.485 40.785 89.575 41.035)
rect(cv "Via3" 89.815 8.175 89.885 8.245)
rect(cv "Metal3" 89.805 8.085 89.895 8.335)
rect(cv "Metal4" 89.725 8.165 89.975 8.255)
rect(cv "Via4" 89.815 8.175 89.885 8.245)
rect(cv "Metal4" 89.725 8.165 89.975 8.255)
rect(cv "Metal5" 89.805 8.085 89.895 8.335)
rect(cv "Via5" 89.815 8.175 89.885 8.245)
rect(cv "Metal5" 89.805 8.085 89.895 8.335)
rect(cv "Metal6" 89.725 8.165 89.975 8.255)
rect(cv "Via6" 89.815 8.175 89.885 8.245)
rect(cv "Metal6" 89.725 8.165 89.975 8.255)
rect(cv "Metal7" 89.805 8.085 89.895 8.335)
rect(cv "Metal7" 89.81 8.17 89.89 41.11)
rect(cv "Via6" 89.815 41.035 89.885 41.105)
rect(cv "Metal6" 89.725 41.025 89.975 41.115)
rect(cv "Metal7" 89.805 40.945 89.895 41.195)
rect(cv "Via3" 90.135 8.175 90.205 8.245)
rect(cv "Metal3" 90.125 8.085 90.215 8.335)
rect(cv "Metal4" 90.045 8.165 90.295 8.255)
rect(cv "Via4" 90.135 8.175 90.205 8.245)
rect(cv "Metal4" 90.045 8.165 90.295 8.255)
rect(cv "Metal5" 90.125 8.085 90.215 8.335)
rect(cv "Via5" 90.135 8.175 90.205 8.245)
rect(cv "Metal5" 90.125 8.085 90.215 8.335)
rect(cv "Metal6" 90.045 8.165 90.295 8.255)
rect(cv "Via6" 90.135 8.175 90.205 8.245)
rect(cv "Metal6" 90.045 8.165 90.295 8.255)
rect(cv "Metal7" 90.125 8.085 90.215 8.335)
rect(cv "Metal7" 90.13 8.17 90.21 37.59)
rect(cv "Via6" 90.135 37.515 90.205 37.585)
rect(cv "Metal6" 90.045 37.505 90.295 37.595)
rect(cv "Metal7" 90.125 37.425 90.215 37.675)
rect(cv "Via3" 90.455 8.175 90.525 8.245)
rect(cv "Metal3" 90.445 8.085 90.535 8.335)
rect(cv "Metal4" 90.365 8.165 90.615 8.255)
rect(cv "Via4" 90.455 8.175 90.525 8.245)
rect(cv "Metal4" 90.365 8.165 90.615 8.255)
rect(cv "Metal5" 90.445 8.085 90.535 8.335)
rect(cv "Via5" 90.455 8.175 90.525 8.245)
rect(cv "Metal5" 90.445 8.085 90.535 8.335)
rect(cv "Metal6" 90.365 8.165 90.615 8.255)
rect(cv "Via6" 90.455 8.175 90.525 8.245)
rect(cv "Metal6" 90.365 8.165 90.615 8.255)
rect(cv "Metal7" 90.445 8.085 90.535 8.335)
rect(cv "Metal7" 90.45 8.17 90.53 36.47)
rect(cv "Via6" 90.455 36.395 90.525 36.465)
rect(cv "Metal6" 90.365 36.385 90.615 36.475)
rect(cv "Metal7" 90.445 36.305 90.535 36.555)
rect(cv "Via3" 90.775 8.175 90.845 8.245)
rect(cv "Metal3" 90.765 8.085 90.855 8.335)
rect(cv "Metal4" 90.685 8.165 90.935 8.255)
rect(cv "Via4" 90.775 8.175 90.845 8.245)
rect(cv "Metal4" 90.685 8.165 90.935 8.255)
rect(cv "Metal5" 90.765 8.085 90.855 8.335)
rect(cv "Via5" 90.775 8.175 90.845 8.245)
rect(cv "Metal5" 90.765 8.085 90.855 8.335)
rect(cv "Metal6" 90.685 8.165 90.935 8.255)
rect(cv "Via6" 90.775 8.175 90.845 8.245)
rect(cv "Metal6" 90.685 8.165 90.935 8.255)
rect(cv "Metal7" 90.765 8.085 90.855 8.335)
rect(cv "Metal7" 90.77 8.17 90.85 36.63)
rect(cv "Via6" 90.775 36.555 90.845 36.625)
rect(cv "Metal6" 90.685 36.545 90.935 36.635)
rect(cv "Metal7" 90.765 36.465 90.855 36.715)
rect(cv "Via3" 124.375 7.325 124.445 7.395)
rect(cv "Metal3" 124.365 7.235 124.455 7.485)
rect(cv "Metal4" 124.285 7.315 124.535 7.405)
rect(cv "Via4" 124.375 7.325 124.445 7.395)
rect(cv "Metal4" 124.285 7.315 124.535 7.405)
rect(cv "Metal5" 124.365 7.235 124.455 7.485)
rect(cv "Via5" 124.375 7.325 124.445 7.395)
rect(cv "Metal5" 124.365 7.235 124.455 7.485)
rect(cv "Metal6" 124.285 7.315 124.535 7.405)
rect(cv "Via6" 124.375 7.325 124.445 7.395)
rect(cv "Metal6" 124.285 7.315 124.535 7.405)
rect(cv "Metal7" 124.365 7.235 124.455 7.485)
rect(cv "Metal7" 124.37 7.32 124.45 41.27)
rect(cv "Via6" 124.375 41.195 124.445 41.265)
rect(cv "Metal6" 124.285 41.185 124.535 41.275)
rect(cv "Metal7" 124.365 41.105 124.455 41.355)
rect(cv "Via3" 124.695 7.325 124.765 7.395)
rect(cv "Metal3" 124.685 7.235 124.775 7.485)
rect(cv "Metal4" 124.605 7.315 124.855 7.405)
rect(cv "Via4" 124.695 7.325 124.765 7.395)
rect(cv "Metal4" 124.605 7.315 124.855 7.405)
rect(cv "Metal5" 124.685 7.235 124.775 7.485)
rect(cv "Via5" 124.695 7.325 124.765 7.395)
rect(cv "Metal5" 124.685 7.235 124.775 7.485)
rect(cv "Metal6" 124.605 7.315 124.855 7.405)
rect(cv "Via6" 124.695 7.325 124.765 7.395)
rect(cv "Metal6" 124.605 7.315 124.855 7.405)
rect(cv "Metal7" 124.685 7.235 124.775 7.485)
rect(cv "Metal7" 124.69 7.32 124.77 41.43)
rect(cv "Via6" 124.695 41.355 124.765 41.425)
rect(cv "Metal6" 124.605 41.345 124.855 41.435)
rect(cv "Metal7" 124.685 41.265 124.775 41.515)
rect(cv "Via3" 125.015 7.325 125.085 7.395)
rect(cv "Metal3" 125.005 7.235 125.095 7.485)
rect(cv "Metal4" 124.925 7.315 125.175 7.405)
rect(cv "Via4" 125.015 7.325 125.085 7.395)
rect(cv "Metal4" 124.925 7.315 125.175 7.405)
rect(cv "Metal5" 125.005 7.235 125.095 7.485)
rect(cv "Via5" 125.015 7.325 125.085 7.395)
rect(cv "Metal5" 125.005 7.235 125.095 7.485)
rect(cv "Metal6" 124.925 7.315 125.175 7.405)
rect(cv "Via6" 125.015 7.325 125.085 7.395)
rect(cv "Metal6" 124.925 7.315 125.175 7.405)
rect(cv "Metal7" 125.005 7.235 125.095 7.485)
rect(cv "Metal7" 125.01 7.32 125.09 37.11)
rect(cv "Via6" 125.015 37.035 125.085 37.105)
rect(cv "Metal6" 124.925 37.025 125.175 37.115)
rect(cv "Metal7" 125.005 36.945 125.095 37.195)
rect(cv "Via3" 125.335 7.325 125.405 7.395)
rect(cv "Metal3" 125.325 7.235 125.415 7.485)
rect(cv "Metal4" 125.245 7.315 125.495 7.405)
rect(cv "Via4" 125.335 7.325 125.405 7.395)
rect(cv "Metal4" 125.245 7.315 125.495 7.405)
rect(cv "Metal5" 125.325 7.235 125.415 7.485)
rect(cv "Via5" 125.335 7.325 125.405 7.395)
rect(cv "Metal5" 125.325 7.235 125.415 7.485)
rect(cv "Metal6" 125.245 7.315 125.495 7.405)
rect(cv "Via6" 125.335 7.325 125.405 7.395)
rect(cv "Metal6" 125.245 7.315 125.495 7.405)
rect(cv "Metal7" 125.325 7.235 125.415 7.485)
rect(cv "Metal7" 125.33 7.32 125.41 36.47)
rect(cv "Via6" 125.335 36.395 125.405 36.465)
rect(cv "Metal6" 125.245 36.385 125.495 36.475)
rect(cv "Metal7" 125.325 36.305 125.415 36.555)
rect(cv "Via3" 125.655 7.325 125.725 7.395)
rect(cv "Metal3" 125.645 7.235 125.735 7.485)
rect(cv "Metal4" 125.565 7.315 125.815 7.405)
rect(cv "Via4" 125.655 7.325 125.725 7.395)
rect(cv "Metal4" 125.565 7.315 125.815 7.405)
rect(cv "Metal5" 125.645 7.235 125.735 7.485)
rect(cv "Via5" 125.655 7.325 125.725 7.395)
rect(cv "Metal5" 125.645 7.235 125.735 7.485)
rect(cv "Metal6" 125.565 7.315 125.815 7.405)
rect(cv "Via6" 125.655 7.325 125.725 7.395)
rect(cv "Metal6" 125.565 7.315 125.815 7.405)
rect(cv "Metal7" 125.645 7.235 125.735 7.485)
rect(cv "Metal7" 125.65 7.32 125.73 36.63)
rect(cv "Via6" 125.655 36.555 125.725 36.625)
rect(cv "Metal6" 125.565 36.545 125.815 36.635)
rect(cv "Metal7" 125.645 36.465 125.735 36.715)
rect(cv "Via3" 125.975 7.325 126.045 7.395)
rect(cv "Metal3" 125.965 7.235 126.055 7.485)
rect(cv "Metal4" 125.885 7.315 126.135 7.405)
rect(cv "Via4" 125.975 7.325 126.045 7.395)
rect(cv "Metal4" 125.885 7.315 126.135 7.405)
rect(cv "Metal5" 125.965 7.235 126.055 7.485)
rect(cv "Via5" 125.975 7.325 126.045 7.395)
rect(cv "Metal5" 125.965 7.235 126.055 7.485)
rect(cv "Metal6" 125.885 7.315 126.135 7.405)
rect(cv "Via6" 125.975 7.325 126.045 7.395)
rect(cv "Metal6" 125.885 7.315 126.135 7.405)
rect(cv "Metal7" 125.965 7.235 126.055 7.485)
rect(cv "Metal7" 125.97 7.32 126.05 41.59)
rect(cv "Via6" 125.975 41.515 126.045 41.585)
rect(cv "Metal6" 125.885 41.505 126.135 41.595)
rect(cv "Metal7" 125.965 41.425 126.055 41.675)
rect(cv "Via3" 12.055 23.065 12.125 23.135)
rect(cv "Metal3" 12.045 22.975 12.135 23.225)
rect(cv "Metal4" 11.965 23.055 12.215 23.145)
rect(cv "Via4" 12.055 23.065 12.125 23.135)
rect(cv "Metal4" 11.965 23.055 12.215 23.145)
rect(cv "Metal5" 12.045 22.975 12.135 23.225)
rect(cv "Via5" 12.055 23.065 12.125 23.135)
rect(cv "Metal5" 12.045 22.975 12.135 23.225)
rect(cv "Metal6" 11.965 23.055 12.215 23.145)
rect(cv "Via6" 12.055 23.065 12.125 23.135)
rect(cv "Metal6" 11.965 23.055 12.215 23.145)
rect(cv "Metal7" 12.045 22.975 12.135 23.225)
rect(cv "Metal7" 12.05 23.06 12.13 35.51)
rect(cv "Via6" 12.055 35.435 12.125 35.505)
rect(cv "Metal6" 11.965 35.425 12.215 35.515)
rect(cv "Metal7" 12.045 35.345 12.135 35.595)
rect(cv "Via3" 12.375 23.065 12.445 23.135)
rect(cv "Metal3" 12.365 22.975 12.455 23.225)
rect(cv "Metal4" 12.285 23.055 12.535 23.145)
rect(cv "Via4" 12.375 23.065 12.445 23.135)
rect(cv "Metal4" 12.285 23.055 12.535 23.145)
rect(cv "Metal5" 12.365 22.975 12.455 23.225)
rect(cv "Via5" 12.375 23.065 12.445 23.135)
rect(cv "Metal5" 12.365 22.975 12.455 23.225)
rect(cv "Metal6" 12.285 23.055 12.535 23.145)
rect(cv "Via6" 12.375 23.065 12.445 23.135)
rect(cv "Metal6" 12.285 23.055 12.535 23.145)
rect(cv "Metal7" 12.365 22.975 12.455 23.225)
rect(cv "Metal7" 12.37 23.06 12.45 35.67)
rect(cv "Via6" 12.375 35.595 12.445 35.665)
rect(cv "Metal6" 12.285 35.585 12.535 35.675)
rect(cv "Metal7" 12.365 35.505 12.455 35.755)
rect(cv "Via3" 12.695 23.065 12.765 23.135)
rect(cv "Metal3" 12.685 22.975 12.775 23.225)
rect(cv "Metal4" 12.605 23.055 12.855 23.145)
rect(cv "Via4" 12.695 23.065 12.765 23.135)
rect(cv "Metal4" 12.605 23.055 12.855 23.145)
rect(cv "Metal5" 12.685 22.975 12.775 23.225)
rect(cv "Via5" 12.695 23.065 12.765 23.135)
rect(cv "Metal5" 12.685 22.975 12.775 23.225)
rect(cv "Metal6" 12.605 23.055 12.855 23.145)
rect(cv "Via6" 12.695 23.065 12.765 23.135)
rect(cv "Metal6" 12.605 23.055 12.855 23.145)
rect(cv "Metal7" 12.685 22.975 12.775 23.225)
rect(cv "Metal7" 12.69 23.06 12.77 35.83)
rect(cv "Via6" 12.695 35.755 12.765 35.825)
rect(cv "Metal6" 12.605 35.745 12.855 35.835)
rect(cv "Metal7" 12.685 35.665 12.775 35.915)
rect(cv "Via3" 13.015 23.065 13.085 23.135)
rect(cv "Metal3" 13.005 22.975 13.095 23.225)
rect(cv "Metal4" 12.925 23.055 13.175 23.145)
rect(cv "Via4" 13.015 23.065 13.085 23.135)
rect(cv "Metal4" 12.925 23.055 13.175 23.145)
rect(cv "Metal5" 13.005 22.975 13.095 23.225)
rect(cv "Via5" 13.015 23.065 13.085 23.135)
rect(cv "Metal5" 13.005 22.975 13.095 23.225)
rect(cv "Metal6" 12.925 23.055 13.175 23.145)
rect(cv "Via6" 13.015 23.065 13.085 23.135)
rect(cv "Metal6" 12.925 23.055 13.175 23.145)
rect(cv "Metal7" 13.005 22.975 13.095 23.225)
rect(cv "Metal7" 13.01 23.06 13.09 35.99)
rect(cv "Via6" 13.015 35.915 13.085 35.985)
rect(cv "Metal6" 12.925 35.905 13.175 35.995)
rect(cv "Metal7" 13.005 35.825 13.095 36.075)
rect(cv "Via3" 13.335 23.065 13.405 23.135)
rect(cv "Metal3" 13.325 22.975 13.415 23.225)
rect(cv "Metal4" 13.245 23.055 13.495 23.145)
rect(cv "Via4" 13.335 23.065 13.405 23.135)
rect(cv "Metal4" 13.245 23.055 13.495 23.145)
rect(cv "Metal5" 13.325 22.975 13.415 23.225)
rect(cv "Via5" 13.335 23.065 13.405 23.135)
rect(cv "Metal5" 13.325 22.975 13.415 23.225)
rect(cv "Metal6" 13.245 23.055 13.495 23.145)
rect(cv "Via6" 13.335 23.065 13.405 23.135)
rect(cv "Metal6" 13.245 23.055 13.495 23.145)
rect(cv "Metal7" 13.325 22.975 13.415 23.225)
rect(cv "Metal7" 13.33 23.06 13.41 35.03)
rect(cv "Via6" 13.335 34.955 13.405 35.025)
rect(cv "Metal6" 13.245 34.945 13.495 35.035)
rect(cv "Metal7" 13.325 34.865 13.415 35.115)
rect(cv "Via3" 13.655 23.065 13.725 23.135)
rect(cv "Metal3" 13.645 22.975 13.735 23.225)
rect(cv "Metal4" 13.565 23.055 13.815 23.145)
rect(cv "Via4" 13.655 23.065 13.725 23.135)
rect(cv "Metal4" 13.565 23.055 13.815 23.145)
rect(cv "Metal5" 13.645 22.975 13.735 23.225)
rect(cv "Via5" 13.655 23.065 13.725 23.135)
rect(cv "Metal5" 13.645 22.975 13.735 23.225)
rect(cv "Metal6" 13.565 23.055 13.815 23.145)
rect(cv "Via6" 13.655 23.065 13.725 23.135)
rect(cv "Metal6" 13.565 23.055 13.815 23.145)
rect(cv "Metal7" 13.645 22.975 13.735 23.225)
rect(cv "Metal7" 13.65 23.06 13.73 35.19)
rect(cv "Via6" 13.655 35.115 13.725 35.185)
rect(cv "Metal6" 13.565 35.105 13.815 35.195)
rect(cv "Metal7" 13.645 35.025 13.735 35.275)
rect(cv "Via3" 13.975 23.065 14.045 23.135)
rect(cv "Metal3" 13.965 22.975 14.055 23.225)
rect(cv "Metal4" 13.885 23.055 14.135 23.145)
rect(cv "Via4" 13.975 23.065 14.045 23.135)
rect(cv "Metal4" 13.885 23.055 14.135 23.145)
rect(cv "Metal5" 13.965 22.975 14.055 23.225)
rect(cv "Via5" 13.975 23.065 14.045 23.135)
rect(cv "Metal5" 13.965 22.975 14.055 23.225)
rect(cv "Metal6" 13.885 23.055 14.135 23.145)
rect(cv "Via6" 13.975 23.065 14.045 23.135)
rect(cv "Metal6" 13.885 23.055 14.135 23.145)
rect(cv "Metal7" 13.965 22.975 14.055 23.225)
rect(cv "Metal7" 13.97 23.06 14.05 36.79)
rect(cv "Via6" 13.975 36.715 14.045 36.785)
rect(cv "Metal6" 13.885 36.705 14.135 36.795)
rect(cv "Metal7" 13.965 36.625 14.055 36.875)
rect(cv "Via3" 14.295 23.065 14.365 23.135)
rect(cv "Metal3" 14.285 22.975 14.375 23.225)
rect(cv "Metal4" 14.205 23.055 14.455 23.145)
rect(cv "Via4" 14.295 23.065 14.365 23.135)
rect(cv "Metal4" 14.205 23.055 14.455 23.145)
rect(cv "Metal5" 14.285 22.975 14.375 23.225)
rect(cv "Via5" 14.295 23.065 14.365 23.135)
rect(cv "Metal5" 14.285 22.975 14.375 23.225)
rect(cv "Metal6" 14.205 23.055 14.455 23.145)
rect(cv "Via6" 14.295 23.065 14.365 23.135)
rect(cv "Metal6" 14.205 23.055 14.455 23.145)
rect(cv "Metal7" 14.285 22.975 14.375 23.225)
rect(cv "Metal7" 14.29 23.06 14.37 36.95)
rect(cv "Via6" 14.295 36.875 14.365 36.945)
rect(cv "Metal6" 14.205 36.865 14.455 36.955)
rect(cv "Metal7" 14.285 36.785 14.375 37.035)
rect(cv "Via3" 14.615 23.065 14.685 23.135)
rect(cv "Metal3" 14.605 22.975 14.695 23.225)
rect(cv "Metal4" 14.525 23.055 14.775 23.145)
rect(cv "Via4" 14.615 23.065 14.685 23.135)
rect(cv "Metal4" 14.525 23.055 14.775 23.145)
rect(cv "Metal5" 14.605 22.975 14.695 23.225)
rect(cv "Via5" 14.615 23.065 14.685 23.135)
rect(cv "Metal5" 14.605 22.975 14.695 23.225)
rect(cv "Metal6" 14.525 23.055 14.775 23.145)
rect(cv "Via6" 14.615 23.065 14.685 23.135)
rect(cv "Metal6" 14.525 23.055 14.775 23.145)
rect(cv "Metal7" 14.605 22.975 14.695 23.225)
rect(cv "Metal7" 14.61 23.06 14.69 37.11)
rect(cv "Via6" 14.615 37.035 14.685 37.105)
rect(cv "Metal6" 14.525 37.025 14.775 37.115)
rect(cv "Metal7" 14.605 36.945 14.695 37.195)
rect(cv "Via3" 14.935 23.065 15.005 23.135)
rect(cv "Metal3" 14.925 22.975 15.015 23.225)
rect(cv "Metal4" 14.845 23.055 15.095 23.145)
rect(cv "Via4" 14.935 23.065 15.005 23.135)
rect(cv "Metal4" 14.845 23.055 15.095 23.145)
rect(cv "Metal5" 14.925 22.975 15.015 23.225)
rect(cv "Via5" 14.935 23.065 15.005 23.135)
rect(cv "Metal5" 14.925 22.975 15.015 23.225)
rect(cv "Metal6" 14.845 23.055 15.095 23.145)
rect(cv "Via6" 14.935 23.065 15.005 23.135)
rect(cv "Metal6" 14.845 23.055 15.095 23.145)
rect(cv "Metal7" 14.925 22.975 15.015 23.225)
rect(cv "Metal7" 14.93 23.06 15.01 37.27)
rect(cv "Via6" 14.935 37.195 15.005 37.265)
rect(cv "Metal6" 14.845 37.185 15.095 37.275)
rect(cv "Metal7" 14.925 37.105 15.015 37.355)
rect(cv "Via3" 15.255 23.065 15.325 23.135)
rect(cv "Metal3" 15.245 22.975 15.335 23.225)
rect(cv "Metal4" 15.165 23.055 15.415 23.145)
rect(cv "Via4" 15.255 23.065 15.325 23.135)
rect(cv "Metal4" 15.165 23.055 15.415 23.145)
rect(cv "Metal5" 15.245 22.975 15.335 23.225)
rect(cv "Via5" 15.255 23.065 15.325 23.135)
rect(cv "Metal5" 15.245 22.975 15.335 23.225)
rect(cv "Metal6" 15.165 23.055 15.415 23.145)
rect(cv "Via6" 15.255 23.065 15.325 23.135)
rect(cv "Metal6" 15.165 23.055 15.415 23.145)
rect(cv "Metal7" 15.245 22.975 15.335 23.225)
rect(cv "Metal7" 15.25 23.06 15.33 37.43)
rect(cv "Via6" 15.255 37.355 15.325 37.425)
rect(cv "Metal6" 15.165 37.345 15.415 37.435)
rect(cv "Metal7" 15.245 37.265 15.335 37.515)
rect(cv "Via3" 15.575 23.065 15.645 23.135)
rect(cv "Metal3" 15.565 22.975 15.655 23.225)
rect(cv "Metal4" 15.485 23.055 15.735 23.145)
rect(cv "Via4" 15.575 23.065 15.645 23.135)
rect(cv "Metal4" 15.485 23.055 15.735 23.145)
rect(cv "Metal5" 15.565 22.975 15.655 23.225)
rect(cv "Via5" 15.575 23.065 15.645 23.135)
rect(cv "Metal5" 15.565 22.975 15.655 23.225)
rect(cv "Metal6" 15.485 23.055 15.735 23.145)
rect(cv "Via6" 15.575 23.065 15.645 23.135)
rect(cv "Metal6" 15.485 23.055 15.735 23.145)
rect(cv "Metal7" 15.565 22.975 15.655 23.225)
rect(cv "Metal7" 15.57 23.06 15.65 37.59)
rect(cv "Via6" 15.575 37.515 15.645 37.585)
rect(cv "Metal6" 15.485 37.505 15.735 37.595)
rect(cv "Metal7" 15.565 37.425 15.655 37.675)
rect(cv "Via3" 15.895 23.065 15.965 23.135)
rect(cv "Metal3" 15.885 22.975 15.975 23.225)
rect(cv "Metal4" 15.805 23.055 16.055 23.145)
rect(cv "Via4" 15.895 23.065 15.965 23.135)
rect(cv "Metal4" 15.805 23.055 16.055 23.145)
rect(cv "Metal5" 15.885 22.975 15.975 23.225)
rect(cv "Via5" 15.895 23.065 15.965 23.135)
rect(cv "Metal5" 15.885 22.975 15.975 23.225)
rect(cv "Metal6" 15.805 23.055 16.055 23.145)
rect(cv "Via6" 15.895 23.065 15.965 23.135)
rect(cv "Metal6" 15.805 23.055 16.055 23.145)
rect(cv "Metal7" 15.885 22.975 15.975 23.225)
rect(cv "Metal7" 15.89 23.06 15.97 36.47)
rect(cv "Via6" 15.895 36.395 15.965 36.465)
rect(cv "Metal6" 15.805 36.385 16.055 36.475)
rect(cv "Metal7" 15.885 36.305 15.975 36.555)
rect(cv "Via3" 16.215 23.065 16.285 23.135)
rect(cv "Metal3" 16.205 22.975 16.295 23.225)
rect(cv "Metal4" 16.125 23.055 16.375 23.145)
rect(cv "Via4" 16.215 23.065 16.285 23.135)
rect(cv "Metal4" 16.125 23.055 16.375 23.145)
rect(cv "Metal5" 16.205 22.975 16.295 23.225)
rect(cv "Via5" 16.215 23.065 16.285 23.135)
rect(cv "Metal5" 16.205 22.975 16.295 23.225)
rect(cv "Metal6" 16.125 23.055 16.375 23.145)
rect(cv "Via6" 16.215 23.065 16.285 23.135)
rect(cv "Metal6" 16.125 23.055 16.375 23.145)
rect(cv "Metal7" 16.205 22.975 16.295 23.225)
rect(cv "Metal7" 16.21 23.06 16.29 36.63)
rect(cv "Via6" 16.215 36.555 16.285 36.625)
rect(cv "Metal6" 16.125 36.545 16.375 36.635)
rect(cv "Metal7" 16.205 36.465 16.295 36.715)
rect(cv "Via3" 91.095 22.425 91.165 22.495)
rect(cv "Metal3" 91.085 22.335 91.175 22.585)
rect(cv "Metal4" 91.005 22.415 91.255 22.505)
rect(cv "Via4" 91.095 22.425 91.165 22.495)
rect(cv "Metal4" 91.005 22.415 91.255 22.505)
rect(cv "Metal5" 91.085 22.335 91.175 22.585)
rect(cv "Via5" 91.095 22.425 91.165 22.495)
rect(cv "Metal5" 91.085 22.335 91.175 22.585)
rect(cv "Metal6" 91.005 22.415 91.255 22.505)
rect(cv "Via6" 91.095 22.425 91.165 22.495)
rect(cv "Metal6" 91.005 22.415 91.255 22.505)
rect(cv "Metal7" 91.085 22.335 91.175 22.585)
rect(cv "Metal7" 91.09 22.42 91.17 37.75)
rect(cv "Via6" 91.095 37.675 91.165 37.745)
rect(cv "Metal6" 91.005 37.665 91.255 37.755)
rect(cv "Metal7" 91.085 37.585 91.175 37.835)
rect(cv "Via3" 91.415 22.425 91.485 22.495)
rect(cv "Metal3" 91.405 22.335 91.495 22.585)
rect(cv "Metal4" 91.325 22.415 91.575 22.505)
rect(cv "Via4" 91.415 22.425 91.485 22.495)
rect(cv "Metal4" 91.325 22.415 91.575 22.505)
rect(cv "Metal5" 91.405 22.335 91.495 22.585)
rect(cv "Via5" 91.415 22.425 91.485 22.495)
rect(cv "Metal5" 91.405 22.335 91.495 22.585)
rect(cv "Metal6" 91.325 22.415 91.575 22.505)
rect(cv "Via6" 91.415 22.425 91.485 22.495)
rect(cv "Metal6" 91.325 22.415 91.575 22.505)
rect(cv "Metal7" 91.405 22.335 91.495 22.585)
rect(cv "Metal7" 91.41 22.42 91.49 37.91)
rect(cv "Via6" 91.415 37.835 91.485 37.905)
rect(cv "Metal6" 91.325 37.825 91.575 37.915)
rect(cv "Metal7" 91.405 37.745 91.495 37.995)
rect(cv "Via3" 91.735 22.425 91.805 22.495)
rect(cv "Metal3" 91.725 22.335 91.815 22.585)
rect(cv "Metal4" 91.645 22.415 91.895 22.505)
rect(cv "Via4" 91.735 22.425 91.805 22.495)
rect(cv "Metal4" 91.645 22.415 91.895 22.505)
rect(cv "Metal5" 91.725 22.335 91.815 22.585)
rect(cv "Via5" 91.735 22.425 91.805 22.495)
rect(cv "Metal5" 91.725 22.335 91.815 22.585)
rect(cv "Metal6" 91.645 22.415 91.895 22.505)
rect(cv "Via6" 91.735 22.425 91.805 22.495)
rect(cv "Metal6" 91.645 22.415 91.895 22.505)
rect(cv "Metal7" 91.725 22.335 91.815 22.585)
rect(cv "Metal7" 91.73 22.42 91.81 38.07)
rect(cv "Via6" 91.735 37.995 91.805 38.065)
rect(cv "Metal6" 91.645 37.985 91.895 38.075)
rect(cv "Metal7" 91.725 37.905 91.815 38.155)
rect(cv "Via3" 92.055 22.425 92.125 22.495)
rect(cv "Metal3" 92.045 22.335 92.135 22.585)
rect(cv "Metal4" 91.965 22.415 92.215 22.505)
rect(cv "Via4" 92.055 22.425 92.125 22.495)
rect(cv "Metal4" 91.965 22.415 92.215 22.505)
rect(cv "Metal5" 92.045 22.335 92.135 22.585)
rect(cv "Via5" 92.055 22.425 92.125 22.495)
rect(cv "Metal5" 92.045 22.335 92.135 22.585)
rect(cv "Metal6" 91.965 22.415 92.215 22.505)
rect(cv "Via6" 92.055 22.425 92.125 22.495)
rect(cv "Metal6" 91.965 22.415 92.215 22.505)
rect(cv "Metal7" 92.045 22.335 92.135 22.585)
rect(cv "Metal7" 92.05 22.42 92.13 38.23)
rect(cv "Via6" 92.055 38.155 92.125 38.225)
rect(cv "Metal6" 91.965 38.145 92.215 38.235)
rect(cv "Metal7" 92.045 38.065 92.135 38.315)
rect(cv "Via3" 92.375 22.425 92.445 22.495)
rect(cv "Metal3" 92.365 22.335 92.455 22.585)
rect(cv "Metal4" 92.285 22.415 92.535 22.505)
rect(cv "Via4" 92.375 22.425 92.445 22.495)
rect(cv "Metal4" 92.285 22.415 92.535 22.505)
rect(cv "Metal5" 92.365 22.335 92.455 22.585)
rect(cv "Via5" 92.375 22.425 92.445 22.495)
rect(cv "Metal5" 92.365 22.335 92.455 22.585)
rect(cv "Metal6" 92.285 22.415 92.535 22.505)
rect(cv "Via6" 92.375 22.425 92.445 22.495)
rect(cv "Metal6" 92.285 22.415 92.535 22.505)
rect(cv "Metal7" 92.365 22.335 92.455 22.585)
rect(cv "Metal7" 92.37 22.42 92.45 39.35)
rect(cv "Via6" 92.375 39.275 92.445 39.345)
rect(cv "Metal6" 92.285 39.265 92.535 39.355)
rect(cv "Metal7" 92.365 39.185 92.455 39.435)
rect(cv "Via3" 92.695 22.425 92.765 22.495)
rect(cv "Metal3" 92.685 22.335 92.775 22.585)
rect(cv "Metal4" 92.605 22.415 92.855 22.505)
rect(cv "Via4" 92.695 22.425 92.765 22.495)
rect(cv "Metal4" 92.605 22.415 92.855 22.505)
rect(cv "Metal5" 92.685 22.335 92.775 22.585)
rect(cv "Via5" 92.695 22.425 92.765 22.495)
rect(cv "Metal5" 92.685 22.335 92.775 22.585)
rect(cv "Metal6" 92.605 22.415 92.855 22.505)
rect(cv "Via6" 92.695 22.425 92.765 22.495)
rect(cv "Metal6" 92.605 22.415 92.855 22.505)
rect(cv "Metal7" 92.685 22.335 92.775 22.585)
rect(cv "Metal7" 92.69 22.42 92.77 39.51)
rect(cv "Via6" 92.695 39.435 92.765 39.505)
rect(cv "Metal6" 92.605 39.425 92.855 39.515)
rect(cv "Metal7" 92.685 39.345 92.775 39.595)
rect(cv "Via3" 93.015 22.425 93.085 22.495)
rect(cv "Metal3" 93.005 22.335 93.095 22.585)
rect(cv "Metal4" 92.925 22.415 93.175 22.505)
rect(cv "Via4" 93.015 22.425 93.085 22.495)
rect(cv "Metal4" 92.925 22.415 93.175 22.505)
rect(cv "Metal5" 93.005 22.335 93.095 22.585)
rect(cv "Via5" 93.015 22.425 93.085 22.495)
rect(cv "Metal5" 93.005 22.335 93.095 22.585)
rect(cv "Metal6" 92.925 22.415 93.175 22.505)
rect(cv "Via6" 93.015 22.425 93.085 22.495)
rect(cv "Metal6" 92.925 22.415 93.175 22.505)
rect(cv "Metal7" 93.005 22.335 93.095 22.585)
rect(cv "Metal7" 93.01 22.42 93.09 39.67)
rect(cv "Via6" 93.015 39.595 93.085 39.665)
rect(cv "Metal6" 92.925 39.585 93.175 39.675)
rect(cv "Metal7" 93.005 39.505 93.095 39.755)
rect(cv "Via3" 93.335 22.425 93.405 22.495)
rect(cv "Metal3" 93.325 22.335 93.415 22.585)
rect(cv "Metal4" 93.245 22.415 93.495 22.505)
rect(cv "Via4" 93.335 22.425 93.405 22.495)
rect(cv "Metal4" 93.245 22.415 93.495 22.505)
rect(cv "Metal5" 93.325 22.335 93.415 22.585)
rect(cv "Via5" 93.335 22.425 93.405 22.495)
rect(cv "Metal5" 93.325 22.335 93.415 22.585)
rect(cv "Metal6" 93.245 22.415 93.495 22.505)
rect(cv "Via6" 93.335 22.425 93.405 22.495)
rect(cv "Metal6" 93.245 22.415 93.495 22.505)
rect(cv "Metal7" 93.325 22.335 93.415 22.585)
rect(cv "Metal7" 93.33 22.42 93.41 39.83)
rect(cv "Via6" 93.335 39.755 93.405 39.825)
rect(cv "Metal6" 93.245 39.745 93.495 39.835)
rect(cv "Metal7" 93.325 39.665 93.415 39.915)
rect(cv "Via3" 93.655 22.425 93.725 22.495)
rect(cv "Metal3" 93.645 22.335 93.735 22.585)
rect(cv "Metal4" 93.565 22.415 93.815 22.505)
rect(cv "Via4" 93.655 22.425 93.725 22.495)
rect(cv "Metal4" 93.565 22.415 93.815 22.505)
rect(cv "Metal5" 93.645 22.335 93.735 22.585)
rect(cv "Via5" 93.655 22.425 93.725 22.495)
rect(cv "Metal5" 93.645 22.335 93.735 22.585)
rect(cv "Metal6" 93.565 22.415 93.815 22.505)
rect(cv "Via6" 93.655 22.425 93.725 22.495)
rect(cv "Metal6" 93.565 22.415 93.815 22.505)
rect(cv "Metal7" 93.645 22.335 93.735 22.585)
rect(cv "Metal7" 93.65 22.42 93.73 39.99)
rect(cv "Via6" 93.655 39.915 93.725 39.985)
rect(cv "Metal6" 93.565 39.905 93.815 39.995)
rect(cv "Metal7" 93.645 39.825 93.735 40.075)
rect(cv "Via3" 93.975 22.425 94.045 22.495)
rect(cv "Metal3" 93.965 22.335 94.055 22.585)
rect(cv "Metal4" 93.885 22.415 94.135 22.505)
rect(cv "Via4" 93.975 22.425 94.045 22.495)
rect(cv "Metal4" 93.885 22.415 94.135 22.505)
rect(cv "Metal5" 93.965 22.335 94.055 22.585)
rect(cv "Via5" 93.975 22.425 94.045 22.495)
rect(cv "Metal5" 93.965 22.335 94.055 22.585)
rect(cv "Metal6" 93.885 22.415 94.135 22.505)
rect(cv "Via6" 93.975 22.425 94.045 22.495)
rect(cv "Metal6" 93.885 22.415 94.135 22.505)
rect(cv "Metal7" 93.965 22.335 94.055 22.585)
rect(cv "Metal7" 93.97 22.42 94.05 40.15)
rect(cv "Via6" 93.975 40.075 94.045 40.145)
rect(cv "Metal6" 93.885 40.065 94.135 40.155)
rect(cv "Metal7" 93.965 39.985 94.055 40.235)
rect(cv "Via3" 94.295 22.425 94.365 22.495)
rect(cv "Metal3" 94.285 22.335 94.375 22.585)
rect(cv "Metal4" 94.205 22.415 94.455 22.505)
rect(cv "Via4" 94.295 22.425 94.365 22.495)
rect(cv "Metal4" 94.205 22.415 94.455 22.505)
rect(cv "Metal5" 94.285 22.335 94.375 22.585)
rect(cv "Via5" 94.295 22.425 94.365 22.495)
rect(cv "Metal5" 94.285 22.335 94.375 22.585)
rect(cv "Metal6" 94.205 22.415 94.455 22.505)
rect(cv "Via6" 94.295 22.425 94.365 22.495)
rect(cv "Metal6" 94.205 22.415 94.455 22.505)
rect(cv "Metal7" 94.285 22.335 94.375 22.585)
rect(cv "Metal7" 94.29 22.42 94.37 40.31)
rect(cv "Via6" 94.295 40.235 94.365 40.305)
rect(cv "Metal6" 94.205 40.225 94.455 40.315)
rect(cv "Metal7" 94.285 40.145 94.375 40.395)
rect(cv "Via3" 94.615 22.425 94.685 22.495)
rect(cv "Metal3" 94.605 22.335 94.695 22.585)
rect(cv "Metal4" 94.525 22.415 94.775 22.505)
rect(cv "Via4" 94.615 22.425 94.685 22.495)
rect(cv "Metal4" 94.525 22.415 94.775 22.505)
rect(cv "Metal5" 94.605 22.335 94.695 22.585)
rect(cv "Via5" 94.615 22.425 94.685 22.495)
rect(cv "Metal5" 94.605 22.335 94.695 22.585)
rect(cv "Metal6" 94.525 22.415 94.775 22.505)
rect(cv "Via6" 94.615 22.425 94.685 22.495)
rect(cv "Metal6" 94.525 22.415 94.775 22.505)
rect(cv "Metal7" 94.605 22.335 94.695 22.585)
rect(cv "Metal7" 94.61 22.42 94.69 40.47)
rect(cv "Via6" 94.615 40.395 94.685 40.465)
rect(cv "Metal6" 94.525 40.385 94.775 40.475)
rect(cv "Metal7" 94.605 40.305 94.695 40.555)
rect(cv "Via3" 94.935 22.425 95.005 22.495)
rect(cv "Metal3" 94.925 22.335 95.015 22.585)
rect(cv "Metal4" 94.845 22.415 95.095 22.505)
rect(cv "Via4" 94.935 22.425 95.005 22.495)
rect(cv "Metal4" 94.845 22.415 95.095 22.505)
rect(cv "Metal5" 94.925 22.335 95.015 22.585)
rect(cv "Via5" 94.935 22.425 95.005 22.495)
rect(cv "Metal5" 94.925 22.335 95.015 22.585)
rect(cv "Metal6" 94.845 22.415 95.095 22.505)
rect(cv "Via6" 94.935 22.425 95.005 22.495)
rect(cv "Metal6" 94.845 22.415 95.095 22.505)
rect(cv "Metal7" 94.925 22.335 95.015 22.585)
rect(cv "Metal7" 94.93 22.42 95.01 40.63)
rect(cv "Via6" 94.935 40.555 95.005 40.625)
rect(cv "Metal6" 94.845 40.545 95.095 40.635)
rect(cv "Metal7" 94.925 40.465 95.015 40.715)
rect(cv "Via3" 95.255 22.425 95.325 22.495)
rect(cv "Metal3" 95.245 22.335 95.335 22.585)
rect(cv "Metal4" 95.165 22.415 95.415 22.505)
rect(cv "Via4" 95.255 22.425 95.325 22.495)
rect(cv "Metal4" 95.165 22.415 95.415 22.505)
rect(cv "Metal5" 95.245 22.335 95.335 22.585)
rect(cv "Via5" 95.255 22.425 95.325 22.495)
rect(cv "Metal5" 95.245 22.335 95.335 22.585)
rect(cv "Metal6" 95.165 22.415 95.415 22.505)
rect(cv "Via6" 95.255 22.425 95.325 22.495)
rect(cv "Metal6" 95.165 22.415 95.415 22.505)
rect(cv "Metal7" 95.245 22.335 95.335 22.585)
rect(cv "Metal7" 95.25 22.42 95.33 40.79)
rect(cv "Via6" 95.255 40.715 95.325 40.785)
rect(cv "Metal6" 95.165 40.705 95.415 40.795)
rect(cv "Metal7" 95.245 40.625 95.335 40.875)
rect(cv "Via3" 95.575 22.425 95.645 22.495)
rect(cv "Metal3" 95.565 22.335 95.655 22.585)
rect(cv "Metal4" 95.485 22.415 95.735 22.505)
rect(cv "Via4" 95.575 22.425 95.645 22.495)
rect(cv "Metal4" 95.485 22.415 95.735 22.505)
rect(cv "Metal5" 95.565 22.335 95.655 22.585)
rect(cv "Via5" 95.575 22.425 95.645 22.495)
rect(cv "Metal5" 95.565 22.335 95.655 22.585)
rect(cv "Metal6" 95.485 22.415 95.735 22.505)
rect(cv "Via6" 95.575 22.425 95.645 22.495)
rect(cv "Metal6" 95.485 22.415 95.735 22.505)
rect(cv "Metal7" 95.565 22.335 95.655 22.585)
rect(cv "Metal7" 95.57 22.42 95.65 40.95)
rect(cv "Via6" 95.575 40.875 95.645 40.945)
rect(cv "Metal6" 95.485 40.865 95.735 40.955)
rect(cv "Metal7" 95.565 40.785 95.655 41.035)
rect(cv "Via3" 95.895 22.425 95.965 22.495)
rect(cv "Metal3" 95.885 22.335 95.975 22.585)
rect(cv "Metal4" 95.805 22.415 96.055 22.505)
rect(cv "Via4" 95.895 22.425 95.965 22.495)
rect(cv "Metal4" 95.805 22.415 96.055 22.505)
rect(cv "Metal5" 95.885 22.335 95.975 22.585)
rect(cv "Via5" 95.895 22.425 95.965 22.495)
rect(cv "Metal5" 95.885 22.335 95.975 22.585)
rect(cv "Metal6" 95.805 22.415 96.055 22.505)
rect(cv "Via6" 95.895 22.425 95.965 22.495)
rect(cv "Metal6" 95.805 22.415 96.055 22.505)
rect(cv "Metal7" 95.885 22.335 95.975 22.585)
rect(cv "Metal7" 95.89 22.42 95.97 41.11)
rect(cv "Via6" 95.895 41.035 95.965 41.105)
rect(cv "Metal6" 95.805 41.025 96.055 41.115)
rect(cv "Metal7" 95.885 40.945 95.975 41.195)
rect(cv "Via3" 96.215 22.425 96.285 22.495)
rect(cv "Metal3" 96.205 22.335 96.295 22.585)
rect(cv "Metal4" 96.125 22.415 96.375 22.505)
rect(cv "Via4" 96.215 22.425 96.285 22.495)
rect(cv "Metal4" 96.125 22.415 96.375 22.505)
rect(cv "Metal5" 96.205 22.335 96.295 22.585)
rect(cv "Via5" 96.215 22.425 96.285 22.495)
rect(cv "Metal5" 96.205 22.335 96.295 22.585)
rect(cv "Metal6" 96.125 22.415 96.375 22.505)
rect(cv "Via6" 96.215 22.425 96.285 22.495)
rect(cv "Metal6" 96.125 22.415 96.375 22.505)
rect(cv "Metal7" 96.205 22.335 96.295 22.585)
rect(cv "Metal7" 96.21 22.42 96.29 36.47)
rect(cv "Via6" 96.215 36.395 96.285 36.465)
rect(cv "Metal6" 96.125 36.385 96.375 36.475)
rect(cv "Metal7" 96.205 36.305 96.295 36.555)
rect(cv "Via3" 96.535 22.425 96.605 22.495)
rect(cv "Metal3" 96.525 22.335 96.615 22.585)
rect(cv "Metal4" 96.445 22.415 96.695 22.505)
rect(cv "Via4" 96.535 22.425 96.605 22.495)
rect(cv "Metal4" 96.445 22.415 96.695 22.505)
rect(cv "Metal5" 96.525 22.335 96.615 22.585)
rect(cv "Via5" 96.535 22.425 96.605 22.495)
rect(cv "Metal5" 96.525 22.335 96.615 22.585)
rect(cv "Metal6" 96.445 22.415 96.695 22.505)
rect(cv "Via6" 96.535 22.425 96.605 22.495)
rect(cv "Metal6" 96.445 22.415 96.695 22.505)
rect(cv "Metal7" 96.525 22.335 96.615 22.585)
rect(cv "Metal7" 96.53 22.42 96.61 36.63)
rect(cv "Via6" 96.535 36.555 96.605 36.625)
rect(cv "Metal6" 96.445 36.545 96.695 36.635)
rect(cv "Metal7" 96.525 36.465 96.615 36.715)
rect(cv "Via3" 111.895 18.825 111.965 18.895)
rect(cv "Metal3" 111.885 18.735 111.975 18.985)
rect(cv "Metal4" 111.805 18.815 112.055 18.905)
rect(cv "Via4" 111.895 18.825 111.965 18.895)
rect(cv "Metal4" 111.805 18.815 112.055 18.905)
rect(cv "Metal5" 111.885 18.735 111.975 18.985)
rect(cv "Via5" 111.895 18.825 111.965 18.895)
rect(cv "Metal5" 111.885 18.735 111.975 18.985)
rect(cv "Metal6" 111.805 18.815 112.055 18.905)
rect(cv "Via6" 111.895 18.825 111.965 18.895)
rect(cv "Metal6" 111.805 18.815 112.055 18.905)
rect(cv "Metal7" 111.885 18.735 111.975 18.985)
rect(cv "Metal7" 111.89 18.82 111.97 41.59)
rect(cv "Via6" 111.895 41.515 111.965 41.585)
rect(cv "Metal6" 111.805 41.505 112.055 41.595)
rect(cv "Metal7" 111.885 41.425 111.975 41.675)
rect(cv "Via3" 112.215 18.825 112.285 18.895)
rect(cv "Metal3" 112.205 18.735 112.295 18.985)
rect(cv "Metal4" 112.125 18.815 112.375 18.905)
rect(cv "Via4" 112.215 18.825 112.285 18.895)
rect(cv "Metal4" 112.125 18.815 112.375 18.905)
rect(cv "Metal5" 112.205 18.735 112.295 18.985)
rect(cv "Via5" 112.215 18.825 112.285 18.895)
rect(cv "Metal5" 112.205 18.735 112.295 18.985)
rect(cv "Metal6" 112.125 18.815 112.375 18.905)
rect(cv "Via6" 112.215 18.825 112.285 18.895)
rect(cv "Metal6" 112.125 18.815 112.375 18.905)
rect(cv "Metal7" 112.205 18.735 112.295 18.985)
rect(cv "Metal7" 112.21 18.82 112.29 37.11)
rect(cv "Via6" 112.215 37.035 112.285 37.105)
rect(cv "Metal6" 112.125 37.025 112.375 37.115)
rect(cv "Metal7" 112.205 36.945 112.295 37.195)
rect(cv "Via3" 112.535 18.825 112.605 18.895)
rect(cv "Metal3" 112.525 18.735 112.615 18.985)
rect(cv "Metal4" 112.445 18.815 112.695 18.905)
rect(cv "Via4" 112.535 18.825 112.605 18.895)
rect(cv "Metal4" 112.445 18.815 112.695 18.905)
rect(cv "Metal5" 112.525 18.735 112.615 18.985)
rect(cv "Via5" 112.535 18.825 112.605 18.895)
rect(cv "Metal5" 112.525 18.735 112.615 18.985)
rect(cv "Metal6" 112.445 18.815 112.695 18.905)
rect(cv "Via6" 112.535 18.825 112.605 18.895)
rect(cv "Metal6" 112.445 18.815 112.695 18.905)
rect(cv "Metal7" 112.525 18.735 112.615 18.985)
rect(cv "Metal7" 112.53 18.82 112.61 37.27)
rect(cv "Via6" 112.535 37.195 112.605 37.265)
rect(cv "Metal6" 112.445 37.185 112.695 37.275)
rect(cv "Metal7" 112.525 37.105 112.615 37.355)
rect(cv "Via3" 112.855 18.825 112.925 18.895)
rect(cv "Metal3" 112.845 18.735 112.935 18.985)
rect(cv "Metal4" 112.765 18.815 113.015 18.905)
rect(cv "Via4" 112.855 18.825 112.925 18.895)
rect(cv "Metal4" 112.765 18.815 113.015 18.905)
rect(cv "Metal5" 112.845 18.735 112.935 18.985)
rect(cv "Via5" 112.855 18.825 112.925 18.895)
rect(cv "Metal5" 112.845 18.735 112.935 18.985)
rect(cv "Metal6" 112.765 18.815 113.015 18.905)
rect(cv "Via6" 112.855 18.825 112.925 18.895)
rect(cv "Metal6" 112.765 18.815 113.015 18.905)
rect(cv "Metal7" 112.845 18.735 112.935 18.985)
rect(cv "Metal7" 112.85 18.82 112.93 36.31)
rect(cv "Via6" 112.855 36.235 112.925 36.305)
rect(cv "Metal6" 112.765 36.225 113.015 36.315)
rect(cv "Metal7" 112.845 36.145 112.935 36.395)
rect(cv "Via3" 113.175 18.825 113.245 18.895)
rect(cv "Metal3" 113.165 18.735 113.255 18.985)
rect(cv "Metal4" 113.085 18.815 113.335 18.905)
rect(cv "Via4" 113.175 18.825 113.245 18.895)
rect(cv "Metal4" 113.085 18.815 113.335 18.905)
rect(cv "Metal5" 113.165 18.735 113.255 18.985)
rect(cv "Via5" 113.175 18.825 113.245 18.895)
rect(cv "Metal5" 113.165 18.735 113.255 18.985)
rect(cv "Metal6" 113.085 18.815 113.335 18.905)
rect(cv "Via6" 113.175 18.825 113.245 18.895)
rect(cv "Metal6" 113.085 18.815 113.335 18.905)
rect(cv "Metal7" 113.165 18.735 113.255 18.985)
rect(cv "Metal7" 113.17 18.82 113.25 36.47)
rect(cv "Via6" 113.175 36.395 113.245 36.465)
rect(cv "Metal6" 113.085 36.385 113.335 36.475)
rect(cv "Metal7" 113.165 36.305 113.255 36.555)
rect(cv "Via3" 113.495 18.825 113.565 18.895)
rect(cv "Metal3" 113.485 18.735 113.575 18.985)
rect(cv "Metal4" 113.405 18.815 113.655 18.905)
rect(cv "Via4" 113.495 18.825 113.565 18.895)
rect(cv "Metal4" 113.405 18.815 113.655 18.905)
rect(cv "Metal5" 113.485 18.735 113.575 18.985)
rect(cv "Via5" 113.495 18.825 113.565 18.895)
rect(cv "Metal5" 113.485 18.735 113.575 18.985)
rect(cv "Metal6" 113.405 18.815 113.655 18.905)
rect(cv "Via6" 113.495 18.825 113.565 18.895)
rect(cv "Metal6" 113.405 18.815 113.655 18.905)
rect(cv "Metal7" 113.485 18.735 113.575 18.985)
rect(cv "Metal7" 113.49 18.82 113.57 36.63)
rect(cv "Via6" 113.495 36.555 113.565 36.625)
rect(cv "Metal6" 113.405 36.545 113.655 36.635)
rect(cv "Metal7" 113.485 36.465 113.575 36.715)
rect(cv "Via3" 16.535 34.155 16.605 34.225)
rect(cv "Metal3" 16.525 34.065 16.615 34.315)
rect(cv "Metal4" 16.445 34.145 16.695 34.235)
rect(cv "Via4" 16.535 34.155 16.605 34.225)
rect(cv "Metal4" 16.445 34.145 16.695 34.235)
rect(cv "Metal5" 16.525 34.065 16.615 34.315)
rect(cv "Via5" 16.535 34.155 16.605 34.225)
rect(cv "Metal5" 16.525 34.065 16.615 34.315)
rect(cv "Metal6" 16.445 34.145 16.695 34.235)
rect(cv "Via6" 16.535 34.155 16.605 34.225)
rect(cv "Metal6" 16.445 34.145 16.695 34.235)
rect(cv "Metal7" 16.525 34.065 16.615 34.315)
rect(cv "Metal7" 16.53 34.15 16.61 35.03)
rect(cv "Via6" 16.535 34.955 16.605 35.025)
rect(cv "Metal6" 16.445 34.945 16.695 35.035)
rect(cv "Metal7" 16.525 34.865 16.615 35.115)
rect(cv "Via3" 16.855 34.155 16.925 34.225)
rect(cv "Metal3" 16.845 34.065 16.935 34.315)
rect(cv "Metal4" 16.765 34.145 17.015 34.235)
rect(cv "Via4" 16.855 34.155 16.925 34.225)
rect(cv "Metal4" 16.765 34.145 17.015 34.235)
rect(cv "Metal5" 16.845 34.065 16.935 34.315)
rect(cv "Via5" 16.855 34.155 16.925 34.225)
rect(cv "Metal5" 16.845 34.065 16.935 34.315)
rect(cv "Metal6" 16.765 34.145 17.015 34.235)
rect(cv "Via6" 16.855 34.155 16.925 34.225)
rect(cv "Metal6" 16.765 34.145 17.015 34.235)
rect(cv "Metal7" 16.845 34.065 16.935 34.315)
rect(cv "Metal7" 16.85 34.15 16.93 35.19)
rect(cv "Via6" 16.855 35.115 16.925 35.185)
rect(cv "Metal6" 16.765 35.105 17.015 35.195)
rect(cv "Metal7" 16.845 35.025 16.935 35.275)
rect(cv "Via3" 17.175 34.155 17.245 34.225)
rect(cv "Metal3" 17.165 34.065 17.255 34.315)
rect(cv "Metal4" 17.085 34.145 17.335 34.235)
rect(cv "Via4" 17.175 34.155 17.245 34.225)
rect(cv "Metal4" 17.085 34.145 17.335 34.235)
rect(cv "Metal5" 17.165 34.065 17.255 34.315)
rect(cv "Via5" 17.175 34.155 17.245 34.225)
rect(cv "Metal5" 17.165 34.065 17.255 34.315)
rect(cv "Metal6" 17.085 34.145 17.335 34.235)
rect(cv "Via6" 17.175 34.155 17.245 34.225)
rect(cv "Metal6" 17.085 34.145 17.335 34.235)
rect(cv "Metal7" 17.165 34.065 17.255 34.315)
rect(cv "Metal7" 17.17 34.15 17.25 35.35)
rect(cv "Via6" 17.175 35.275 17.245 35.345)
rect(cv "Metal6" 17.085 35.265 17.335 35.355)
rect(cv "Metal7" 17.165 35.185 17.255 35.435)
rect(cv "Via3" 17.495 34.155 17.565 34.225)
rect(cv "Metal3" 17.485 34.065 17.575 34.315)
rect(cv "Metal4" 17.405 34.145 17.655 34.235)
rect(cv "Via4" 17.495 34.155 17.565 34.225)
rect(cv "Metal4" 17.405 34.145 17.655 34.235)
rect(cv "Metal5" 17.485 34.065 17.575 34.315)
rect(cv "Via5" 17.495 34.155 17.565 34.225)
rect(cv "Metal5" 17.485 34.065 17.575 34.315)
rect(cv "Metal6" 17.405 34.145 17.655 34.235)
rect(cv "Via6" 17.495 34.155 17.565 34.225)
rect(cv "Metal6" 17.405 34.145 17.655 34.235)
rect(cv "Metal7" 17.485 34.065 17.575 34.315)
rect(cv "Metal7" 17.49 34.15 17.57 38.39)
rect(cv "Via6" 17.495 38.315 17.565 38.385)
rect(cv "Metal6" 17.405 38.305 17.655 38.395)
rect(cv "Metal7" 17.485 38.225 17.575 38.475)
rect(cv "Via3" 17.815 34.155 17.885 34.225)
rect(cv "Metal3" 17.805 34.065 17.895 34.315)
rect(cv "Metal4" 17.725 34.145 17.975 34.235)
rect(cv "Via4" 17.815 34.155 17.885 34.225)
rect(cv "Metal4" 17.725 34.145 17.975 34.235)
rect(cv "Metal5" 17.805 34.065 17.895 34.315)
rect(cv "Via5" 17.815 34.155 17.885 34.225)
rect(cv "Metal5" 17.805 34.065 17.895 34.315)
rect(cv "Metal6" 17.725 34.145 17.975 34.235)
rect(cv "Via6" 17.815 34.155 17.885 34.225)
rect(cv "Metal6" 17.725 34.145 17.975 34.235)
rect(cv "Metal7" 17.805 34.065 17.895 34.315)
rect(cv "Metal7" 17.81 34.15 17.89 38.55)
rect(cv "Via6" 17.815 38.475 17.885 38.545)
rect(cv "Metal6" 17.725 38.465 17.975 38.555)
rect(cv "Metal7" 17.805 38.385 17.895 38.635)
rect(cv "Via3" 18.135 34.155 18.205 34.225)
rect(cv "Metal3" 18.125 34.065 18.215 34.315)
rect(cv "Metal4" 18.045 34.145 18.295 34.235)
rect(cv "Via4" 18.135 34.155 18.205 34.225)
rect(cv "Metal4" 18.045 34.145 18.295 34.235)
rect(cv "Metal5" 18.125 34.065 18.215 34.315)
rect(cv "Via5" 18.135 34.155 18.205 34.225)
rect(cv "Metal5" 18.125 34.065 18.215 34.315)
rect(cv "Metal6" 18.045 34.145 18.295 34.235)
rect(cv "Via6" 18.135 34.155 18.205 34.225)
rect(cv "Metal6" 18.045 34.145 18.295 34.235)
rect(cv "Metal7" 18.125 34.065 18.215 34.315)
rect(cv "Metal7" 18.13 34.15 18.21 38.71)
rect(cv "Via6" 18.135 38.635 18.205 38.705)
rect(cv "Metal6" 18.045 38.625 18.295 38.715)
rect(cv "Metal7" 18.125 38.545 18.215 38.795)
rect(cv "Via3" 18.455 34.155 18.525 34.225)
rect(cv "Metal3" 18.445 34.065 18.535 34.315)
rect(cv "Metal4" 18.365 34.145 18.615 34.235)
rect(cv "Via4" 18.455 34.155 18.525 34.225)
rect(cv "Metal4" 18.365 34.145 18.615 34.235)
rect(cv "Metal5" 18.445 34.065 18.535 34.315)
rect(cv "Via5" 18.455 34.155 18.525 34.225)
rect(cv "Metal5" 18.445 34.065 18.535 34.315)
rect(cv "Metal6" 18.365 34.145 18.615 34.235)
rect(cv "Via6" 18.455 34.155 18.525 34.225)
rect(cv "Metal6" 18.365 34.145 18.615 34.235)
rect(cv "Metal7" 18.445 34.065 18.535 34.315)
rect(cv "Metal7" 18.45 34.15 18.53 38.87)
rect(cv "Via6" 18.455 38.795 18.525 38.865)
rect(cv "Metal6" 18.365 38.785 18.615 38.875)
rect(cv "Metal7" 18.445 38.705 18.535 38.955)
rect(cv "Via3" 18.775 34.155 18.845 34.225)
rect(cv "Metal3" 18.765 34.065 18.855 34.315)
rect(cv "Metal4" 18.685 34.145 18.935 34.235)
rect(cv "Via4" 18.775 34.155 18.845 34.225)
rect(cv "Metal4" 18.685 34.145 18.935 34.235)
rect(cv "Metal5" 18.765 34.065 18.855 34.315)
rect(cv "Via5" 18.775 34.155 18.845 34.225)
rect(cv "Metal5" 18.765 34.065 18.855 34.315)
rect(cv "Metal6" 18.685 34.145 18.935 34.235)
rect(cv "Via6" 18.775 34.155 18.845 34.225)
rect(cv "Metal6" 18.685 34.145 18.935 34.235)
rect(cv "Metal7" 18.765 34.065 18.855 34.315)
rect(cv "Metal7" 18.77 34.15 18.85 39.03)
rect(cv "Via6" 18.775 38.955 18.845 39.025)
rect(cv "Metal6" 18.685 38.945 18.935 39.035)
rect(cv "Metal7" 18.765 38.865 18.855 39.115)
rect(cv "Via3" 19.095 34.155 19.165 34.225)
rect(cv "Metal3" 19.085 34.065 19.175 34.315)
rect(cv "Metal4" 19.005 34.145 19.255 34.235)
rect(cv "Via4" 19.095 34.155 19.165 34.225)
rect(cv "Metal4" 19.005 34.145 19.255 34.235)
rect(cv "Metal5" 19.085 34.065 19.175 34.315)
rect(cv "Via5" 19.095 34.155 19.165 34.225)
rect(cv "Metal5" 19.085 34.065 19.175 34.315)
rect(cv "Metal6" 19.005 34.145 19.255 34.235)
rect(cv "Via6" 19.095 34.155 19.165 34.225)
rect(cv "Metal6" 19.005 34.145 19.255 34.235)
rect(cv "Metal7" 19.085 34.065 19.175 34.315)
rect(cv "Metal7" 19.09 34.15 19.17 39.19)
rect(cv "Via6" 19.095 39.115 19.165 39.185)
rect(cv "Metal6" 19.005 39.105 19.255 39.195)
rect(cv "Metal7" 19.085 39.025 19.175 39.275)
rect(cv "Via3" 19.415 34.155 19.485 34.225)
rect(cv "Metal3" 19.405 34.065 19.495 34.315)
rect(cv "Metal4" 19.325 34.145 19.575 34.235)
rect(cv "Via4" 19.415 34.155 19.485 34.225)
rect(cv "Metal4" 19.325 34.145 19.575 34.235)
rect(cv "Metal5" 19.405 34.065 19.495 34.315)
rect(cv "Via5" 19.415 34.155 19.485 34.225)
rect(cv "Metal5" 19.405 34.065 19.495 34.315)
rect(cv "Metal6" 19.325 34.145 19.575 34.235)
rect(cv "Via6" 19.415 34.155 19.485 34.225)
rect(cv "Metal6" 19.325 34.145 19.575 34.235)
rect(cv "Metal7" 19.405 34.065 19.495 34.315)
rect(cv "Metal7" 19.41 34.15 19.49 36.47)
rect(cv "Via6" 19.415 36.395 19.485 36.465)
rect(cv "Metal6" 19.325 36.385 19.575 36.475)
rect(cv "Metal7" 19.405 36.305 19.495 36.555)
rect(cv "Via3" 19.735 34.155 19.805 34.225)
rect(cv "Metal3" 19.725 34.065 19.815 34.315)
rect(cv "Metal4" 19.645 34.145 19.895 34.235)
rect(cv "Via4" 19.735 34.155 19.805 34.225)
rect(cv "Metal4" 19.645 34.145 19.895 34.235)
rect(cv "Metal5" 19.725 34.065 19.815 34.315)
rect(cv "Via5" 19.735 34.155 19.805 34.225)
rect(cv "Metal5" 19.725 34.065 19.815 34.315)
rect(cv "Metal6" 19.645 34.145 19.895 34.235)
rect(cv "Via6" 19.735 34.155 19.805 34.225)
rect(cv "Metal6" 19.645 34.145 19.895 34.235)
rect(cv "Metal7" 19.725 34.065 19.815 34.315)
rect(cv "Metal7" 19.73 34.15 19.81 36.63)
rect(cv "Via6" 19.735 36.555 19.805 36.625)
rect(cv "Metal6" 19.645 36.545 19.895 36.635)
rect(cv "Metal7" 19.725 36.465 19.815 36.715)
rect(cv "Via3" 76.055 33.675 76.125 33.745)
rect(cv "Metal3" 76.045 33.585 76.135 33.835)
rect(cv "Metal4" 75.965 33.665 76.215 33.755)
rect(cv "Via4" 76.055 33.675 76.125 33.745)
rect(cv "Metal4" 75.965 33.665 76.215 33.755)
rect(cv "Metal5" 76.045 33.585 76.135 33.835)
rect(cv "Via5" 76.055 33.675 76.125 33.745)
rect(cv "Metal5" 76.045 33.585 76.135 33.835)
rect(cv "Metal6" 75.965 33.665 76.215 33.755)
rect(cv "Via6" 76.055 33.675 76.125 33.745)
rect(cv "Metal6" 75.965 33.665 76.215 33.755)
rect(cv "Metal7" 76.045 33.585 76.135 33.835)
rect(cv "Metal7" 76.05 33.67 76.13 34.71)
rect(cv "Via6" 76.055 34.635 76.125 34.705)
rect(cv "Metal6" 75.965 34.625 76.215 34.715)
rect(cv "Metal7" 76.045 34.545 76.135 34.795)
rect(cv "Via3" 76.375 33.675 76.445 33.745)
rect(cv "Metal3" 76.365 33.585 76.455 33.835)
rect(cv "Metal4" 76.285 33.665 76.535 33.755)
rect(cv "Via4" 76.375 33.675 76.445 33.745)
rect(cv "Metal4" 76.285 33.665 76.535 33.755)
rect(cv "Metal5" 76.365 33.585 76.455 33.835)
rect(cv "Via5" 76.375 33.675 76.445 33.745)
rect(cv "Metal5" 76.365 33.585 76.455 33.835)
rect(cv "Metal6" 76.285 33.665 76.535 33.755)
rect(cv "Via6" 76.375 33.675 76.445 33.745)
rect(cv "Metal6" 76.285 33.665 76.535 33.755)
rect(cv "Metal7" 76.365 33.585 76.455 33.835)
rect(cv "Metal7" 76.37 33.67 76.45 34.87)
rect(cv "Via6" 76.375 34.795 76.445 34.865)
rect(cv "Metal6" 76.285 34.785 76.535 34.875)
rect(cv "Metal7" 76.365 34.705 76.455 34.955)
rect(cv "Via3" 76.695 33.675 76.765 33.745)
rect(cv "Metal3" 76.685 33.585 76.775 33.835)
rect(cv "Metal4" 76.605 33.665 76.855 33.755)
rect(cv "Via4" 76.695 33.675 76.765 33.745)
rect(cv "Metal4" 76.605 33.665 76.855 33.755)
rect(cv "Metal5" 76.685 33.585 76.775 33.835)
rect(cv "Via5" 76.695 33.675 76.765 33.745)
rect(cv "Metal5" 76.685 33.585 76.775 33.835)
rect(cv "Metal6" 76.605 33.665 76.855 33.755)
rect(cv "Via6" 76.695 33.675 76.765 33.745)
rect(cv "Metal6" 76.605 33.665 76.855 33.755)
rect(cv "Metal7" 76.685 33.585 76.775 33.835)
rect(cv "Metal7" 76.69 33.67 76.77 37.43)
rect(cv "Via6" 76.695 37.355 76.765 37.425)
rect(cv "Metal6" 76.605 37.345 76.855 37.435)
rect(cv "Metal7" 76.685 37.265 76.775 37.515)
rect(cv "Via3" 77.015 33.675 77.085 33.745)
rect(cv "Metal3" 77.005 33.585 77.095 33.835)
rect(cv "Metal4" 76.925 33.665 77.175 33.755)
rect(cv "Via4" 77.015 33.675 77.085 33.745)
rect(cv "Metal4" 76.925 33.665 77.175 33.755)
rect(cv "Metal5" 77.005 33.585 77.095 33.835)
rect(cv "Via5" 77.015 33.675 77.085 33.745)
rect(cv "Metal5" 77.005 33.585 77.095 33.835)
rect(cv "Metal6" 76.925 33.665 77.175 33.755)
rect(cv "Via6" 77.015 33.675 77.085 33.745)
rect(cv "Metal6" 76.925 33.665 77.175 33.755)
rect(cv "Metal7" 77.005 33.585 77.095 33.835)
rect(cv "Metal7" 77.01 33.67 77.09 37.75)
rect(cv "Via6" 77.015 37.675 77.085 37.745)
rect(cv "Metal6" 76.925 37.665 77.175 37.755)
rect(cv "Metal7" 77.005 37.585 77.095 37.835)
rect(cv "Via3" 77.335 33.675 77.405 33.745)
rect(cv "Metal3" 77.325 33.585 77.415 33.835)
rect(cv "Metal4" 77.245 33.665 77.495 33.755)
rect(cv "Via4" 77.335 33.675 77.405 33.745)
rect(cv "Metal4" 77.245 33.665 77.495 33.755)
rect(cv "Metal5" 77.325 33.585 77.415 33.835)
rect(cv "Via5" 77.335 33.675 77.405 33.745)
rect(cv "Metal5" 77.325 33.585 77.415 33.835)
rect(cv "Metal6" 77.245 33.665 77.495 33.755)
rect(cv "Via6" 77.335 33.675 77.405 33.745)
rect(cv "Metal6" 77.245 33.665 77.495 33.755)
rect(cv "Metal7" 77.325 33.585 77.415 33.835)
rect(cv "Metal7" 77.33 33.67 77.41 37.91)
rect(cv "Via6" 77.335 37.835 77.405 37.905)
rect(cv "Metal6" 77.245 37.825 77.495 37.915)
rect(cv "Metal7" 77.325 37.745 77.415 37.995)
rect(cv "Via3" 77.655 33.675 77.725 33.745)
rect(cv "Metal3" 77.645 33.585 77.735 33.835)
rect(cv "Metal4" 77.565 33.665 77.815 33.755)
rect(cv "Via4" 77.655 33.675 77.725 33.745)
rect(cv "Metal4" 77.565 33.665 77.815 33.755)
rect(cv "Metal5" 77.645 33.585 77.735 33.835)
rect(cv "Via5" 77.655 33.675 77.725 33.745)
rect(cv "Metal5" 77.645 33.585 77.735 33.835)
rect(cv "Metal6" 77.565 33.665 77.815 33.755)
rect(cv "Via6" 77.655 33.675 77.725 33.745)
rect(cv "Metal6" 77.565 33.665 77.815 33.755)
rect(cv "Metal7" 77.645 33.585 77.735 33.835)
rect(cv "Metal7" 77.65 33.67 77.73 38.07)
rect(cv "Via6" 77.655 37.995 77.725 38.065)
rect(cv "Metal6" 77.565 37.985 77.815 38.075)
rect(cv "Metal7" 77.645 37.905 77.735 38.155)
rect(cv "Via3" 77.975 33.675 78.045 33.745)
rect(cv "Metal3" 77.965 33.585 78.055 33.835)
rect(cv "Metal4" 77.885 33.665 78.135 33.755)
rect(cv "Via4" 77.975 33.675 78.045 33.745)
rect(cv "Metal4" 77.885 33.665 78.135 33.755)
rect(cv "Metal5" 77.965 33.585 78.055 33.835)
rect(cv "Via5" 77.975 33.675 78.045 33.745)
rect(cv "Metal5" 77.965 33.585 78.055 33.835)
rect(cv "Metal6" 77.885 33.665 78.135 33.755)
rect(cv "Via6" 77.975 33.675 78.045 33.745)
rect(cv "Metal6" 77.885 33.665 78.135 33.755)
rect(cv "Metal7" 77.965 33.585 78.055 33.835)
rect(cv "Metal7" 77.97 33.67 78.05 38.23)
rect(cv "Via6" 77.975 38.155 78.045 38.225)
rect(cv "Metal6" 77.885 38.145 78.135 38.235)
rect(cv "Metal7" 77.965 38.065 78.055 38.315)
rect(cv "Via3" 78.295 33.675 78.365 33.745)
rect(cv "Metal3" 78.285 33.585 78.375 33.835)
rect(cv "Metal4" 78.205 33.665 78.455 33.755)
rect(cv "Via4" 78.295 33.675 78.365 33.745)
rect(cv "Metal4" 78.205 33.665 78.455 33.755)
rect(cv "Metal5" 78.285 33.585 78.375 33.835)
rect(cv "Via5" 78.295 33.675 78.365 33.745)
rect(cv "Metal5" 78.285 33.585 78.375 33.835)
rect(cv "Metal6" 78.205 33.665 78.455 33.755)
rect(cv "Via6" 78.295 33.675 78.365 33.745)
rect(cv "Metal6" 78.205 33.665 78.455 33.755)
rect(cv "Metal7" 78.285 33.585 78.375 33.835)
rect(cv "Metal7" 78.29 33.67 78.37 36.47)
rect(cv "Via6" 78.295 36.395 78.365 36.465)
rect(cv "Metal6" 78.205 36.385 78.455 36.475)
rect(cv "Metal7" 78.285 36.305 78.375 36.555)
rect(cv "Via3" 78.615 33.675 78.685 33.745)
rect(cv "Metal3" 78.605 33.585 78.695 33.835)
rect(cv "Metal4" 78.525 33.665 78.775 33.755)
rect(cv "Via4" 78.615 33.675 78.685 33.745)
rect(cv "Metal4" 78.525 33.665 78.775 33.755)
rect(cv "Metal5" 78.605 33.585 78.695 33.835)
rect(cv "Via5" 78.615 33.675 78.685 33.745)
rect(cv "Metal5" 78.605 33.585 78.695 33.835)
rect(cv "Metal6" 78.525 33.665 78.775 33.755)
rect(cv "Via6" 78.615 33.675 78.685 33.745)
rect(cv "Metal6" 78.525 33.665 78.775 33.755)
rect(cv "Metal7" 78.605 33.585 78.695 33.835)
rect(cv "Metal7" 78.61 33.67 78.69 36.63)
rect(cv "Via6" 78.615 36.555 78.685 36.625)
rect(cv "Metal6" 78.525 36.545 78.775 36.635)
rect(cv "Metal7" 78.605 36.465 78.695 36.715)
rect(cv "Via3" 116.695 31.035 116.765 31.105)
rect(cv "Metal3" 116.685 30.945 116.775 31.195)
rect(cv "Metal4" 116.605 31.025 116.855 31.115)
rect(cv "Via4" 116.695 31.035 116.765 31.105)
rect(cv "Metal4" 116.605 31.025 116.855 31.115)
rect(cv "Metal5" 116.685 30.945 116.775 31.195)
rect(cv "Via5" 116.695 31.035 116.765 31.105)
rect(cv "Metal5" 116.685 30.945 116.775 31.195)
rect(cv "Metal6" 116.605 31.025 116.855 31.115)
rect(cv "Via6" 116.695 31.035 116.765 31.105)
rect(cv "Metal6" 116.605 31.025 116.855 31.115)
rect(cv "Metal7" 116.685 30.945 116.775 31.195)
rect(cv "Metal7" 116.69 31.03 116.77 36.15)
rect(cv "Via6" 116.695 36.075 116.765 36.145)
rect(cv "Metal6" 116.605 36.065 116.855 36.155)
rect(cv "Metal7" 116.685 35.985 116.775 36.235)
rect(cv "Via3" 117.015 31.035 117.085 31.105)
rect(cv "Metal3" 117.005 30.945 117.095 31.195)
rect(cv "Metal4" 116.925 31.025 117.175 31.115)
rect(cv "Via4" 117.015 31.035 117.085 31.105)
rect(cv "Metal4" 116.925 31.025 117.175 31.115)
rect(cv "Metal5" 117.005 30.945 117.095 31.195)
rect(cv "Via5" 117.015 31.035 117.085 31.105)
rect(cv "Metal5" 117.005 30.945 117.095 31.195)
rect(cv "Metal6" 116.925 31.025 117.175 31.115)
rect(cv "Via6" 117.015 31.035 117.085 31.105)
rect(cv "Metal6" 116.925 31.025 117.175 31.115)
rect(cv "Metal7" 117.005 30.945 117.095 31.195)
rect(cv "Metal7" 117.01 31.03 117.09 36.79)
rect(cv "Via6" 117.015 36.715 117.085 36.785)
rect(cv "Metal6" 116.925 36.705 117.175 36.795)
rect(cv "Metal7" 117.005 36.625 117.095 36.875)
rect(cv "Via3" 117.335 31.035 117.405 31.105)
rect(cv "Metal3" 117.325 30.945 117.415 31.195)
rect(cv "Metal4" 117.245 31.025 117.495 31.115)
rect(cv "Via4" 117.335 31.035 117.405 31.105)
rect(cv "Metal4" 117.245 31.025 117.495 31.115)
rect(cv "Metal5" 117.325 30.945 117.415 31.195)
rect(cv "Via5" 117.335 31.035 117.405 31.105)
rect(cv "Metal5" 117.325 30.945 117.415 31.195)
rect(cv "Metal6" 117.245 31.025 117.495 31.115)
rect(cv "Via6" 117.335 31.035 117.405 31.105)
rect(cv "Metal6" 117.245 31.025 117.495 31.115)
rect(cv "Metal7" 117.325 30.945 117.415 31.195)
rect(cv "Metal7" 117.33 31.03 117.41 36.95)
rect(cv "Via6" 117.335 36.875 117.405 36.945)
rect(cv "Metal6" 117.245 36.865 117.495 36.955)
rect(cv "Metal7" 117.325 36.785 117.415 37.035)
rect(cv "Via3" 117.655 31.035 117.725 31.105)
rect(cv "Metal3" 117.645 30.945 117.735 31.195)
rect(cv "Metal4" 117.565 31.025 117.815 31.115)
rect(cv "Via4" 117.655 31.035 117.725 31.105)
rect(cv "Metal4" 117.565 31.025 117.815 31.115)
rect(cv "Metal5" 117.645 30.945 117.735 31.195)
rect(cv "Via5" 117.655 31.035 117.725 31.105)
rect(cv "Metal5" 117.645 30.945 117.735 31.195)
rect(cv "Metal6" 117.565 31.025 117.815 31.115)
rect(cv "Via6" 117.655 31.035 117.725 31.105)
rect(cv "Metal6" 117.565 31.025 117.815 31.115)
rect(cv "Metal7" 117.645 30.945 117.735 31.195)
rect(cv "Metal7" 117.65 31.03 117.73 41.27)
rect(cv "Via6" 117.655 41.195 117.725 41.265)
rect(cv "Metal6" 117.565 41.185 117.815 41.275)
rect(cv "Metal7" 117.645 41.105 117.735 41.355)
rect(cv "Via3" 117.975 31.035 118.045 31.105)
rect(cv "Metal3" 117.965 30.945 118.055 31.195)
rect(cv "Metal4" 117.885 31.025 118.135 31.115)
rect(cv "Via4" 117.975 31.035 118.045 31.105)
rect(cv "Metal4" 117.885 31.025 118.135 31.115)
rect(cv "Metal5" 117.965 30.945 118.055 31.195)
rect(cv "Via5" 117.975 31.035 118.045 31.105)
rect(cv "Metal5" 117.965 30.945 118.055 31.195)
rect(cv "Metal6" 117.885 31.025 118.135 31.115)
rect(cv "Via6" 117.975 31.035 118.045 31.105)
rect(cv "Metal6" 117.885 31.025 118.135 31.115)
rect(cv "Metal7" 117.965 30.945 118.055 31.195)
rect(cv "Metal7" 117.97 31.03 118.05 41.43)
rect(cv "Via6" 117.975 41.355 118.045 41.425)
rect(cv "Metal6" 117.885 41.345 118.135 41.435)
rect(cv "Metal7" 117.965 41.265 118.055 41.515)
rect(cv "Via3" 118.295 31.035 118.365 31.105)
rect(cv "Metal3" 118.285 30.945 118.375 31.195)
rect(cv "Metal4" 118.205 31.025 118.455 31.115)
rect(cv "Via4" 118.295 31.035 118.365 31.105)
rect(cv "Metal4" 118.205 31.025 118.455 31.115)
rect(cv "Metal5" 118.285 30.945 118.375 31.195)
rect(cv "Via5" 118.295 31.035 118.365 31.105)
rect(cv "Metal5" 118.285 30.945 118.375 31.195)
rect(cv "Metal6" 118.205 31.025 118.455 31.115)
rect(cv "Via6" 118.295 31.035 118.365 31.105)
rect(cv "Metal6" 118.205 31.025 118.455 31.115)
rect(cv "Metal7" 118.285 30.945 118.375 31.195)
rect(cv "Metal7" 118.29 31.03 118.37 36.47)
rect(cv "Via6" 118.295 36.395 118.365 36.465)
rect(cv "Metal6" 118.205 36.385 118.455 36.475)
rect(cv "Metal7" 118.285 36.305 118.375 36.555)
rect(cv "Via3" 118.615 31.035 118.685 31.105)
rect(cv "Metal3" 118.605 30.945 118.695 31.195)
rect(cv "Metal4" 118.525 31.025 118.775 31.115)
rect(cv "Via4" 118.615 31.035 118.685 31.105)
rect(cv "Metal4" 118.525 31.025 118.775 31.115)
rect(cv "Metal5" 118.605 30.945 118.695 31.195)
rect(cv "Via5" 118.615 31.035 118.685 31.105)
rect(cv "Metal5" 118.605 30.945 118.695 31.195)
rect(cv "Metal6" 118.525 31.025 118.775 31.115)
rect(cv "Via6" 118.615 31.035 118.685 31.105)
rect(cv "Metal6" 118.525 31.025 118.775 31.115)
rect(cv "Metal7" 118.605 30.945 118.695 31.195)
rect(cv "Metal7" 118.61 31.03 118.69 36.63)
rect(cv "Via6" 118.615 36.555 118.685 36.625)
rect(cv "Metal6" 118.525 36.545 118.775 36.635)
rect(cv "Metal7" 118.605 36.465 118.695 36.715)
rect(cv "Metal6" 0.21 34.63 76.13 34.71)
rect(cv "Via5" 0.215 34.635 0.285 34.705)
rect(cv "Metal5" 0.205 34.545 0.295 34.795)
rect(cv "Metal6" 0.125 34.625 0.375 34.715)
rect(cv "Via4" 0.215 34.635 0.285 34.705)
rect(cv "Metal4" 0.125 34.625 0.375 34.715)
rect(cv "Metal5" 0.205 34.545 0.295 34.795)
rect(cv "Via3" 0.215 34.635 0.285 34.705)
rect(cv "Metal3" 0.205 34.545 0.295 34.795)
rect(cv "Metal4" 0.125 34.625 0.375 34.715)
rect(cv "Metal3" 0.18 34.6 0.32 42.04)
port(cv "R1" "Metal3" 0.25 41.97)
rect(cv "Metal6" 0.53 34.79 76.45 34.87)
rect(cv "Via5" 0.535 34.795 0.605 34.865)
rect(cv "Metal5" 0.525 34.705 0.615 34.955)
rect(cv "Metal6" 0.445 34.785 0.695 34.875)
rect(cv "Via4" 0.535 34.795 0.605 34.865)
rect(cv "Metal4" 0.445 34.785 0.695 34.875)
rect(cv "Metal5" 0.525 34.705 0.615 34.955)
rect(cv "Via3" 0.535 34.795 0.605 34.865)
rect(cv "Metal3" 0.525 34.705 0.615 34.955)
rect(cv "Metal4" 0.445 34.785 0.695 34.875)
rect(cv "Metal3" 0.5 34.76 0.64 42.04)
port(cv "R0" "Metal3" 0.57 41.97)
rect(cv "Metal6" 0.85 34.95 16.61 35.03)
rect(cv "Via5" 0.855 34.955 0.925 35.025)
rect(cv "Metal5" 0.845 34.865 0.935 35.115)
rect(cv "Metal6" 0.765 34.945 1.015 35.035)
rect(cv "Via4" 0.855 34.955 0.925 35.025)
rect(cv "Metal4" 0.765 34.945 1.015 35.035)
rect(cv "Metal5" 0.845 34.865 0.935 35.115)
rect(cv "Via3" 0.855 34.955 0.925 35.025)
rect(cv "Metal3" 0.845 34.865 0.935 35.115)
rect(cv "Metal4" 0.765 34.945 1.015 35.035)
rect(cv "Metal3" 0.82 34.92 0.96 42.04)
port(cv "C2" "Metal3" 0.89 41.97)
rect(cv "Metal6" 1.17 35.11 16.93 35.19)
rect(cv "Via5" 1.175 35.115 1.245 35.185)
rect(cv "Metal5" 1.165 35.025 1.255 35.275)
rect(cv "Metal6" 1.085 35.105 1.335 35.195)
rect(cv "Via4" 1.175 35.115 1.245 35.185)
rect(cv "Metal4" 1.085 35.105 1.335 35.195)
rect(cv "Metal5" 1.165 35.025 1.255 35.275)
rect(cv "Via3" 1.175 35.115 1.245 35.185)
rect(cv "Metal3" 1.165 35.025 1.255 35.275)
rect(cv "Metal4" 1.085 35.105 1.335 35.195)
rect(cv "Metal3" 1.14 35.08 1.28 42.04)
port(cv "C1" "Metal3" 1.21 41.97)
rect(cv "Metal6" 1.49 35.27 17.25 35.35)
rect(cv "Via5" 1.495 35.275 1.565 35.345)
rect(cv "Metal5" 1.485 35.185 1.575 35.435)
rect(cv "Metal6" 1.405 35.265 1.655 35.355)
rect(cv "Via4" 1.495 35.275 1.565 35.345)
rect(cv "Metal4" 1.405 35.265 1.655 35.355)
rect(cv "Metal5" 1.485 35.185 1.575 35.435)
rect(cv "Via3" 1.495 35.275 1.565 35.345)
rect(cv "Metal3" 1.485 35.185 1.575 35.435)
rect(cv "Metal4" 1.405 35.265 1.655 35.355)
rect(cv "Metal3" 1.46 35.24 1.6 42.04)
port(cv "C0" "Metal3" 1.53 41.97)
rect(cv "Metal6" 1.81 35.43 12.13 35.51)
rect(cv "Via5" 1.815 35.435 1.885 35.505)
rect(cv "Metal5" 1.805 35.345 1.895 35.595)
rect(cv "Metal6" 1.725 35.425 1.975 35.515)
rect(cv "Via4" 1.815 35.435 1.885 35.505)
rect(cv "Metal4" 1.725 35.425 1.975 35.515)
rect(cv "Metal5" 1.805 35.345 1.895 35.595)
rect(cv "Via3" 1.815 35.435 1.885 35.505)
rect(cv "Metal3" 1.805 35.345 1.895 35.595)
rect(cv "Metal4" 1.725 35.425 1.975 35.515)
rect(cv "Metal3" 1.78 35.4 1.92 42.04)
port(cv "CLK1" "Metal3" 1.85 41.97)
rect(cv "Metal6" 2.13 35.59 12.45 35.67)
rect(cv "Via5" 2.135 35.595 2.205 35.665)
rect(cv "Metal5" 2.125 35.505 2.215 35.755)
rect(cv "Metal6" 2.045 35.585 2.295 35.675)
rect(cv "Via4" 2.135 35.595 2.205 35.665)
rect(cv "Metal4" 2.045 35.585 2.295 35.675)
rect(cv "Metal5" 2.125 35.505 2.215 35.755)
rect(cv "Via3" 2.135 35.595 2.205 35.665)
rect(cv "Metal3" 2.125 35.505 2.215 35.755)
rect(cv "Metal4" 2.045 35.585 2.295 35.675)
rect(cv "Metal3" 2.1 35.56 2.24 42.04)
port(cv "CLK2" "Metal3" 2.17 41.97)
rect(cv "Metal6" 2.45 35.75 12.77 35.83)
rect(cv "Via5" 2.455 35.755 2.525 35.825)
rect(cv "Metal5" 2.445 35.665 2.535 35.915)
rect(cv "Metal6" 2.365 35.745 2.615 35.835)
rect(cv "Via4" 2.455 35.755 2.525 35.825)
rect(cv "Metal4" 2.365 35.745 2.615 35.835)
rect(cv "Metal5" 2.445 35.665 2.535 35.915)
rect(cv "Via3" 2.455 35.755 2.525 35.825)
rect(cv "Metal3" 2.445 35.665 2.535 35.915)
rect(cv "Metal4" 2.365 35.745 2.615 35.835)
rect(cv "Metal3" 2.42 35.72 2.56 42.04)
port(cv "WR" "Metal3" 2.49 41.97)
rect(cv "Metal6" 2.77 35.91 13.09 35.99)
rect(cv "Via5" 2.775 35.915 2.845 35.985)
rect(cv "Metal5" 2.765 35.825 2.855 36.075)
rect(cv "Metal6" 2.685 35.905 2.935 35.995)
rect(cv "Via4" 2.775 35.915 2.845 35.985)
rect(cv "Metal4" 2.685 35.905 2.935 35.995)
rect(cv "Metal5" 2.765 35.825 2.855 36.075)
rect(cv "Via3" 2.775 35.915 2.845 35.985)
rect(cv "Metal3" 2.765 35.825 2.855 36.075)
rect(cv "Metal4" 2.685 35.905 2.935 35.995)
rect(cv "Metal3" 2.74 35.88 2.88 42.04)
port(cv "RD" "Metal3" 2.81 41.97)
rect(cv "Metal6" 3.09 36.07 116.77 36.15)
rect(cv "Via5" 3.095 36.075 3.165 36.145)
rect(cv "Metal5" 3.085 35.985 3.175 36.235)
rect(cv "Metal6" 3.005 36.065 3.255 36.155)
rect(cv "Via4" 3.095 36.075 3.165 36.145)
rect(cv "Metal4" 3.005 36.065 3.255 36.155)
rect(cv "Metal5" 3.085 35.985 3.175 36.235)
rect(cv "Via3" 3.095 36.075 3.165 36.145)
rect(cv "Metal3" 3.085 35.985 3.175 36.235)
rect(cv "Metal4" 3.005 36.065 3.255 36.155)
rect(cv "Metal3" 3.06 36.04 3.2 42.04)
port(cv "DIN" "Metal3" 3.13 41.97)
rect(cv "Metal6" 3.41 36.23 112.93 36.31)
rect(cv "Via5" 3.415 36.235 3.485 36.305)
rect(cv "Metal5" 3.405 36.145 3.495 36.395)
rect(cv "Metal6" 3.325 36.225 3.575 36.315)
rect(cv "Via4" 3.415 36.235 3.485 36.305)
rect(cv "Metal4" 3.325 36.225 3.575 36.315)
rect(cv "Metal5" 3.405 36.145 3.495 36.395)
rect(cv "Via3" 3.415 36.235 3.485 36.305)
rect(cv "Metal3" 3.405 36.145 3.495 36.395)
rect(cv "Metal4" 3.325 36.225 3.575 36.315)
rect(cv "Metal3" 3.38 36.2 3.52 42.04)
port(cv "DOUT" "Metal3" 3.45 41.97)
rect(cv "Metal6" 3.73 36.39 125.41 36.47)
rect(cv "Via5" 3.735 36.395 3.805 36.465)
rect(cv "Metal5" 3.725 36.305 3.815 36.555)
rect(cv "Metal6" 3.645 36.385 3.895 36.475)
rect(cv "Via4" 3.735 36.395 3.805 36.465)
rect(cv "Metal4" 3.645 36.385 3.895 36.475)
rect(cv "Metal5" 3.725 36.305 3.815 36.555)
rect(cv "Via3" 3.735 36.395 3.805 36.465)
rect(cv "Metal3" 3.725 36.305 3.815 36.555)
rect(cv "Metal4" 3.645 36.385 3.895 36.475)
rect(cv "Metal3" 3.7 36.36 3.84 42.04)
port(cv "VDD" "Metal3" 3.77 41.97)
rect(cv "Metal6" 4.05 36.55 125.73 36.63)
rect(cv "Via5" 4.055 36.555 4.125 36.625)
rect(cv "Metal5" 4.045 36.465 4.135 36.715)
rect(cv "Metal6" 3.965 36.545 4.215 36.635)
rect(cv "Via4" 4.055 36.555 4.125 36.625)
rect(cv "Metal4" 3.965 36.545 4.215 36.635)
rect(cv "Metal5" 4.045 36.465 4.135 36.715)
rect(cv "Via3" 4.055 36.555 4.125 36.625)
rect(cv "Metal3" 4.045 36.465 4.135 36.715)
rect(cv "Metal4" 3.965 36.545 4.215 36.635)
rect(cv "Metal3" 4.02 36.52 4.16 42.04)
port(cv "GND" "Metal3" 4.09 41.97)
rect(cv "Metal6" 13.97 36.71 117.09 36.79)
rect(cv "Metal6" 14.29 36.87 117.41 36.95)
rect(cv "Metal6" 14.61 37.03 125.09 37.11)
rect(cv "Metal6" 14.93 37.19 112.61 37.27)
rect(cv "Metal6" 15.25 37.35 76.77 37.43)
rect(cv "Metal6" 15.57 37.51 90.21 37.59)
rect(cv "Metal6" 77.01 37.67 91.17 37.75)
rect(cv "Metal6" 77.33 37.83 91.49 37.91)
rect(cv "Metal6" 77.65 37.99 91.81 38.07)
rect(cv "Metal6" 77.97 38.15 92.13 38.23)
rect(cv "Metal6" 5.01 38.31 17.57 38.39)
rect(cv "Metal6" 5.33 38.47 17.89 38.55)
rect(cv "Metal6" 5.65 38.63 18.21 38.71)
rect(cv "Metal6" 5.97 38.79 18.53 38.87)
rect(cv "Metal6" 6.29 38.95 18.85 39.03)
rect(cv "Metal6" 6.61 39.11 19.17 39.19)
rect(cv "Metal6" 6.93 39.27 92.45 39.35)
rect(cv "Metal6" 7.25 39.43 92.77 39.51)
rect(cv "Metal6" 7.57 39.59 93.09 39.67)
rect(cv "Metal6" 7.89 39.75 93.41 39.83)
rect(cv "Metal6" 8.21 39.91 93.73 39.99)
rect(cv "Metal6" 8.53 40.07 94.05 40.15)
rect(cv "Metal6" 8.85 40.23 94.37 40.31)
rect(cv "Metal6" 9.17 40.39 94.69 40.47)
rect(cv "Metal6" 9.49 40.55 95.01 40.63)
rect(cv "Metal6" 9.81 40.71 95.33 40.79)
rect(cv "Metal6" 10.13 40.87 95.65 40.95)
rect(cv "Metal6" 10.45 41.03 95.97 41.11)
rect(cv "Metal6" 10.77 41.19 124.45 41.27)
rect(cv "Metal6" 11.09 41.35 124.77 41.43)
rect(cv "Metal6" 111.89 41.51 126.05 41.59)
rect(cv "prBoundary" 0.0 0.0 131.84 42.05)
dbSave(cv) printf("LAYOUT sram_4x6 %L\n" cv~>bBox) dbClose(cv)
exit()
